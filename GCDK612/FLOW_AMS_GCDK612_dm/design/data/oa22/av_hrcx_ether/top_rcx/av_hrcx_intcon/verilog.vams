// Verilog-AMS netlist generated by the AMS netlister, version ICOA5.2.51.264.
// Cadence Design Systems, Inc.

`include "disciplines.vams"

module top_rcx ( TXC,ANLG_TST,RXDV,LEDR,TXER,RXC,XTAL25,LEDL,ANDIS,
TPON,SIDDQ,B10_DIS,SCAN_MODE,TXEN,scan_reset,SCAN_ENABLE,MDIO_IN,.
TX_SLP_TRIM({ \TX_SLP_TRIM(1) ,\TX_SLP_TRIM(0)  }),LEDT,B100_DIS,LEDS,
MDINT,VDDRX,LEDC,RBIAS_SENSE,RBIAS,scan_set,RESETN,TPOP,LEDD,.PHY(
{ \PHY(4) ,\PHY(3) ,\PHY(2) ,\PHY(1) ,\PHY(0)  }),TRISTATE,VDD,
SCANCLK3,SYMBOL_MODE,TPIP,COL,DISABLE10,VDDTX,GNDRX,VDDA_250,VDDA_160,
GNDA_250,GNDA_160,MDIO_OE,MDC,TPIN,.TX_AMP_TRIM(
{ \TX_AMP_TRIM(1) ,\TX_AMP_TRIM(0)  }),SCANCLK2,.TXD(
{ \TXD(4) ,\TXD(3) ,\TXD(2) ,\TXD(1) ,\TXD(0)  }),DISABLE100,GNDTX,GND,
MDIO_OUT,.BGTRIM({ \BGTRIM(3) ,\BGTRIM(2) ,\BGTRIM(1) ,\BGTRIM(0)  }),
SCANCLK1,RXER,.RXD({ \RXD(4) ,\RXD(3) ,\RXD(2) ,\RXD(1) ,\RXD(0)  }),
CRS );

output   TXC;
output   ANLG_TST;
output   RXDV;
output   LEDR;

input   TXER;
output   RXC;
input   XTAL25;
output   LEDL;
input
 ANDIS;
output   TPON;
input   SIDDQ;
output   B10_DIS;
input
 SCAN_MODE;
input   TXEN;
input   scan_reset;
input   SCAN_ENABLE;

input   MDIO_IN;
input   \TX_SLP_TRIM(0) ;
input   \TX_SLP_TRIM(1) ;

output   LEDT;
output   B100_DIS;
output   LEDS;
output   MDINT;

input   VDDRX;
output   LEDC;
input   RBIAS_SENSE;
input   RBIAS;

input   scan_set;
input   RESETN;
output   TPOP;
output   LEDD;

input   \PHY(0) ;
input   \PHY(1) ;
input   \PHY(2) ;
input
 \PHY(3) ;
input   \PHY(4) ;
output   TRISTATE;
input   VDD;
input
 SCANCLK3;
output   SYMBOL_MODE;
input   TPIP;
output   COL;
input
 DISABLE10;
input   VDDTX;
input   GNDRX;
input   VDDA_250;
input
 VDDA_160;
input   GNDA_250;
input   GNDA_160;
output   MDIO_OE;

input   MDC;
input   TPIN;
input   \TX_AMP_TRIM(0) ;
input
 \TX_AMP_TRIM(1) ;
input   SCANCLK2;
input   \TXD(0) ;
input
 \TXD(1) ;
input   \TXD(2) ;
input   \TXD(3) ;
input   \TXD(4) ;

input   DISABLE100;
input   GNDTX;
input   GND;
output   MDIO_OUT;

input   \BGTRIM(0) ;
input   \BGTRIM(1) ;
input   \BGTRIM(2) ;
input
 \BGTRIM(3) ;
input   SCANCLK1;
output   RXER;
output   \RXD(0) ;

output   \RXD(1) ;
output   \RXD(2) ;
output   \RXD(3) ;
output
 \RXD(4) ;
output   CRS;

cmodel #(.c(1.124e-12)) (*
integer library_binding = "analogLib";
 *)

c1 ( VDD, GND );
cmodel #(.c(2.373e-17)) (*
integer library_binding = "analogLib";
 *)

c2 ( ANDIS, GND );
cmodel #(.c(2.373e-17)) (*
integer library_binding = "analogLib";
 *)

c3 ( ANLG_TST, GND );
cmodel #(.c(2.758e-17)) (*
integer library_binding = "analogLib";
 *)

c4 ( B100_DIS, GND );
cmodel #(.c(2.331e-17)) (*
integer library_binding = "analogLib";
 *)

c5 ( B10_DIS, GND );
cmodel #(.c(9.81e-16)) (*
integer library_binding = "analogLib";
 *)

c6 ( \BGTRIM(0) , GND );
cmodel #(.c(1.193e-15)) (*
integer library_binding = "analogLib";
 *)

c7 ( \BGTRIM(1) , GND );
cmodel #(.c(1.193e-15)) (*
integer library_binding = "analogLib";
 *)

c8 ( \BGTRIM(2) , GND );
cmodel #(.c(9.81e-16)) (*
integer library_binding = "analogLib";
 *)

c9 ( \BGTRIM(3) , GND );
cmodel #(.c(2.373e-17)) (*
integer library_binding = "analogLib";
 *)

c10 ( COL, GND );
cmodel #(.c(2.373e-17)) (*
integer library_binding = "analogLib";
 *)

c11 ( CRS, GND );
cmodel #(.c(8.779e-16)) (*
integer library_binding = "analogLib";
 *)

c12 ( DISABLE10, GND );
cmodel #(.c(6.884e-16)) (*
integer library_binding = "analogLib";
 *)

c13 ( DISABLE100, GND );
cmodel #(.c(4.557e-15)) (*
integer library_binding = "analogLib";
 *)

c14 ( GNDA_160, GND );
cmodel #(.c(4.858e-15)) (*
integer library_binding = "analogLib";
 *)

c15 ( GNDA_250, GND );
cmodel #(.c(2.812e-14)) (*
integer library_binding = "analogLib";
 *)

c16 ( GNDRX, GND );
cmodel #(.c(2.612e-14)) (*
integer library_binding = "analogLib";
 *)

c17 ( GNDTX, GND );
cmodel #(.c(2.373e-17)) (*
integer library_binding = "analogLib";
 *)

c18 ( LEDC, GND );
cmodel #(.c(2.373e-17)) (*
integer library_binding = "analogLib";
 *)

c19 ( LEDD, GND );
cmodel #(.c(2.373e-17)) (*
integer library_binding = "analogLib";
 *)

c20 ( LEDL, GND );
cmodel #(.c(2.373e-17)) (*
integer library_binding = "analogLib";
 *)

c21 ( LEDR, GND );
cmodel #(.c(2.373e-17)) (*
integer library_binding = "analogLib";
 *)

c22 ( LEDS, GND );
cmodel #(.c(2.373e-17)) (*
integer library_binding = "analogLib";
 *)

c23 ( LEDT, GND );
cmodel #(.c(2.373e-17)) (*
integer library_binding = "analogLib";
 *)

c24 ( MDC, GND );
cmodel #(.c(2.373e-17)) (*
integer library_binding = "analogLib";
 *)

c25 ( MDINT, GND );
cmodel #(.c(2.373e-17)) (*
integer library_binding = "analogLib";
 *)

c26 ( MDIO_IN, GND );
cmodel #(.c(2.373e-17)) (*
integer library_binding = "analogLib";
 *)

c27 ( MDIO_OE, GND );
cmodel #(.c(2.373e-17)) (*
integer library_binding = "analogLib";
 *)

c28 ( MDIO_OUT, GND );
cmodel #(.c(2.373e-17)) (*
integer library_binding = "analogLib";
 *)

c29 ( \PHY(0) , GND );
cmodel #(.c(2.373e-17)) (*
integer library_binding = "analogLib";
 *)

c30 ( \PHY(1) , GND );
cmodel #(.c(2.373e-17)) (*
integer library_binding = "analogLib";
 *)

c31 ( \PHY(2) , GND );
cmodel #(.c(2.373e-17)) (*
integer library_binding = "analogLib";
 *)

c32 ( \PHY(3) , GND );
cmodel #(.c(2.373e-17)) (*
integer library_binding = "analogLib";
 *)

c33 ( \PHY(4) , GND );
cmodel #(.c(2.418e-15)) (*
integer library_binding = "analogLib";
 *)

c34 ( RBIAS, GND );
cmodel #(.c(2.418e-15)) (*
integer library_binding = "analogLib";
 *)

c35 ( RBIAS_SENSE, GND );
cmodel #(.c(2.563e-17)) (*
integer library_binding = "analogLib";
 *)

c36 ( RESETN, GND );
cmodel #(.c(2.373e-17)) (*
integer library_binding = "analogLib";
 *)

c37 ( RXC, GND );
cmodel #(.c(2.373e-17)) (*
integer library_binding = "analogLib";
 *)

c38 ( \RXD(0) , GND );
cmodel #(.c(2.373e-17)) (*
integer library_binding = "analogLib";
 *)

c39 ( \RXD(1) , GND );
cmodel #(.c(2.373e-17)) (*
integer library_binding = "analogLib";
 *)

c40 ( \RXD(2) , GND );
cmodel #(.c(2.373e-17)) (*
integer library_binding = "analogLib";
 *)

c41 ( \RXD(3) , GND );
cmodel #(.c(2.373e-17)) (*
integer library_binding = "analogLib";
 *)

c42 ( \RXD(4) , GND );
cmodel #(.c(2.373e-17)) (*
integer library_binding = "analogLib";
 *)

c43 ( RXDV, GND );
cmodel #(.c(2.373e-17)) (*
integer library_binding = "analogLib";
 *)

c44 ( RXER, GND );
cmodel #(.c(2.373e-17)) (*
integer library_binding = "analogLib";
 *)

c45 ( SCANCLK1, GND );
cmodel #(.c(2.373e-17)) (*
integer library_binding = "analogLib";
 *)

c46 ( SCANCLK2, GND );
cmodel #(.c(2.373e-17)) (*
integer library_binding = "analogLib";
 *)

c47 ( SCANCLK3, GND );
cmodel #(.c(2.373e-17)) (*
integer library_binding = "analogLib";
 *)

c48 ( SCAN_ENABLE, GND );
cmodel #(.c(2.373e-17)) (*
integer library_binding = "analogLib";
 *)

c49 ( SCAN_MODE, GND );
cmodel #(.c(8.779e-16)) (*
integer library_binding = "analogLib";
 *)

c50 ( SIDDQ, GND );
cmodel #(.c(2.373e-17)) (*
integer library_binding = "analogLib";
 *)

c51 ( SYMBOL_MODE, GND );
cmodel #(.c(6.156e-15)) (*
integer library_binding = "analogLib";
 *)

c52 ( TPIN, GND );
cmodel #(.c(4.72e-15)) (*
integer library_binding = "analogLib";
 *)

c53 ( TPIP, GND );
cmodel #(.c(4.593e-15)) (*
integer library_binding = "analogLib";
 *)

c54 ( TPON, GND );
cmodel #(.c(2.373e-17)) (*
integer library_binding = "analogLib";
 *)

c55 ( TRISTATE, GND );
cmodel #(.c(2.373e-17)) (*
integer library_binding = "analogLib";
 *)

c56 ( TXC, GND );
cmodel #(.c(2.373e-17)) (*
integer library_binding = "analogLib";
 *)

c57 ( \TXD(0) , GND );
cmodel #(.c(2.373e-17)) (*
integer library_binding = "analogLib";
 *)

c58 ( \TXD(1) , GND );
cmodel #(.c(2.373e-17)) (*
integer library_binding = "analogLib";
 *)

c59 ( \TXD(2) , GND );
cmodel #(.c(2.373e-17)) (*
integer library_binding = "analogLib";
 *)

c60 ( \TXD(3) , GND );
cmodel #(.c(2.373e-17)) (*
integer library_binding = "analogLib";
 *)

c61 ( \TXD(4) , GND );
cmodel #(.c(2.373e-17)) (*
integer library_binding = "analogLib";
 *)

c62 ( TXEN, GND );
cmodel #(.c(2.758e-17)) (*
integer library_binding = "analogLib";
 *)

c63 ( TXER, GND );
cmodel #(.c(2.373e-17)) (*
integer library_binding = "analogLib";
 *)

c64 ( \TX_AMP_TRIM(0) , GND );
cmodel #(.c(2.373e-17)) (*
integer library_binding = "analogLib";
 *)

c65 ( \TX_AMP_TRIM(1) , GND );
cmodel #(.c(2.373e-17)) (*
integer library_binding = "analogLib";
 *)

c66 ( \TX_SLP_TRIM(0) , GND );
cmodel #(.c(2.373e-17)) (*
integer library_binding = "analogLib";
 *)

c67 ( \TX_SLP_TRIM(1) , GND );
cmodel #(.c(5.062e-15)) (*
integer library_binding = "analogLib";
 *)

c68 ( VDDA_160, GND );
cmodel #(.c(4.557e-15)) (*
integer library_binding = "analogLib";
 *)

c69 ( VDDA_250, GND );
cmodel #(.c(1.874e-14)) (*
integer library_binding = "analogLib";
 *)

c70 ( VDDRX, GND );
cmodel #(.c(8.627e-15)) (*
integer library_binding = "analogLib";
 *)

c71 ( VDDTX, GND );
cmodel #(.c(6.846e-16)) (*
integer library_binding = "analogLib";
 *)

c72 ( XTAL25, GND );
cmodel #(.c(2.373e-17)) (*
integer library_binding = "analogLib";
 *)

c73 ( scan_reset, GND );
cmodel #(.c(2.373e-17)) (*
integer library_binding = "analogLib";
 *)

c74 ( scan_set, GND );
cmodel #(.c(9.923e-16)) (*
integer library_binding = "analogLib";
 *)

c75 ( \1:BGTRIM(0) , GND );
cmodel #(.c(1.207e-15)) (*
integer library_binding = "analogLib";
 *)

c76 ( \1:BGTRIM(1) , GND );
cmodel #(.c(1.207e-15)) (*
integer library_binding = "analogLib";
 *)

c77 ( \1:BGTRIM(2) , GND );
cmodel #(.c(9.923e-16)) (*
integer library_binding = "analogLib";
 *)

c78 ( \1:BGTRIM(3) , GND );
cmodel #(.c(1.221e-14)) (*
integer library_binding = "analogLib";
 *)

c79 ( \3:XTAL25 , GND );
cmodel #(.c(8.88e-16)) (*
integer library_binding = "analogLib";
 *)

c80 ( \1:DISABLE10 , GND );
cmodel #(.c(7.168e-16)) (*
integer library_binding = "analogLib";
 *)

c81 ( \1:DISABLE100 , GND );
cmodel #(.c(2.788e-15)) (*
integer library_binding = "analogLib";
 *)

c82 ( \1:GNDA_160 , GND );
cmodel #(.c(3.689e-15)) (*
integer library_binding = "analogLib";
 *)

c83 ( \1:GNDA_250 , GND );
cmodel #(.c(3.055e-14)) (*
integer library_binding = "analogLib";
 *)

c84 ( I_REXT_REF100, GND );
cmodel #(.c(3.986e-17)) (*
integer library_binding = "analogLib";
 *)

c85 ( I_REXT_400_TX, GND );
cmodel #(.c(3.986e-17)) (*
integer library_binding = "analogLib";
 *)

c86 ( I_RPOLY_REF100, GND );
cmodel #(.c(4.248e-17)) (*
integer library_binding = "analogLib";
 *)

c87 ( \PHASE_IN(0) , GND );
cmodel #(.c(4.77e-17)) (*
integer library_binding = "analogLib";
 *)

c88 ( \PHASE_IN(10) , GND );
cmodel #(.c(2.544e-15)) (*
integer library_binding = "analogLib";
 *)

c89 ( \PHASE_IN(1) , GND );
cmodel #(.c(5.772e-17)) (*
integer library_binding = "analogLib";
 *)

c90 ( \PHASE_IN(2) , GND );
cmodel #(.c(2.731e-15)) (*
integer library_binding = "analogLib";
 *)

c91 ( \PHASE_IN(3) , GND );
cmodel #(.c(2.782e-15)) (*
integer library_binding = "analogLib";
 *)

c92 ( \PHASE_IN(4) , GND );
cmodel #(.c(5.423e-17)) (*
integer library_binding = "analogLib";
 *)

c93 ( \PHASE_IN(5) , GND );
cmodel #(.c(5.091e-17)) (*
integer library_binding = "analogLib";
 *)

c94 ( \PHASE_IN(6) , GND );
cmodel #(.c(5.091e-17)) (*
integer library_binding = "analogLib";
 *)

c95 ( \PHASE_IN(7) , GND );
cmodel #(.c(5.074e-17)) (*
integer library_binding = "analogLib";
 *)

c96 ( \PHASE_IN(8) , GND );
cmodel #(.c(5.069e-17)) (*
integer library_binding = "analogLib";
 *)

c97 ( \PHASE_IN(9) , GND );
cmodel #(.c(2.429e-14)) (*
integer library_binding = "analogLib";
 *)

c98 ( PLL_160_IN, GND );
cmodel #(.c(1.826e-15)) (*
integer library_binding = "analogLib";
 *)

c99 ( \1:RBIAS , GND );
cmodel #(.c(1.826e-15)) (*
integer library_binding = "analogLib";
 *)

c100 ( \1:RBIAS_SENSE , GND );
cmodel #(.c(1.241e-15)) (*
integer library_binding = "analogLib";
 *)

c101 ( \8:SIDDQ , GND );
cmodel #(.c(4.301e-15)) (*
integer library_binding = "analogLib";
 *)

c102 ( \1:VDDA_160 , GND );
cmodel #(.c(3.93e-15)) (*
integer library_binding = "analogLib";
 *)

c103 ( \1:VDDA_250 , GND );
cmodel #(.c(1.06e-15)) (*
integer library_binding = "analogLib";
 *)

c104 ( BASE10_TX_DIS_1p0, GND );
cmodel #(.c(3.022e-14)) (*
integer library_binding = "analogLib";
 *)

c105 ( \8:GNDTX , GND );
cmodel #(.c(1.478e-16)) (*
integer library_binding = "analogLib";
 *)

c106 ( I_REXT_100_NC, GND );
cmodel #(.c(8.294e-17)) (*
integer library_binding = "analogLib";
 *)

c107 ( \7:I_REXT_400_TX , GND );
cmodel #(.c(6.807e-17)) (*
integer library_binding = "analogLib";
 *)

c108 ( \I_REXT_50(0) , GND );
cmodel #(.c(6.641e-16)) (*
integer library_binding = "analogLib";
 *)

c109 ( \I_REXT_50(1) , GND );
cmodel #(.c(1.979e-15)) (*
integer library_binding = "analogLib";
 *)

c110 ( \MLT3_TDATA_2p5(0) , GND );
cmodel #(.c(1.801e-15)) (*
integer library_binding = "analogLib";
 *)

c111 ( \MLT3_TDATA_2p5(1) , GND );
cmodel #(.c(3.428e-15)) (*
integer library_binding = "analogLib";
 *)

c112 ( RESET_10BT, GND );
cmodel #(.c(1.007e-15)) (*
integer library_binding = "analogLib";
 *)

c113 ( \9:SIDDQ , GND );
cmodel #(.c(2.325e-15)) (*
integer library_binding = "analogLib";
 *)

c114 ( TENBT_CLK160_1p0, GND );
cmodel #(.c(4.358e-15)) (*
integer library_binding = "analogLib";
 *)

c115 ( \TENBT_FILTER_1p0(0) , GND );
cmodel #(.c(4.645e-15)) (*
integer library_binding = "analogLib";
 *)

c116 ( \TENBT_FILTER_1p0(1) , GND );
cmodel #(.c(1.626e-15)) (*
integer library_binding = "analogLib";
 *)

c117 ( \TENBT_FILTER_1p0(2) , GND );
cmodel #(.c(1.673e-15)) (*
integer library_binding = "analogLib";
 *)

c118 ( \TENBT_FILTER_1p0(3) , GND );
cmodel #(.c(4.088e-15)) (*
integer library_binding = "analogLib";
 *)

c119 ( \TENBT_FILTER_1p0(4) , GND );
cmodel #(.c(3.42e-15)) (*
integer library_binding = "analogLib";
 *)

c120 ( \1:TPON , GND );
cmodel #(.c(9.02e-16)) (*
integer library_binding = "analogLib";
 *)

c121 ( TP_DISC_2p5, GND );
cmodel #(.c(6.809e-17)) (*
integer library_binding = "analogLib";
 *)

c122 ( TX100_DIS_2p5, GND );
cmodel #(.c(7.545e-15)) (*
integer library_binding = "analogLib";
 *)

c123 ( \27:VDDTX , GND );
cmodel #(.c(4.891e-17)) (*
integer library_binding = "analogLib";
 *)

c124 ( X10_DIS_2p5, GND );
cmodel #(.c(1.066e-16)) (*
integer library_binding = "analogLib";
 *)

c125 ( \ADC_1p0(0) , GND );
cmodel #(.c(1.059e-16)) (*
integer library_binding = "analogLib";
 *)

c126 ( \ADC_1p0(1) , GND );
cmodel #(.c(1.238e-15)) (*
integer library_binding = "analogLib";
 *)

c127 ( \ADC_1p0(2) , GND );
cmodel #(.c(1.513e-16)) (*
integer library_binding = "analogLib";
 *)

c128 ( \9:ADC_1p0(3) , GND );
cmodel #(.c(1.197e-15)) (*
integer library_binding = "analogLib";
 *)

c129 ( \ADC_1p0(4) , GND );
cmodel #(.c(4.826e-17)) (*
integer library_binding = "analogLib";
 *)

c130 ( \ADC_1p0(5) , GND );
cmodel #(.c(1.792e-16)) (*
integer library_binding = "analogLib";
 *)

c131 ( ADC_DIS_2p5, GND );
cmodel #(.c(1.15e-16)) (*
integer library_binding = "analogLib";
 *)

c132 ( ADC_TEST_2p5, GND );
cmodel #(.c(1.97e-16)) (*
integer library_binding = "analogLib";
 *)

c133 ( \AEQ_CNT_ANLG(0) , GND );
cmodel #(.c(2.039e-14)) (*
integer library_binding = "analogLib";
 *)

c134 ( \AEQ_CNT_ANLG(1) , GND );
cmodel #(.c(1.797e-14)) (*
integer library_binding = "analogLib";
 *)

c135 ( \AEQ_CNT_ANLG(2) , GND );
cmodel #(.c(1.209e-16)) (*
integer library_binding = "analogLib";
 *)

c136 ( \AEQ_CNT_ANLG(3) , GND );
cmodel #(.c(8.986e-17)) (*
integer library_binding = "analogLib";
 *)

c137 ( \AEQ_CNT_ANLG(4) , GND );
cmodel #(.c(1.624e-16)) (*
integer library_binding = "analogLib";
 *)

c138 ( AEQ_DIS_2p5, GND );
cmodel #(.c(8.175e-17)) (*
integer library_binding = "analogLib";
 *)

c139 ( \8:TX100_DIS_2p5 , GND );
cmodel #(.c(3.055e-16)) (*
integer library_binding = "analogLib";
 *)

c140 ( BASEFX_DIS, GND );
cmodel #(.c(2.632e-16)) (*
integer library_binding = "analogLib";
 *)

c141 ( BLW_DIS_2p5, GND );
cmodel #(.c(3.625e-16)) (*
integer library_binding = "analogLib";
 *)

c142 ( \FLASH_1p0(0) , GND );
cmodel #(.c(3.577e-16)) (*
integer library_binding = "analogLib";
 *)

c143 ( \FLASH_1p0(1) , GND );
cmodel #(.c(1.512e-16)) (*
integer library_binding = "analogLib";
 *)

c144 ( \FLASH_1p0(2) , GND );
cmodel #(.c(2.401e-14)) (*
integer library_binding = "analogLib";
 *)

c145 ( \17:GNDRX , GND );
cmodel #(.c(1.772e-15)) (*
integer library_binding = "analogLib";
 *)

c146 ( \I_REXT_100(0) , GND );
cmodel #(.c(1.652e-15)) (*
integer library_binding = "analogLib";
 *)

c147 ( \I_REXT_100(1) , GND );
cmodel #(.c(1.592e-15)) (*
integer library_binding = "analogLib";
 *)

c148 ( \I_REXT_100(2) , GND );
cmodel #(.c(1.451e-15)) (*
integer library_binding = "analogLib";
 *)

c149 ( \I_REXT_100(3) , GND );
cmodel #(.c(7.727e-17)) (*
integer library_binding = "analogLib";
 *)

c150 ( \I_REXT_100(4) , GND );
cmodel #(.c(1.009e-16)) (*
integer library_binding = "analogLib";
 *)

c151 ( \I_REXT_100(5) , GND );
cmodel #(.c(1.406e-16)) (*
integer library_binding = "analogLib";
 *)

c152 ( \I_REXT_100(6) , GND );
cmodel #(.c(1.869e-16)) (*
integer library_binding = "analogLib";
 *)

c153 ( \I_RPOLY_100(0) , GND );
cmodel #(.c(1.493e-15)) (*
integer library_binding = "analogLib";
 *)

c154 ( \I_RPOLY_100(1) , GND );
cmodel #(.c(1.653e-15)) (*
integer library_binding = "analogLib";
 *)

c155 ( \I_RPOLY_100(2) , GND );
cmodel #(.c(1.219e-15)) (*
integer library_binding = "analogLib";
 *)

c156 ( \I_RPOLY_100(3) , GND );
cmodel #(.c(1.707e-15)) (*
integer library_binding = "analogLib";
 *)

c157 ( \I_RPOLY_100(4) , GND );
cmodel #(.c(1.396e-15)) (*
integer library_binding = "analogLib";
 *)

c158 ( \I_RPOLY_100(5) , GND );
cmodel #(.c(2.749e-16)) (*
integer library_binding = "analogLib";
 *)

c159 ( MR_BYPASS10RX_FILTER, GND );
cmodel #(.c(1.393e-14)) (*
integer library_binding = "analogLib";
 *)

c160 ( AEQ_BYPASS, GND );
cmodel #(.c(8.097e-17)) (*
integer library_binding = "analogLib";
 *)

c161 ( MR_SQUELCH_DISB_2p5, GND );
cmodel #(.c(1.378e-14)) (*
integer library_binding = "analogLib";
 *)

c162 ( \MR_SQUELCH_RANGE_2p5(0) , GND );
cmodel #(.c(1.319e-16)) (*
integer library_binding = "analogLib";
 *)

c163 ( \MR_SQUELCH_RANGE_2p5(1) , GND );
cmodel #(.c(1.887e-15)) (*
integer library_binding = "analogLib";
 *)

c164 ( \PHASE_250(0) , GND );
cmodel #(.c(1.787e-15)) (*
integer library_binding = "analogLib";
 *)

c165 ( \PHASE_250(10) , GND );
cmodel #(.c(1.771e-15)) (*
integer library_binding = "analogLib";
 *)

c166 ( \PHASE_250(1) , GND );
cmodel #(.c(1.826e-15)) (*
integer library_binding = "analogLib";
 *)

c167 ( \PHASE_250(2) , GND );
cmodel #(.c(1.956e-15)) (*
integer library_binding = "analogLib";
 *)

c168 ( \PHASE_250(3) , GND );
cmodel #(.c(1.95e-15)) (*
integer library_binding = "analogLib";
 *)

c169 ( \PHASE_250(4) , GND );
cmodel #(.c(1.108e-16)) (*
integer library_binding = "analogLib";
 *)

c170 ( \PHASE_250(5) , GND );
cmodel #(.c(1.828e-15)) (*
integer library_binding = "analogLib";
 *)

c171 ( \PHASE_250(6) , GND );
cmodel #(.c(3.59e-16)) (*
integer library_binding = "analogLib";
 *)

c172 ( \PHASE_250(7) , GND );
cmodel #(.c(2.032e-15)) (*
integer library_binding = "analogLib";
 *)

c173 ( \PHASE_250(8) , GND );
cmodel #(.c(1.942e-15)) (*
integer library_binding = "analogLib";
 *)

c174 ( \PHASE_250(9) , GND );
cmodel #(.c(1.278e-15)) (*
integer library_binding = "analogLib";
 *)

c175 ( RCLK125_TST, GND );
cmodel #(.c(1.33e-15)) (*
integer library_binding = "analogLib";
 *)

c176 ( RCLK125_TST_SEL, GND );
cmodel #(.c(3.803e-16)) (*
integer library_binding = "analogLib";
 *)

c177 ( RCLK125_1p0, GND );
cmodel #(.c(4.977e-15)) (*
integer library_binding = "analogLib";
 *)

c178 ( RESET_DSP, GND );
cmodel #(.c(1.012e-15)) (*
integer library_binding = "analogLib";
 *)

c179 ( POS_DETECT_2p5, GND );
cmodel #(.c(9.051e-16)) (*
integer library_binding = "analogLib";
 *)

c180 ( NEG_DETECT_2p5, GND );
cmodel #(.c(3.664e-17)) (*
integer library_binding = "analogLib";
 *)

c181 ( RX10_PRESENT_2p5, GND );
cmodel #(.c(1.039e-15)) (*
integer library_binding = "analogLib";
 *)

c182 ( SLICER_OUT_2p5, GND );
cmodel #(.c(1.873e-16)) (*
integer library_binding = "analogLib";
 *)

c183 ( T2_MODE, GND );
cmodel #(.c(2.976e-15)) (*
integer library_binding = "analogLib";
 *)

c184 ( TIMING_DN_ANLG, GND );
cmodel #(.c(3.279e-15)) (*
integer library_binding = "analogLib";
 *)

c185 ( TIMING_UP_ANLG, GND );
cmodel #(.c(5.945e-15)) (*
integer library_binding = "analogLib";
 *)

c186 ( \1:TPIN , GND );
cmodel #(.c(5.142e-15)) (*
integer library_binding = "analogLib";
 *)

c187 ( \1:TPIP , GND );
cmodel #(.c(2.001e-14)) (*
integer library_binding = "analogLib";
 *)

c188 ( \7:VDDRX , GND );
cmodel #(.c(1.193e-14)) (*
integer library_binding = "analogLib";
 *)

c189 ( \WANDER_CNT(0) , GND );
cmodel #(.c(8.206e-17)) (*
integer library_binding = "analogLib";
 *)

c190 ( \WANDER_CNT(1) , GND );
cmodel #(.c(2.351e-14)) (*
integer library_binding = "analogLib";
 *)

c191 ( \WANDER_CNT(2) , GND );
cmodel #(.c(3.625e-16)) (*
integer library_binding = "analogLib";
 *)

c192 ( \WANDER_CNT(3) , GND );
cmodel #(.c(2.571e-16)) (*
integer library_binding = "analogLib";
 *)

c193 ( \WANDER_CNT(4) , GND );
cmodel #(.c(2.479e-16)) (*
integer library_binding = "analogLib";
 *)

c194 ( \WANDER_CNT(5) , GND );
cmodel #(.c(3.157e-16)) (*
integer library_binding = "analogLib";
 *)

c195 ( \WANDER_CNT(6) , GND );
cmodel #(.c(2.364e-16)) (*
integer library_binding = "analogLib";
 *)

c196 ( \8:X10_DIS_2p5 , GND );
cmodel #(.c(3.959e-16)) (*
integer library_binding = "analogLib";
 *)

c197 ( \7:ADC_1p0(0) , GND );
cmodel #(.c(7.137e-17)) (*
integer library_binding = "analogLib";
 *)

c198 ( \7:ADC_1p0(1) , GND );
cmodel #(.c(5.187e-17)) (*
integer library_binding = "analogLib";
 *)

c199 ( \7:ADC_1p0(2) , GND );
cmodel #(.c(4.331e-16)) (*
integer library_binding = "analogLib";
 *)

c200 ( \10:ADC_1p0(3) , GND );
cmodel #(.c(6.239e-17)) (*
integer library_binding = "analogLib";
 *)

c201 ( \9:ADC_1p0(4) , GND );
cmodel #(.c(3.034e-16)) (*
integer library_binding = "analogLib";
 *)

c202 ( \9:ADC_1p0(5) , GND );
cmodel #(.c(4.242e-16)) (*
integer library_binding = "analogLib";
 *)

c203 ( \4:AEQ_BYPASS , GND );
cmodel #(.c(8.262e-17)) (*
integer library_binding = "analogLib";
 *)

c204 ( \6:AEQ_CNT_ANLG(0) , GND );
cmodel #(.c(8.996e-17)) (*
integer library_binding = "analogLib";
 *)

c205 ( \4:AEQ_CNT_ANLG(1) , GND );
cmodel #(.c(6.154e-17)) (*
integer library_binding = "analogLib";
 *)

c206 ( \4:AEQ_CNT_ANLG(2) , GND );
cmodel #(.c(2.038e-16)) (*
integer library_binding = "analogLib";
 *)

c207 ( \6:AEQ_CNT_ANLG(3) , GND );
cmodel #(.c(1.867e-16)) (*
integer library_binding = "analogLib";
 *)

c208 ( \6:AEQ_CNT_ANLG(4) , GND );
cmodel #(.c(3.806e-16)) (*
integer library_binding = "analogLib";
 *)

c209 ( \2:ANDIS , GND );
cmodel #(.c(3.806e-16)) (*
integer library_binding = "analogLib";
 *)

c210 ( \2:ANLG_TST , GND );
cmodel #(.c(3.322e-16)) (*
integer library_binding = "analogLib";
 *)

c211 ( \3:B100_DIS , GND );
cmodel #(.c(3.736e-16)) (*
integer library_binding = "analogLib";
 *)

c212 ( \3:B10_DIS , GND );
cmodel #(.c(3.124e-17)) (*
integer library_binding = "analogLib";
 *)

c213 ( \5:BASE10_TX_DIS_1p0 , GND );
cmodel #(.c(1.604e-15)) (*
integer library_binding = "analogLib";
 *)

c214 ( \7:BASEFX_DIS , GND );
cmodel #(.c(9.742e-17)) (*
integer library_binding = "analogLib";
 *)

c215 ( clkpll_sc, GND );
cmodel #(.c(9.739e-17)) (*
integer library_binding = "analogLib";
 *)

c216 ( \2:clkpll_sc , GND );
cmodel #(.c(3.806e-16)) (*
integer library_binding = "analogLib";
 *)

c217 ( \2:COL , GND );
cmodel #(.c(3.806e-16)) (*
integer library_binding = "analogLib";
 *)

c218 ( \2:CRS , GND );
cmodel #(.c(3.256e-16)) (*
integer library_binding = "analogLib";
 *)

c219 ( \7:FLASH_1p0(0) , GND );
cmodel #(.c(2.513e-16)) (*
integer library_binding = "analogLib";
 *)

c220 ( \9:FLASH_1p0(1) , GND );
cmodel #(.c(3.385e-16)) (*
integer library_binding = "analogLib";
 *)

c221 ( \7:FLASH_1p0(2) , GND );
cmodel #(.c(3.806e-16)) (*
integer library_binding = "analogLib";
 *)

c222 ( \2:LEDC , GND );
cmodel #(.c(3.806e-16)) (*
integer library_binding = "analogLib";
 *)

c223 ( \2:LEDD , GND );
cmodel #(.c(3.806e-16)) (*
integer library_binding = "analogLib";
 *)

c224 ( \2:LEDL , GND );
cmodel #(.c(3.806e-16)) (*
integer library_binding = "analogLib";
 *)

c225 ( \2:LEDR , GND );
cmodel #(.c(3.806e-16)) (*
integer library_binding = "analogLib";
 *)

c226 ( \2:LEDS , GND );
cmodel #(.c(3.806e-16)) (*
integer library_binding = "analogLib";
 *)

c227 ( \2:LEDT , GND );
cmodel #(.c(3.806e-16)) (*
integer library_binding = "analogLib";
 *)

c228 ( \2:MDC , GND );
cmodel #(.c(3.806e-16)) (*
integer library_binding = "analogLib";
 *)

c229 ( \2:MDINT , GND );
cmodel #(.c(3.806e-16)) (*
integer library_binding = "analogLib";
 *)

c230 ( \2:MDIO_IN , GND );
cmodel #(.c(3.806e-16)) (*
integer library_binding = "analogLib";
 *)

c231 ( \2:MDIO_OE , GND );
cmodel #(.c(3.806e-16)) (*
integer library_binding = "analogLib";
 *)

c232 ( \2:MDIO_OUT , GND );
cmodel #(.c(4.906e-16)) (*
integer library_binding = "analogLib";
 *)

c233 ( \MLT3_TDATA_1p0(0) , GND );
cmodel #(.c(4.906e-16)) (*
integer library_binding = "analogLib";
 *)

c234 ( \MLT3_TDATA_1p0(1) , GND );
cmodel #(.c(1.066e-16)) (*
integer library_binding = "analogLib";
 *)

c235 ( \5:MR_BYPASS10RX_FILTER , GND );
cmodel #(.c(4.906e-16)) (*
integer library_binding = "analogLib";
 *)

c236 ( MR_SQUELCH_DISB_1p0, GND );
cmodel #(.c(4.906e-16)) (*
integer library_binding = "analogLib";
 *)

c237 ( \MR_SQUELCH_RANGE_1p0(0) , GND );
cmodel #(.c(4.906e-16)) (*
integer library_binding = "analogLib";
 *)

c238 ( \MR_SQUELCH_RANGE_1p0(1) , GND );
cmodel #(.c(4.784e-16)) (*
integer library_binding = "analogLib";
 *)

c239 ( NEG_DETECT_1p0, GND );
cmodel #(.c(3.806e-16)) (*
integer library_binding = "analogLib";
 *)

c240 ( \2:PHY(0) , GND );
cmodel #(.c(3.806e-16)) (*
integer library_binding = "analogLib";
 *)

c241 ( \2:PHY(1) , GND );
cmodel #(.c(3.806e-16)) (*
integer library_binding = "analogLib";
 *)

c242 ( \2:PHY(2) , GND );
cmodel #(.c(3.806e-16)) (*
integer library_binding = "analogLib";
 *)

c243 ( \2:PHY(3) , GND );
cmodel #(.c(3.806e-16)) (*
integer library_binding = "analogLib";
 *)

c244 ( \2:PHY(4) , GND );
cmodel #(.c(4.784e-16)) (*
integer library_binding = "analogLib";
 *)

c245 ( POS_DETECT_1p0, GND );
cmodel #(.c(4.134e-16)) (*
integer library_binding = "analogLib";
 *)

c246 ( \7:RCLK125_1p0 , GND );
cmodel #(.c(3.346e-15)) (*
integer library_binding = "analogLib";
 *)

c247 ( \2:RESET_10BT , GND );
cmodel #(.c(4.015e-16)) (*
integer library_binding = "analogLib";
 *)

c248 ( \3:RESETN , GND );
cmodel #(.c(4.142e-16)) (*
integer library_binding = "analogLib";
 *)

c249 ( \4:RESET_DSP , GND );
cmodel #(.c(4.906e-16)) (*
integer library_binding = "analogLib";
 *)

c250 ( RX10_PRESENT_1p0, GND );
cmodel #(.c(3.806e-16)) (*
integer library_binding = "analogLib";
 *)

c251 ( \2:RXC , GND );
cmodel #(.c(3.806e-16)) (*
integer library_binding = "analogLib";
 *)

c252 ( \2:RXD(0) , GND );
cmodel #(.c(3.806e-16)) (*
integer library_binding = "analogLib";
 *)

c253 ( \2:RXD(1) , GND );
cmodel #(.c(3.806e-16)) (*
integer library_binding = "analogLib";
 *)

c254 ( \2:RXD(2) , GND );
cmodel #(.c(3.806e-16)) (*
integer library_binding = "analogLib";
 *)

c255 ( \2:RXD(3) , GND );
cmodel #(.c(3.806e-16)) (*
integer library_binding = "analogLib";
 *)

c256 ( \2:RXD(4) , GND );
cmodel #(.c(3.806e-16)) (*
integer library_binding = "analogLib";
 *)

c257 ( \2:RXDV , GND );
cmodel #(.c(3.806e-16)) (*
integer library_binding = "analogLib";
 *)

c258 ( \2:RXER , GND );
cmodel #(.c(3.806e-16)) (*
integer library_binding = "analogLib";
 *)

c259 ( \2:SCANCLK1 , GND );
cmodel #(.c(3.806e-16)) (*
integer library_binding = "analogLib";
 *)

c260 ( \2:SCANCLK2 , GND );
cmodel #(.c(3.806e-16)) (*
integer library_binding = "analogLib";
 *)

c261 ( \2:SCANCLK3 , GND );
cmodel #(.c(3.806e-16)) (*
integer library_binding = "analogLib";
 *)

c262 ( \2:SCAN_ENABLE , GND );
cmodel #(.c(3.806e-16)) (*
integer library_binding = "analogLib";
 *)

c263 ( \2:SCAN_MODE , GND );
cmodel #(.c(4.906e-16)) (*
integer library_binding = "analogLib";
 *)

c264 ( SLICER_OUT_1p0, GND );
cmodel #(.c(3.806e-16)) (*
integer library_binding = "analogLib";
 *)

c265 ( \2:SYMBOL_MODE , GND );
cmodel #(.c(2.993e-17)) (*
integer library_binding = "analogLib";
 *)

c266 ( \6:T2_MODE , GND );
cmodel #(.c(2.994e-17)) (*
integer library_binding = "analogLib";
 *)

c267 ( \5:TENBT_CLK160_1p0 , GND );
cmodel #(.c(4.641e-16)) (*
integer library_binding = "analogLib";
 *)

c268 ( \4:TENBT_FILTER_1p0(0) , GND );
cmodel #(.c(4.851e-16)) (*
integer library_binding = "analogLib";
 *)

c269 ( \4:TENBT_FILTER_1p0(1) , GND );
cmodel #(.c(2.229e-15)) (*
integer library_binding = "analogLib";
 *)

c270 ( \4:TENBT_FILTER_1p0(2) , GND );
cmodel #(.c(2.192e-15)) (*
integer library_binding = "analogLib";
 *)

c271 ( \4:TENBT_FILTER_1p0(3) , GND );
cmodel #(.c(5.483e-16)) (*
integer library_binding = "analogLib";
 *)

c272 ( \4:TENBT_FILTER_1p0(4) , GND );
cmodel #(.c(4.906e-16)) (*
integer library_binding = "analogLib";
 *)

c273 ( \TEST_MODE(0) , GND );
cmodel #(.c(4.906e-16)) (*
integer library_binding = "analogLib";
 *)

c274 ( \TEST_MODE(1) , GND );
cmodel #(.c(4.906e-16)) (*
integer library_binding = "analogLib";
 *)

c275 ( \TEST_MODE(2) , GND );
cmodel #(.c(2.065e-16)) (*
integer library_binding = "analogLib";
 *)

c276 ( \4:TIMING_DN_ANLG , GND );
cmodel #(.c(4.529e-17)) (*
integer library_binding = "analogLib";
 *)

c277 ( \4:TIMING_UP_ANLG , GND );
cmodel #(.c(4.906e-16)) (*
integer library_binding = "analogLib";
 *)

c278 ( TP_DISC_1p0, GND );
cmodel #(.c(3.806e-16)) (*
integer library_binding = "analogLib";
 *)

c279 ( \2:TRISTATE , GND );
cmodel #(.c(3.806e-16)) (*
integer library_binding = "analogLib";
 *)

c280 ( \2:TXC , GND );
cmodel #(.c(3.806e-16)) (*
integer library_binding = "analogLib";
 *)

c281 ( \2:TXD(0) , GND );
cmodel #(.c(3.806e-16)) (*
integer library_binding = "analogLib";
 *)

c282 ( \2:TXD(1) , GND );
cmodel #(.c(3.806e-16)) (*
integer library_binding = "analogLib";
 *)

c283 ( \2:TXD(2) , GND );
cmodel #(.c(3.806e-16)) (*
integer library_binding = "analogLib";
 *)

c284 ( \2:TXD(3) , GND );
cmodel #(.c(3.806e-16)) (*
integer library_binding = "analogLib";
 *)

c285 ( \2:TXD(4) , GND );
cmodel #(.c(3.806e-16)) (*
integer library_binding = "analogLib";
 *)

c286 ( \2:TXEN , GND );
cmodel #(.c(3.438e-16)) (*
integer library_binding = "analogLib";
 *)

c287 ( \3:TXER , GND );
cmodel #(.c(4.905e-16)) (*
integer library_binding = "analogLib";
 *)

c288 ( \TX_AMPTRIM_1p0(0) , GND );
cmodel #(.c(4.582e-16)) (*
integer library_binding = "analogLib";
 *)

c289 ( \TX_AMPTRIM_1p0(1) , GND );
cmodel #(.c(3.806e-16)) (*
integer library_binding = "analogLib";
 *)

c290 ( \2:TX_AMP_TRIM(0) , GND );
cmodel #(.c(3.806e-16)) (*
integer library_binding = "analogLib";
 *)

c291 ( \2:TX_AMP_TRIM(1) , GND );
cmodel #(.c(4.906e-16)) (*
integer library_binding = "analogLib";
 *)

c292 ( \TX_SLOPETRIM_1p0(0) , GND );
cmodel #(.c(4.906e-16)) (*
integer library_binding = "analogLib";
 *)

c293 ( \TX_SLOPETRIM_1p0(1) , GND );
cmodel #(.c(3.806e-16)) (*
integer library_binding = "analogLib";
 *)

c294 ( \2:TX_SLP_TRIM(0) , GND );
cmodel #(.c(3.806e-16)) (*
integer library_binding = "analogLib";
 *)

c295 ( \2:TX_SLP_TRIM(1) , GND );
cmodel #(.c(2.131e-15)) (*
integer library_binding = "analogLib";
 *)

c296 ( \4:WANDER_CNT(0) , GND );
cmodel #(.c(1.47e-16)) (*
integer library_binding = "analogLib";
 *)

c297 ( \6:WANDER_CNT(1) , GND );
cmodel #(.c(1.742e-16)) (*
integer library_binding = "analogLib";
 *)

c298 ( \4:WANDER_CNT(2) , GND );
cmodel #(.c(3.257e-16)) (*
integer library_binding = "analogLib";
 *)

c299 ( \5:WANDER_CNT(3) , GND );
cmodel #(.c(4.827e-16)) (*
integer library_binding = "analogLib";
 *)

c300 ( \6:WANDER_CNT(4) , GND );
cmodel #(.c(2.215e-16)) (*
integer library_binding = "analogLib";
 *)

c301 ( \6:WANDER_CNT(5) , GND );
cmodel #(.c(4.005e-16)) (*
integer library_binding = "analogLib";
 *)

c302 ( \5:WANDER_CNT(6) , GND );
cmodel #(.c(4.906e-16)) (*
integer library_binding = "analogLib";
 *)

c303 ( XTAL25_1p0, GND );
cmodel #(.c(4.906e-16)) (*
integer library_binding = "analogLib";
 *)

c304 ( X_125, GND );
cmodel #(.c(4.906e-16)) (*
integer library_binding = "analogLib";
 *)

c305 ( X_160, GND );
cmodel #(.c(3.806e-16)) (*
integer library_binding = "analogLib";
 *)

c306 ( \2:scan_reset , GND );
cmodel #(.c(3.806e-16)) (*
integer library_binding = "analogLib";
 *)

c307 ( \2:scan_set , GND );
cmodel #(.c(8.478e-17)) (*
integer library_binding = "analogLib";
 *)

c308 ( \6:ADC_DIS_2p5 , GND );
cmodel #(.c(7.381e-16)) (*
integer library_binding = "analogLib";
 *)

c309 ( \6:ADC_TEST_2p5 , GND );
cmodel #(.c(2.188e-16)) (*
integer library_binding = "analogLib";
 *)

c310 ( \6:AEQ_DIS_2p5 , GND );
cmodel #(.c(1.946e-16)) (*
integer library_binding = "analogLib";
 *)

c311 ( \4:B100_DIS , GND );
cmodel #(.c(1.331e-16)) (*
integer library_binding = "analogLib";
 *)

c312 ( \4:B10_DIS , GND );
cmodel #(.c(8.695e-16)) (*
integer library_binding = "analogLib";
 *)

c313 ( \8:BASEFX_DIS , GND );
cmodel #(.c(7.742e-16)) (*
integer library_binding = "analogLib";
 *)

c314 ( \6:BLW_DIS_2p5 , GND );
cmodel #(.c(8.781e-15)) (*
integer library_binding = "analogLib";
 *)

c315 ( \18:GNDRX , GND );
cmodel #(.c(3.962e-14)) (*
integer library_binding = "analogLib";
 *)

c316 ( \9:GNDTX , GND );
cmodel #(.c(5.378e-16)) (*
integer library_binding = "analogLib";
 *)

c317 ( \2:MLT3_TDATA_1p0(0) , GND );
cmodel #(.c(5.378e-16)) (*
integer library_binding = "analogLib";
 *)

c318 ( \2:MLT3_TDATA_1p0(1) , GND );
cmodel #(.c(3.954e-17)) (*
integer library_binding = "analogLib";
 *)

c319 ( \4:MLT3_TDATA_2p5(0) , GND );
cmodel #(.c(1.307e-16)) (*
integer library_binding = "analogLib";
 *)

c320 ( \4:MLT3_TDATA_2p5(1) , GND );
cmodel #(.c(5.378e-16)) (*
integer library_binding = "analogLib";
 *)

c321 ( \2:MR_SQUELCH_DISB_1p0 , GND );
cmodel #(.c(6.573e-16)) (*
integer library_binding = "analogLib";
 *)

c322 ( \6:MR_SQUELCH_DISB_2p5 , GND );
cmodel #(.c(5.378e-16)) (*
integer library_binding = "analogLib";
 *)

c323 ( \2:MR_SQUELCH_RANGE_1p0(0) , GND );
cmodel #(.c(5.378e-16)) (*
integer library_binding = "analogLib";
 *)

c324 ( \2:MR_SQUELCH_RANGE_1p0(1) , GND );
cmodel #(.c(6.414e-16)) (*
integer library_binding = "analogLib";
 *)

c325 ( \4:MR_SQUELCH_RANGE_2p5(0) , GND );
cmodel #(.c(6.74e-16)) (*
integer library_binding = "analogLib";
 *)

c326 ( \6:MR_SQUELCH_RANGE_2p5(1) , GND );
cmodel #(.c(2.732e-17)) (*
integer library_binding = "analogLib";
 *)

c327 ( \3:NEG_DETECT_1p0 , GND );
cmodel #(.c(8.107e-16)) (*
integer library_binding = "analogLib";
 *)

c328 ( \3:NEG_DETECT_2p5 , GND );
cmodel #(.c(6.583e-17)) (*
integer library_binding = "analogLib";
 *)

c329 ( \4:PHASE_250(0) , GND );
cmodel #(.c(1.577e-16)) (*
integer library_binding = "analogLib";
 *)

c330 ( \4:PHASE_250(10) , GND );
cmodel #(.c(1.734e-16)) (*
integer library_binding = "analogLib";
 *)

c331 ( \4:PHASE_250(1) , GND );
cmodel #(.c(1.523e-16)) (*
integer library_binding = "analogLib";
 *)

c332 ( \4:PHASE_250(2) , GND );
cmodel #(.c(1.036e-16)) (*
integer library_binding = "analogLib";
 *)

c333 ( \4:PHASE_250(3) , GND );
cmodel #(.c(4.991e-17)) (*
integer library_binding = "analogLib";
 *)

c334 ( \4:PHASE_250(4) , GND );
cmodel #(.c(8.916e-16)) (*
integer library_binding = "analogLib";
 *)

c335 ( \4:PHASE_250(5) , GND );
cmodel #(.c(4.607e-17)) (*
integer library_binding = "analogLib";
 *)

c336 ( \4:PHASE_250(6) , GND );
cmodel #(.c(7.283e-16)) (*
integer library_binding = "analogLib";
 *)

c337 ( \4:PHASE_250(7) , GND );
cmodel #(.c(2.993e-17)) (*
integer library_binding = "analogLib";
 *)

c338 ( \4:PHASE_250(8) , GND );
cmodel #(.c(9.115e-17)) (*
integer library_binding = "analogLib";
 *)

c339 ( \4:PHASE_250(9) , GND );
cmodel #(.c(6.199e-17)) (*
integer library_binding = "analogLib";
 *)

c340 ( \6:PHASE_IN(0) , GND );
cmodel #(.c(2.827e-14)) (*
integer library_binding = "analogLib";
 *)

c341 ( \5:PHASE_IN(10) , GND );
cmodel #(.c(1.247e-16)) (*
integer library_binding = "analogLib";
 *)

c342 ( \4:PHASE_IN(1) , GND );
cmodel #(.c(2.831e-14)) (*
integer library_binding = "analogLib";
 *)

c343 ( \5:PHASE_IN(2) , GND );
cmodel #(.c(2.852e-14)) (*
integer library_binding = "analogLib";
 *)

c344 ( \3:PHASE_IN(3) , GND );
cmodel #(.c(2.861e-14)) (*
integer library_binding = "analogLib";
 *)

c345 ( \3:PHASE_IN(4) , GND );
cmodel #(.c(2.822e-14)) (*
integer library_binding = "analogLib";
 *)

c346 ( \5:PHASE_IN(5) , GND );
cmodel #(.c(2.816e-14)) (*
integer library_binding = "analogLib";
 *)

c347 ( \5:PHASE_IN(6) , GND );
cmodel #(.c(2.827e-14)) (*
integer library_binding = "analogLib";
 *)

c348 ( \5:PHASE_IN(7) , GND );
cmodel #(.c(2.824e-14)) (*
integer library_binding = "analogLib";
 *)

c349 ( \5:PHASE_IN(8) , GND );
cmodel #(.c(2.816e-14)) (*
integer library_binding = "analogLib";
 *)

c350 ( \5:PHASE_IN(9) , GND );
cmodel #(.c(6.715e-17)) (*
integer library_binding = "analogLib";
 *)

c351 ( \4:PLL_160_IN , GND );
cmodel #(.c(2.732e-17)) (*
integer library_binding = "analogLib";
 *)

c352 ( \3:POS_DETECT_1p0 , GND );
cmodel #(.c(7.968e-16)) (*
integer library_binding = "analogLib";
 *)

c353 ( \3:POS_DETECT_2p5 , GND );
cmodel #(.c(3.542e-16)) (*
integer library_binding = "analogLib";
 *)

c354 ( \4:RCLK125_TST , GND );
cmodel #(.c(2.09e-16)) (*
integer library_binding = "analogLib";
 *)

c355 ( \4:RCLK125_TST_SEL , GND );
cmodel #(.c(1.01e-16)) (*
integer library_binding = "analogLib";
 *)

c356 ( \4:RESETN , GND );
cmodel #(.c(5.23e-16)) (*
integer library_binding = "analogLib";
 *)

c357 ( \2:RX10_PRESENT_1p0 , GND );
cmodel #(.c(6.934e-16)) (*
integer library_binding = "analogLib";
 *)

c358 ( \6:RX10_PRESENT_2p5 , GND );
cmodel #(.c(8.026e-16)) (*
integer library_binding = "analogLib";
 *)

c359 ( \10:SIDDQ , GND );
cmodel #(.c(5.628e-16)) (*
integer library_binding = "analogLib";
 *)

c360 ( \2:SLICER_OUT_1p0 , GND );
cmodel #(.c(8.003e-16)) (*
integer library_binding = "analogLib";
 *)

c361 ( \3:SLICER_OUT_2p5 , GND );
cmodel #(.c(5.23e-16)) (*
integer library_binding = "analogLib";
 *)

c362 ( \2:TEST_MODE(0) , GND );
cmodel #(.c(5.23e-16)) (*
integer library_binding = "analogLib";
 *)

c363 ( \2:TEST_MODE(1) , GND );
cmodel #(.c(5.23e-16)) (*
integer library_binding = "analogLib";
 *)

c364 ( \2:TEST_MODE(2) , GND );
cmodel #(.c(5.23e-16)) (*
integer library_binding = "analogLib";
 *)

c365 ( \2:TP_DISC_1p0 , GND );
cmodel #(.c(4.231e-16)) (*
integer library_binding = "analogLib";
 *)

c366 ( \4:TP_DISC_2p5 , GND );
cmodel #(.c(7.548e-17)) (*
integer library_binding = "analogLib";
 *)

c367 ( \9:TX100_DIS_2p5 , GND );
cmodel #(.c(1.864e-16)) (*
integer library_binding = "analogLib";
 *)

c368 ( \4:TXER , GND );
cmodel #(.c(5.069e-16)) (*
integer library_binding = "analogLib";
 *)

c369 ( \2:TX_AMPTRIM_1p0(0) , GND );
cmodel #(.c(4.319e-17)) (*
integer library_binding = "analogLib";
 *)

c370 ( \3:TX_AMPTRIM_1p0(1) , GND );
cmodel #(.c(5.069e-16)) (*
integer library_binding = "analogLib";
 *)

c371 ( \2:TX_SLOPETRIM_1p0(0) , GND );
cmodel #(.c(5.069e-16)) (*
integer library_binding = "analogLib";
 *)

c372 ( \2:TX_SLOPETRIM_1p0(1) , GND );
cmodel #(.c(1.739e-14)) (*
integer library_binding = "analogLib";
 *)

c373 ( \8:VDDRX , GND );
cmodel #(.c(5.472e-14)) (*
integer library_binding = "analogLib";
 *)

c374 ( \28:VDDTX , GND );
cmodel #(.c(1.358e-16)) (*
integer library_binding = "analogLib";
 *)

c375 ( \9:X10_DIS_2p5 , GND );
cmodel #(.c(5.628e-16)) (*
integer library_binding = "analogLib";
 *)

c376 ( \2:XTAL25_1p0 , GND );
cmodel #(.c(1.225e-16)) (*
integer library_binding = "analogLib";
 *)

c377 ( \4:XTAL25 , GND );
cmodel #(.c(5.628e-16)) (*
integer library_binding = "analogLib";
 *)

c378 ( \2:X_125 , GND );
cmodel #(.c(5.628e-16)) (*
integer library_binding = "analogLib";
 *)

c379 ( \2:X_160 , GND );
cmodel #(.c(5.891e-16)) (*
integer library_binding = "analogLib";
 *)

c380 ( \9:VDDRX , GND );
cmodel #(.c(1.008e-16)) (*
integer library_binding = "analogLib";
 *)

c381 ( \19:GNDRX , GND );
cmodel #(.c(2.945e-17)) (*
integer library_binding = "analogLib";
 *)

c382 ( \6:I_REXT_100(0) , GND );
cmodel #(.c(2.945e-17)) (*
integer library_binding = "analogLib";
 *)

c383 ( \6:I_REXT_100(1) , GND );
cmodel #(.c(2.945e-17)) (*
integer library_binding = "analogLib";
 *)

c384 ( \6:I_REXT_100(2) , GND );
cmodel #(.c(2.945e-17)) (*
integer library_binding = "analogLib";
 *)

c385 ( \6:I_REXT_100(3) , GND );
cmodel #(.c(2.945e-17)) (*
integer library_binding = "analogLib";
 *)

c386 ( \6:I_REXT_100(4) , GND );
cmodel #(.c(2.159e-16)) (*
integer library_binding = "analogLib";
 *)

c387 ( \6:I_REXT_100(5) , GND );
cmodel #(.c(3.141e-16)) (*
integer library_binding = "analogLib";
 *)

c388 ( \6:I_REXT_100(6) , GND );
cmodel #(.c(2.945e-17)) (*
integer library_binding = "analogLib";
 *)

c389 ( \7:I_REXT_100_NC , GND );
cmodel #(.c(2.945e-17)) (*
integer library_binding = "analogLib";
 *)

c390 ( \7:I_REXT_50(0) , GND );
cmodel #(.c(9.973e-17)) (*
integer library_binding = "analogLib";
 *)

c391 ( \6:I_REXT_50(1) , GND );
cmodel #(.c(2.895e-17)) (*
integer library_binding = "analogLib";
 *)

c392 ( \6:I_REXT_REF100 , GND );
cmodel #(.c(2.945e-17)) (*
integer library_binding = "analogLib";
 *)

c393 ( \6:I_RPOLY_100(0) , GND );
cmodel #(.c(2.941e-17)) (*
integer library_binding = "analogLib";
 *)

c394 ( \6:I_RPOLY_100(1) , GND );
cmodel #(.c(5.814e-17)) (*
integer library_binding = "analogLib";
 *)

c395 ( \6:I_RPOLY_100(2) , GND );
cmodel #(.c(7.094e-17)) (*
integer library_binding = "analogLib";
 *)

c396 ( \6:I_RPOLY_100(3) , GND );
cmodel #(.c(4.657e-17)) (*
integer library_binding = "analogLib";
 *)

c397 ( \6:I_RPOLY_100(4) , GND );
cmodel #(.c(7.13e-17)) (*
integer library_binding = "analogLib";
 *)

c398 ( \6:I_RPOLY_100(5) , GND );
cmodel #(.c(7.136e-17)) (*
integer library_binding = "analogLib";
 *)

c399 ( \8:I_RPOLY_REF100 , GND );
cmodel #(.c(2.895e-17)) (*
integer library_binding = "analogLib";
 *)

c400 ( \11:SIDDQ , GND );
cmodel #(.c(4.369e-16)) (*
integer library_binding = "analogLib";
 *)

c401 ( \1:I_REXT_400_TX , GND );
cmodel #(.c(1.657e-16)) (*
integer library_binding = "analogLib";
 *)

c402 ( \1:I_RPOLY_REF100 , GND );
cmodel #(.c(2.834e-16)) (*
integer library_binding = "analogLib";
 *)

c403 ( \1:PHASE_IN(0) , GND );
cmodel #(.c(8.323e-16)) (*
integer library_binding = "analogLib";
 *)

c404 ( \1:SIDDQ , GND );
cmodel #(.c(3.189e-14)) (*
integer library_binding = "analogLib";
 *)

c405 ( \1:XTAL25 , GND );
cmodel #(.c(5.667e-14)) (*
integer library_binding = "analogLib";
 *)

c406 ( \1:PLL_160_IN , GND );
cmodel #(.c(2.428e-14)) (*
integer library_binding = "analogLib";
 *)

c407 ( \3:I_RPOLY_REF100 , GND );
cmodel #(.c(6.545e-14)) (*
integer library_binding = "analogLib";
 *)

c408 ( \2:I_RPOLY_REF100 , GND );
cmodel #(.c(5.696e-15)) (*
integer library_binding = "analogLib";
 *)

c409 ( \2:PHASE_IN(0) , GND );
cmodel #(.c(8.671e-15)) (*
integer library_binding = "analogLib";
 *)

c410 ( \2:TENBT_CLK160_1p0 , GND );
cmodel #(.c(2.86e-15)) (*
integer library_binding = "analogLib";
 *)

c411 ( \1:TENBT_CLK160_1p0 , GND );
cmodel #(.c(2.738e-14)) (*
integer library_binding = "analogLib";
 *)

c412 ( \2:I_REXT_400_TX , GND );
cmodel #(.c(9.883e-15)) (*
integer library_binding = "analogLib";
 *)

c413 ( \14:VDDTX , GND );
cmodel #(.c(6.039e-14)) (*
integer library_binding = "analogLib";
 *)

c414 ( \9:VDDTX , GND );
cmodel #(.c(9.216e-16)) (*
integer library_binding = "analogLib";
 *)

c415 ( \7:VDDTX , GND );
cmodel #(.c(3.706e-15)) (*
integer library_binding = "analogLib";
 *)

c416 ( \3:BASE10_TX_DIS_1p0 , GND );
cmodel #(.c(8.704e-15)) (*
integer library_binding = "analogLib";
 *)

c417 ( \3:TENBT_CLK160_1p0 , GND );
cmodel #(.c(2.49e-15)) (*
integer library_binding = "analogLib";
 *)

c418 ( \1:TENBT_FILTER_1p0(3) , GND );
cmodel #(.c(2.439e-15)) (*
integer library_binding = "analogLib";
 *)

c419 ( \1:TENBT_FILTER_1p0(2) , GND );
cmodel #(.c(2.42e-15)) (*
integer library_binding = "analogLib";
 *)

c420 ( \2:TENBT_FILTER_1p0(3) , GND );
cmodel #(.c(2.306e-15)) (*
integer library_binding = "analogLib";
 *)

c421 ( \2:TENBT_FILTER_1p0(2) , GND );
cmodel #(.c(2.369e-14)) (*
integer library_binding = "analogLib";
 *)

c422 ( \1:I_REXT_50(1) , GND );
cmodel #(.c(1.256e-14)) (*
integer library_binding = "analogLib";
 *)

c423 ( \1:X10_DIS_2p5 , GND );
cmodel #(.c(1.209e-14)) (*
integer library_binding = "analogLib";
 *)

c424 ( \1:TX100_DIS_2p5 , GND );
cmodel #(.c(5.532e-15)) (*
integer library_binding = "analogLib";
 *)

c425 ( \5:I_REXT_400_TX , GND );
cmodel #(.c(7.506e-15)) (*
integer library_binding = "analogLib";
 *)

c426 ( \2:I_REXT_100_NC , GND );
cmodel #(.c(2.503e-14)) (*
integer library_binding = "analogLib";
 *)

c427 ( \1:I_REXT_100_NC , GND );
cmodel #(.c(8.082e-15)) (*
integer library_binding = "analogLib";
 *)

c428 ( \2:I_REXT_50(0) , GND );
cmodel #(.c(3.344e-14)) (*
integer library_binding = "analogLib";
 *)

c429 ( \1:I_REXT_50(0) , GND );
cmodel #(.c(7.602e-15)) (*
integer library_binding = "analogLib";
 *)

c430 ( \3:SIDDQ , GND );
cmodel #(.c(1.296e-14)) (*
integer library_binding = "analogLib";
 *)

c431 ( \2:SIDDQ , GND );
cmodel #(.c(1.539e-14)) (*
integer library_binding = "analogLib";
 *)

c432 ( \1:WANDER_CNT(3) , GND );
cmodel #(.c(9.532e-15)) (*
integer library_binding = "analogLib";
 *)

c433 ( \4:TX100_DIS_2p5 , GND );
cmodel #(.c(2.264e-14)) (*
integer library_binding = "analogLib";
 *)

c434 ( \2:TX100_DIS_2p5 , GND );
cmodel #(.c(1.808e-14)) (*
integer library_binding = "analogLib";
 *)

c435 ( \1:WANDER_CNT(6) , GND );
cmodel #(.c(1.477e-14)) (*
integer library_binding = "analogLib";
 *)

c436 ( \1:WANDER_CNT(0) , GND );
cmodel #(.c(1.331e-14)) (*
integer library_binding = "analogLib";
 *)

c437 ( \2:T2_MODE , GND );
cmodel #(.c(1.449e-14)) (*
integer library_binding = "analogLib";
 *)

c438 ( \1:T2_MODE , GND );
cmodel #(.c(2.865e-14)) (*
integer library_binding = "analogLib";
 *)

c439 ( \1:WANDER_CNT(2) , GND );
cmodel #(.c(2.956e-14)) (*
integer library_binding = "analogLib";
 *)

c440 ( \2:WANDER_CNT(1) , GND );
cmodel #(.c(1.702e-14)) (*
integer library_binding = "analogLib";
 *)

c441 ( \1:AEQ_CNT_ANLG(0) , GND );
cmodel #(.c(3.146e-16)) (*
integer library_binding = "analogLib";
 *)

c442 ( \2:BASEFX_DIS , GND );
cmodel #(.c(1.44e-14)) (*
integer library_binding = "analogLib";
 *)

c443 ( \2:AEQ_CNT_ANLG(3) , GND );
cmodel #(.c(1.659e-14)) (*
integer library_binding = "analogLib";
 *)

c444 ( \1:AEQ_CNT_ANLG(3) , GND );
cmodel #(.c(3.38e-16)) (*
integer library_binding = "analogLib";
 *)

c445 ( \4:X10_DIS_2p5 , GND );
cmodel #(.c(1.879e-16)) (*
integer library_binding = "analogLib";
 *)

c446 ( \2:BLW_DIS_2p5 , GND );
cmodel #(.c(1.502e-14)) (*
integer library_binding = "analogLib";
 *)

c447 ( \2:AEQ_CNT_ANLG(4) , GND );
cmodel #(.c(1.616e-14)) (*
integer library_binding = "analogLib";
 *)

c448 ( \1:AEQ_CNT_ANLG(4) , GND );
cmodel #(.c(2.578e-16)) (*
integer library_binding = "analogLib";
 *)

c449 ( \2:ADC_DIS_2p5 , GND );
cmodel #(.c(1.509e-14)) (*
integer library_binding = "analogLib";
 *)

c450 ( \1:AEQ_BYPASS , GND );
cmodel #(.c(3.118e-16)) (*
integer library_binding = "analogLib";
 *)

c451 ( \1:WANDER_CNT(4) , GND );
cmodel #(.c(1.838e-14)) (*
integer library_binding = "analogLib";
 *)

c452 ( \1:AEQ_CNT_ANLG(2) , GND );
cmodel #(.c(1.451e-16)) (*
integer library_binding = "analogLib";
 *)

c453 ( \3:WANDER_CNT(1) , GND );
cmodel #(.c(2.379e-14)) (*
integer library_binding = "analogLib";
 *)

c454 ( \1:WANDER_CNT(1) , GND );
cmodel #(.c(2.023e-14)) (*
integer library_binding = "analogLib";
 *)

c455 ( \1:AEQ_CNT_ANLG(1) , GND );
cmodel #(.c(2.774e-16)) (*
integer library_binding = "analogLib";
 *)

c456 ( \1:WANDER_CNT(5) , GND );
cmodel #(.c(3.704e-16)) (*
integer library_binding = "analogLib";
 *)

c457 ( \3:T2_MODE , GND );
cmodel #(.c(1.522e-16)) (*
integer library_binding = "analogLib";
 *)

c458 ( \1:ADC_TEST_2p5 , GND );
cmodel #(.c(2.262e-16)) (*
integer library_binding = "analogLib";
 *)

c459 ( \3:AEQ_CNT_ANLG(3) , GND );
cmodel #(.c(1.598e-14)) (*
integer library_binding = "analogLib";
 *)

c460 ( \1:MR_SQUELCH_RANGE_2p5(0) , GND );
cmodel #(.c(3.238e-16)) (*
integer library_binding = "analogLib";
 *)

c461 ( \3:MR_SQUELCH_DISB_2p5 , GND );
cmodel #(.c(3.479e-16)) (*
integer library_binding = "analogLib";
 *)

c462 ( \5:TX100_DIS_2p5 , GND );
cmodel #(.c(1.736e-16)) (*
integer library_binding = "analogLib";
 *)

c463 ( \3:RX10_PRESENT_2p5 , GND );
cmodel #(.c(2.333e-16)) (*
integer library_binding = "analogLib";
 *)

c464 ( \3:MR_SQUELCH_RANGE_2p5(1) , GND );
cmodel #(.c(1.449e-14)) (*
integer library_binding = "analogLib";
 *)

c465 ( \1:MR_BYPASS10RX_FILTER , GND );
cmodel #(.c(2.301e-16)) (*
integer library_binding = "analogLib";
 *)

c466 ( \3:AEQ_CNT_ANLG(4) , GND );
cmodel #(.c(1.982e-15)) (*
integer library_binding = "analogLib";
 *)

c467 ( \4:BASEFX_DIS , GND );
cmodel #(.c(5.113e-16)) (*
integer library_binding = "analogLib";
 *)

c468 ( \4:AEQ_CNT_ANLG(0) , GND );
cmodel #(.c(3.351e-16)) (*
integer library_binding = "analogLib";
 *)

c469 ( \2:AEQ_CNT_ANLG(2) , GND );
cmodel #(.c(7.955e-16)) (*
integer library_binding = "analogLib";
 *)

c470 ( \4:AEQ_CNT_ANLG(4) , GND );
cmodel #(.c(9.808e-16)) (*
integer library_binding = "analogLib";
 *)

c471 ( \2:AEQ_BYPASS , GND );
cmodel #(.c(2.863e-15)) (*
integer library_binding = "analogLib";
 *)

c472 ( \1:RCLK125_TST_SEL , GND );
cmodel #(.c(1.03e-15)) (*
integer library_binding = "analogLib";
 *)

c473 ( \4:WANDER_CNT(5) , GND );
cmodel #(.c(3.36e-15)) (*
integer library_binding = "analogLib";
 *)

c474 ( \1:TIMING_DN_ANLG , GND );
cmodel #(.c(3.984e-15)) (*
integer library_binding = "analogLib";
 *)

c475 ( \1:TIMING_UP_ANLG , GND );
cmodel #(.c(1.528e-15)) (*
integer library_binding = "analogLib";
 *)

c476 ( \3:WANDER_CNT(3) , GND );
cmodel #(.c(4.28e-15)) (*
integer library_binding = "analogLib";
 *)

c477 ( \1:RESET_DSP , GND );
cmodel #(.c(8.936e-16)) (*
integer library_binding = "analogLib";
 *)

c478 ( \4:WANDER_CNT(1) , GND );
cmodel #(.c(3.912e-15)) (*
integer library_binding = "analogLib";
 *)

c479 ( \2:WANDER_CNT(0) , GND );
cmodel #(.c(2.717e-15)) (*
integer library_binding = "analogLib";
 *)

c480 ( \1:PHASE_250(7) , GND );
cmodel #(.c(9.759e-16)) (*
integer library_binding = "analogLib";
 *)

c481 ( \2:WANDER_CNT(2) , GND );
cmodel #(.c(4.442e-15)) (*
integer library_binding = "analogLib";
 *)

c482 ( \1:PHASE_250(6) , GND );
cmodel #(.c(1.208e-15)) (*
integer library_binding = "analogLib";
 *)

c483 ( \1:PHASE_250(5) , GND );
cmodel #(.c(2.516e-14)) (*
integer library_binding = "analogLib";
 *)

c484 ( \2:PLL_160_IN , GND );
cmodel #(.c(1.565e-15)) (*
integer library_binding = "analogLib";
 *)

c485 ( \4:WANDER_CNT(4) , GND );
cmodel #(.c(1.192e-15)) (*
integer library_binding = "analogLib";
 *)

c486 ( \3:WANDER_CNT(6) , GND );
cmodel #(.c(4.679e-15)) (*
integer library_binding = "analogLib";
 *)

c487 ( \1:PHASE_250(1) , GND );
cmodel #(.c(1.235e-15)) (*
integer library_binding = "analogLib";
 *)

c488 ( \4:T2_MODE , GND );
cmodel #(.c(4.617e-15)) (*
integer library_binding = "analogLib";
 *)

c489 ( \1:PHASE_250(0) , GND );
cmodel #(.c(9.97e-16)) (*
integer library_binding = "analogLib";
 *)

c490 ( \4:AEQ_CNT_ANLG(3) , GND );
cmodel #(.c(2.314e-15)) (*
integer library_binding = "analogLib";
 *)

c491 ( \4:ADC_DIS_2p5 , GND );
cmodel #(.c(1.764e-15)) (*
integer library_binding = "analogLib";
 *)

c492 ( \2:AEQ_CNT_ANLG(1) , GND );
cmodel #(.c(1.704e-15)) (*
integer library_binding = "analogLib";
 *)

c493 ( \3:MR_BYPASS10RX_FILTER , GND );
cmodel #(.c(2.907e-15)) (*
integer library_binding = "analogLib";
 *)

c494 ( \4:BLW_DIS_2p5 , GND );
cmodel #(.c(8.823e-16)) (*
integer library_binding = "analogLib";
 *)

c495 ( \2:RESET_DSP , GND );
cmodel #(.c(2.746e-15)) (*
integer library_binding = "analogLib";
 *)

c496 ( \3:ADC_TEST_2p5 , GND );
cmodel #(.c(7.101e-16)) (*
integer library_binding = "analogLib";
 *)

c497 ( \2:TIMING_UP_ANLG , GND );
cmodel #(.c(3.93e-15)) (*
integer library_binding = "analogLib";
 *)

c498 ( \4:RX10_PRESENT_2p5 , GND );
cmodel #(.c(8.645e-16)) (*
integer library_binding = "analogLib";
 *)

c499 ( \2:TIMING_DN_ANLG , GND );
cmodel #(.c(4.139e-15)) (*
integer library_binding = "analogLib";
 *)

c500 ( \4:MR_SQUELCH_DISB_2p5 , GND );
cmodel #(.c(3.1e-15)) (*
integer library_binding = "analogLib";
 *)

c501 ( \2:MR_SQUELCH_RANGE_2p5(0) , GND );
cmodel #(.c(4.048e-15)) (*
integer library_binding = "analogLib";
 *)

c502 ( \4:MR_SQUELCH_RANGE_2p5(1) , GND );
cmodel #(.c(2.091e-15)) (*
integer library_binding = "analogLib";
 *)

c503 ( \2:RCLK125_TST_SEL , GND );
cmodel #(.c(1.963e-15)) (*
integer library_binding = "analogLib";
 *)

c504 ( \2:PHASE_250(7) , GND );
cmodel #(.c(2.943e-15)) (*
integer library_binding = "analogLib";
 *)

c505 ( \2:PHASE_250(6) , GND );
cmodel #(.c(1.945e-15)) (*
integer library_binding = "analogLib";
 *)

c506 ( \2:PHASE_250(5) , GND );
cmodel #(.c(2.149e-15)) (*
integer library_binding = "analogLib";
 *)

c507 ( \2:PHASE_250(1) , GND );
cmodel #(.c(2.287e-15)) (*
integer library_binding = "analogLib";
 *)

c508 ( \2:PHASE_250(0) , GND );
cmodel #(.c(2.551e-14)) (*
integer library_binding = "analogLib";
 *)

c509 ( \2:XTAL25 , GND );
cmodel #(.c(6.237e-15)) (*
integer library_binding = "analogLib";
 *)

c510 ( \6:X10_DIS_2p5 , GND );
cmodel #(.c(4.298e-15)) (*
integer library_binding = "analogLib";
 *)

c511 ( \4:SIDDQ , GND );
cmodel #(.c(4.005e-16)) (*
integer library_binding = "analogLib";
 *)

c512 ( \1:SCAN_MODE , GND );
cmodel #(.c(4.005e-16)) (*
integer library_binding = "analogLib";
 *)

c513 ( \1:SCANCLK1 , GND );
cmodel #(.c(4.005e-16)) (*
integer library_binding = "analogLib";
 *)

c514 ( \1:SCANCLK2 , GND );
cmodel #(.c(4.005e-16)) (*
integer library_binding = "analogLib";
 *)

c515 ( \1:SCANCLK3 , GND );
cmodel #(.c(4.005e-16)) (*
integer library_binding = "analogLib";
 *)

c516 ( \1:scan_set , GND );
cmodel #(.c(4.005e-16)) (*
integer library_binding = "analogLib";
 *)

c517 ( \1:SCAN_ENABLE , GND );
cmodel #(.c(4.005e-16)) (*
integer library_binding = "analogLib";
 *)

c518 ( \1:scan_reset , GND );
cmodel #(.c(4.025e-16)) (*
integer library_binding = "analogLib";
 *)

c519 ( \1:MDIO_IN , GND );
cmodel #(.c(4.005e-16)) (*
integer library_binding = "analogLib";
 *)

c520 ( \1:PHY(4) , GND );
cmodel #(.c(4.005e-16)) (*
integer library_binding = "analogLib";
 *)

c521 ( \1:PHY(3) , GND );
cmodel #(.c(4.005e-16)) (*
integer library_binding = "analogLib";
 *)

c522 ( \1:PHY(2) , GND );
cmodel #(.c(4.005e-16)) (*
integer library_binding = "analogLib";
 *)

c523 ( \1:PHY(1) , GND );
cmodel #(.c(4.005e-16)) (*
integer library_binding = "analogLib";
 *)

c524 ( \1:PHY(0) , GND );
cmodel #(.c(4.005e-16)) (*
integer library_binding = "analogLib";
 *)

c525 ( \1:CRS , GND );
cmodel #(.c(4.005e-16)) (*
integer library_binding = "analogLib";
 *)

c526 ( \1:MDINT , GND );
cmodel #(.c(4.005e-16)) (*
integer library_binding = "analogLib";
 *)

c527 ( \1:LEDL , GND );
cmodel #(.c(4.005e-16)) (*
integer library_binding = "analogLib";
 *)

c528 ( \1:LEDD , GND );
cmodel #(.c(4.005e-16)) (*
integer library_binding = "analogLib";
 *)

c529 ( \1:SYMBOL_MODE , GND );
cmodel #(.c(4.005e-16)) (*
integer library_binding = "analogLib";
 *)

c530 ( \1:RXDV , GND );
cmodel #(.c(4.005e-16)) (*
integer library_binding = "analogLib";
 *)

c531 ( \1:TRISTATE , GND );
cmodel #(.c(4.005e-16)) (*
integer library_binding = "analogLib";
 *)

c532 ( \1:RXC , GND );
cmodel #(.c(4.005e-16)) (*
integer library_binding = "analogLib";
 *)

c533 ( \1:LEDT , GND );
cmodel #(.c(4.005e-16)) (*
integer library_binding = "analogLib";
 *)

c534 ( \1:LEDS , GND );
cmodel #(.c(4.005e-16)) (*
integer library_binding = "analogLib";
 *)

c535 ( \1:TXEN , GND );
cmodel #(.c(4.005e-16)) (*
integer library_binding = "analogLib";
 *)

c536 ( \1:COL , GND );
cmodel #(.c(4.005e-16)) (*
integer library_binding = "analogLib";
 *)

c537 ( \1:LEDC , GND );
cmodel #(.c(4.005e-16)) (*
integer library_binding = "analogLib";
 *)

c538 ( \1:MDIO_OE , GND );
cmodel #(.c(4.005e-16)) (*
integer library_binding = "analogLib";
 *)

c539 ( \1:MDIO_OUT , GND );
cmodel #(.c(4.005e-16)) (*
integer library_binding = "analogLib";
 *)

c540 ( \1:MDC , GND );
cmodel #(.c(4.005e-16)) (*
integer library_binding = "analogLib";
 *)

c541 ( \1:TX_AMP_TRIM(1) , GND );
cmodel #(.c(4.005e-16)) (*
integer library_binding = "analogLib";
 *)

c542 ( \1:TX_AMP_TRIM(0) , GND );
cmodel #(.c(4.005e-16)) (*
integer library_binding = "analogLib";
 *)

c543 ( \1:TXD(4) , GND );
cmodel #(.c(4.005e-16)) (*
integer library_binding = "analogLib";
 *)

c544 ( \1:TXD(3) , GND );
cmodel #(.c(4.005e-16)) (*
integer library_binding = "analogLib";
 *)

c545 ( \1:TXD(2) , GND );
cmodel #(.c(4.005e-16)) (*
integer library_binding = "analogLib";
 *)

c546 ( \1:TXD(1) , GND );
cmodel #(.c(4.005e-16)) (*
integer library_binding = "analogLib";
 *)

c547 ( \1:TXD(0) , GND );
cmodel #(.c(4.005e-16)) (*
integer library_binding = "analogLib";
 *)

c548 ( \1:LEDR , GND );
cmodel #(.c(4.005e-16)) (*
integer library_binding = "analogLib";
 *)

c549 ( \1:ANLG_TST , GND );
cmodel #(.c(4.005e-16)) (*
integer library_binding = "analogLib";
 *)

c550 ( \1:ANDIS , GND );
cmodel #(.c(4.005e-16)) (*
integer library_binding = "analogLib";
 *)

c551 ( \1:RXD(4) , GND );
cmodel #(.c(4.005e-16)) (*
integer library_binding = "analogLib";
 *)

c552 ( \1:RXD(3) , GND );
cmodel #(.c(4.005e-16)) (*
integer library_binding = "analogLib";
 *)

c553 ( \1:RXD(2) , GND );
cmodel #(.c(4.005e-16)) (*
integer library_binding = "analogLib";
 *)

c554 ( \1:RXD(1) , GND );
cmodel #(.c(4.005e-16)) (*
integer library_binding = "analogLib";
 *)

c555 ( \1:RXD(0) , GND );
cmodel #(.c(4.005e-16)) (*
integer library_binding = "analogLib";
 *)

c556 ( \1:RXER , GND );
cmodel #(.c(4.005e-16)) (*
integer library_binding = "analogLib";
 *)

c557 ( \1:TX_SLP_TRIM(1) , GND );
cmodel #(.c(4.005e-16)) (*
integer library_binding = "analogLib";
 *)

c558 ( \1:TXC , GND );
cmodel #(.c(4.005e-16)) (*
integer library_binding = "analogLib";
 *)

c559 ( \1:TX_SLP_TRIM(0) , GND );
cmodel #(.c(9.142e-15)) (*
integer library_binding = "analogLib";
 *)

c560 ( \2:ADC_1p0(2) , GND );
cmodel #(.c(1.153e-14)) (*
integer library_binding = "analogLib";
 *)

c561 ( \1:ADC_1p0(2) , GND );
cmodel #(.c(1.315e-14)) (*
integer library_binding = "analogLib";
 *)

c562 ( \2:ADC_1p0(4) , GND );
cmodel #(.c(1.002e-14)) (*
integer library_binding = "analogLib";
 *)

c563 ( \2:ADC_1p0(1) , GND );
cmodel #(.c(5.424e-15)) (*
integer library_binding = "analogLib";
 *)

c564 ( \2:FLASH_1p0(1) , GND );
cmodel #(.c(5.528e-15)) (*
integer library_binding = "analogLib";
 *)

c565 ( \2:ADC_1p0(5) , GND );
cmodel #(.c(8.692e-15)) (*
integer library_binding = "analogLib";
 *)

c566 ( \1:ADC_1p0(5) , GND );
cmodel #(.c(3.438e-15)) (*
integer library_binding = "analogLib";
 *)

c567 ( \2:B100_DIS , GND );
cmodel #(.c(2.522e-15)) (*
integer library_binding = "analogLib";
 *)

c568 ( \1:B100_DIS , GND );
cmodel #(.c(8.425e-15)) (*
integer library_binding = "analogLib";
 *)

c569 ( \2:FLASH_1p0(0) , GND );
cmodel #(.c(8.557e-15)) (*
integer library_binding = "analogLib";
 *)

c570 ( \1:FLASH_1p0(2) , GND );
cmodel #(.c(7.225e-15)) (*
integer library_binding = "analogLib";
 *)

c571 ( \2:ADC_1p0(0) , GND );
cmodel #(.c(8.844e-15)) (*
integer library_binding = "analogLib";
 *)

c572 ( \2:RCLK125_1p0 , GND );
cmodel #(.c(7.679e-15)) (*
integer library_binding = "analogLib";
 *)

c573 ( \2:ADC_1p0(3) , GND );
cmodel #(.c(5.577e-16)) (*
integer library_binding = "analogLib";
 *)

c574 ( \1:TX_AMPTRIM_1p0(1) , GND );
cmodel #(.c(5.776e-16)) (*
integer library_binding = "analogLib";
 *)

c575 ( \1:POS_DETECT_1p0 , GND );
cmodel #(.c(5.781e-16)) (*
integer library_binding = "analogLib";
 *)

c576 ( \1:NEG_DETECT_1p0 , GND );
cmodel #(.c(6.107e-15)) (*
integer library_binding = "analogLib";
 *)

c577 ( \1:I_RPOLY_100(5) , GND );
cmodel #(.c(5.706e-15)) (*
integer library_binding = "analogLib";
 *)

c578 ( \1:I_RPOLY_100(4) , GND );
cmodel #(.c(6.019e-15)) (*
integer library_binding = "analogLib";
 *)

c579 ( \1:I_RPOLY_100(2) , GND );
cmodel #(.c(2.391e-15)) (*
integer library_binding = "analogLib";
 *)

c580 ( \1:I_RPOLY_100(0) , GND );
cmodel #(.c(2.616e-15)) (*
integer library_binding = "analogLib";
 *)

c581 ( \1:I_REXT_100(6) , GND );
cmodel #(.c(3.262e-15)) (*
integer library_binding = "analogLib";
 *)

c582 ( \1:I_REXT_100(5) , GND );
cmodel #(.c(3.243e-15)) (*
integer library_binding = "analogLib";
 *)

c583 ( \1:I_REXT_100(4) , GND );
cmodel #(.c(4.733e-15)) (*
integer library_binding = "analogLib";
 *)

c584 ( \1:I_REXT_100(2) , GND );
cmodel #(.c(5.419e-15)) (*
integer library_binding = "analogLib";
 *)

c585 ( \1:I_REXT_100(1) , GND );
cmodel #(.c(3.817e-15)) (*
integer library_binding = "analogLib";
 *)

c586 ( \1:I_REXT_100(0) , GND );
cmodel #(.c(6.647e-15)) (*
integer library_binding = "analogLib";
 *)

c587 ( \3:ADC_1p0(2) , GND );
cmodel #(.c(1.446e-14)) (*
integer library_binding = "analogLib";
 *)

c588 ( \6:SIDDQ , GND );
cmodel #(.c(2.289e-14)) (*
integer library_binding = "analogLib";
 *)

c589 ( \2:I_RPOLY_100(1) , GND );
cmodel #(.c(2.412e-14)) (*
integer library_binding = "analogLib";
 *)

c590 ( \2:I_REXT_100(1) , GND );
cmodel #(.c(2.178e-14)) (*
integer library_binding = "analogLib";
 *)

c591 ( \3:I_REXT_100(0) , GND );
cmodel #(.c(2.083e-14)) (*
integer library_binding = "analogLib";
 *)

c592 ( \2:I_REXT_100(0) , GND );
cmodel #(.c(2.216e-14)) (*
integer library_binding = "analogLib";
 *)

c593 ( \3:I_REXT_100(6) , GND );
cmodel #(.c(1.93e-14)) (*
integer library_binding = "analogLib";
 *)

c594 ( \3:I_REXT_100(5) , GND );
cmodel #(.c(1.179e-14)) (*
integer library_binding = "analogLib";
 *)

c595 ( \2:I_REXT_REF100 , GND );
cmodel #(.c(1.989e-14)) (*
integer library_binding = "analogLib";
 *)

c596 ( \3:I_RPOLY_100(5) , GND );
cmodel #(.c(1.619e-14)) (*
integer library_binding = "analogLib";
 *)

c597 ( \2:I_RPOLY_100(5) , GND );
cmodel #(.c(2.489e-14)) (*
integer library_binding = "analogLib";
 *)

c598 ( \3:I_RPOLY_100(4) , GND );
cmodel #(.c(2.258e-14)) (*
integer library_binding = "analogLib";
 *)

c599 ( \2:I_RPOLY_100(4) , GND );
cmodel #(.c(2.196e-14)) (*
integer library_binding = "analogLib";
 *)

c600 ( \3:I_RPOLY_100(0) , GND );
cmodel #(.c(1.633e-14)) (*
integer library_binding = "analogLib";
 *)

c601 ( \3:I_REXT_100(2) , GND );
cmodel #(.c(1.465e-14)) (*
integer library_binding = "analogLib";
 *)

c602 ( \2:I_REXT_100(2) , GND );
cmodel #(.c(1.129e-14)) (*
integer library_binding = "analogLib";
 *)

c603 ( \3:I_REXT_100(4) , GND );
cmodel #(.c(4.708e-14)) (*
integer library_binding = "analogLib";
 *)

c604 ( \3:ADC_1p0(0) , GND );
cmodel #(.c(3.696e-14)) (*
integer library_binding = "analogLib";
 *)

c605 ( \4:ADC_1p0(3) , GND );
cmodel #(.c(2.286e-14)) (*
integer library_binding = "analogLib";
 *)

c606 ( \4:FLASH_1p0(1) , GND );
cmodel #(.c(4.084e-14)) (*
integer library_binding = "analogLib";
 *)

c607 ( \4:ADC_1p0(5) , GND );
cmodel #(.c(1.188e-14)) (*
integer library_binding = "analogLib";
 *)

c608 ( \3:ADC_1p0(5) , GND );
cmodel #(.c(1.514e-15)) (*
integer library_binding = "analogLib";
 *)

c609 ( \4:I_REXT_50(1) , GND );
cmodel #(.c(2.918e-16)) (*
integer library_binding = "analogLib";
 *)

c610 ( \4:I_RPOLY_100(2) , GND );
cmodel #(.c(1.885e-15)) (*
integer library_binding = "analogLib";
 *)

c611 ( \6:I_RPOLY_REF100 , GND );
cmodel #(.c(1.184e-15)) (*
integer library_binding = "analogLib";
 *)

c612 ( \4:I_RPOLY_100(5) , GND );
cmodel #(.c(1.013e-15)) (*
integer library_binding = "analogLib";
 *)

c613 ( \4:I_RPOLY_100(4) , GND );
cmodel #(.c(1.23e-15)) (*
integer library_binding = "analogLib";
 *)

c614 ( \4:I_REXT_REF100 , GND );
cmodel #(.c(1.38e-15)) (*
integer library_binding = "analogLib";
 *)

c615 ( \5:I_REXT_50(0) , GND );
cmodel #(.c(1.602e-15)) (*
integer library_binding = "analogLib";
 *)

c616 ( \5:I_REXT_100_NC , GND );
cmodel #(.c(1.097e-15)) (*
integer library_binding = "analogLib";
 *)

c617 ( \4:I_REXT_100(0) , GND );
cmodel #(.c(6.973e-16)) (*
integer library_binding = "analogLib";
 *)

c618 ( \4:I_REXT_100(2) , GND );
cmodel #(.c(1.107e-15)) (*
integer library_binding = "analogLib";
 *)

c619 ( \4:I_RPOLY_100(1) , GND );
cmodel #(.c(1.216e-15)) (*
integer library_binding = "analogLib";
 *)

c620 ( \7:SIDDQ , GND );
cmodel #(.c(1.454e-15)) (*
integer library_binding = "analogLib";
 *)

c621 ( \7:GNDRX , GND );
cmodel #(.c(5.726e-15)) (*
integer library_binding = "analogLib";
 *)

c622 ( \8:GNDRX , GND );
cmodel #(.c(7.949e-16)) (*
integer library_binding = "analogLib";
 *)

c623 ( \4:VDDRX , GND );
cmodel #(.c(1.327e-14)) (*
integer library_binding = "analogLib";
 *)

c624 ( \5:FLASH_1p0(1) , GND );
cmodel #(.c(3.222e-14)) (*
integer library_binding = "analogLib";
 *)

c625 ( \5:ADC_1p0(5) , GND );
cmodel #(.c(2.699e-14)) (*
integer library_binding = "analogLib";
 *)

c626 ( \5:ADC_1p0(3) , GND );
cmodel #(.c(3.725e-14)) (*
integer library_binding = "analogLib";
 *)

c627 ( \5:ADC_1p0(0) , GND );
cmodel #(.c(2.662e-14)) (*
integer library_binding = "analogLib";
 *)

c628 ( \7:ADC_1p0(3) , GND );
cmodel #(.c(2.232e-14)) (*
integer library_binding = "analogLib";
 *)

c629 ( \7:ADC_1p0(5) , GND );
cmodel #(.c(1.618e-14)) (*
integer library_binding = "analogLib";
 *)

c630 ( \7:FLASH_1p0(1) , GND );
cmodel #(.c(4.854e-15)) (*
integer library_binding = "analogLib";
 *)

c631 ( \2:BASE10_TX_DIS_1p0 , GND );
cmodel #(.c(1.762e-15)) (*
integer library_binding = "analogLib";
 *)

c632 ( \1:BASE10_TX_DIS_1p0 , GND );
cmodel #(.c(1.804e-17)) (*
integer library_binding = "analogLib";
 *)

c633 ( \4:VDDTX , GND );
cmodel #(.c(1.193e-15)) (*
integer library_binding = "analogLib";
 *)

c634 ( \3:VDDTX , GND );
cmodel #(.c(7.63e-15)) (*
integer library_binding = "analogLib";
 *)

c635 ( \3:GNDTX , GND );
cmodel #(.c(3.862e-14)) (*
integer library_binding = "analogLib";
 *)

c636 ( \1:GNDTX , GND );
cmodel #(.c(1.622e-14)) (*
integer library_binding = "analogLib";
 *)

c637 ( \2:X10_DIS_2p5 , GND );
cmodel #(.c(7.244e-15)) (*
integer library_binding = "analogLib";
 *)

c638 ( \5:X10_DIS_2p5 , GND );
cmodel #(.c(1.225e-14)) (*
integer library_binding = "analogLib";
 *)

c639 ( \1:MR_SQUELCH_DISB_2p5 , GND );
cmodel #(.c(9.347e-15)) (*
integer library_binding = "analogLib";
 *)

c640 ( \2:MR_SQUELCH_DISB_2p5 , GND );
cmodel #(.c(1.239e-14)) (*
integer library_binding = "analogLib";
 *)

c641 ( \2:MR_SQUELCH_RANGE_2p5(1) , GND );
cmodel #(.c(1.584e-14)) (*
integer library_binding = "analogLib";
 *)

c642 ( \1:MR_SQUELCH_RANGE_2p5(1) , GND );
cmodel #(.c(1.429e-14)) (*
integer library_binding = "analogLib";
 *)

c643 ( \1:BASEFX_DIS , GND );
cmodel #(.c(1.276e-14)) (*
integer library_binding = "analogLib";
 *)

c644 ( \3:BASEFX_DIS , GND );
cmodel #(.c(1.232e-14)) (*
integer library_binding = "analogLib";
 *)

c645 ( \2:RX10_PRESENT_2p5 , GND );
cmodel #(.c(1.526e-14)) (*
integer library_binding = "analogLib";
 *)

c646 ( \1:RX10_PRESENT_2p5 , GND );
cmodel #(.c(3.555e-15)) (*
integer library_binding = "analogLib";
 *)

c647 ( \3:X10_DIS_2p5 , GND );
cmodel #(.c(1.262e-14)) (*
integer library_binding = "analogLib";
 *)

c648 ( \1:BLW_DIS_2p5 , GND );
cmodel #(.c(1.414e-14)) (*
integer library_binding = "analogLib";
 *)

c649 ( \3:BLW_DIS_2p5 , GND );
cmodel #(.c(1.461e-14)) (*
integer library_binding = "analogLib";
 *)

c650 ( \1:ADC_DIS_2p5 , GND );
cmodel #(.c(1.658e-14)) (*
integer library_binding = "analogLib";
 *)

c651 ( \3:ADC_DIS_2p5 , GND );
cmodel #(.c(1.519e-14)) (*
integer library_binding = "analogLib";
 *)

c652 ( \2:WANDER_CNT(4) , GND );
cmodel #(.c(1.813e-14)) (*
integer library_binding = "analogLib";
 *)

c653 ( \3:WANDER_CNT(4) , GND );
cmodel #(.c(1.516e-14)) (*
integer library_binding = "analogLib";
 *)

c654 ( \2:WANDER_CNT(5) , GND );
cmodel #(.c(1.661e-14)) (*
integer library_binding = "analogLib";
 *)

c655 ( \3:WANDER_CNT(5) , GND );
cmodel #(.c(8.124e-15)) (*
integer library_binding = "analogLib";
 *)

c656 ( \2:ADC_TEST_2p5 , GND );
cmodel #(.c(9.443e-15)) (*
integer library_binding = "analogLib";
 *)

c657 ( \4:ADC_TEST_2p5 , GND );
cmodel #(.c(3.093e-15)) (*
integer library_binding = "analogLib";
 *)

c658 ( \2:TXER , GND );
cmodel #(.c(2.978e-15)) (*
integer library_binding = "analogLib";
 *)

c659 ( \1:TXER , GND );
cmodel #(.c(2.53e-15)) (*
integer library_binding = "analogLib";
 *)

c660 ( \2:B10_DIS , GND );
cmodel #(.c(1.907e-15)) (*
integer library_binding = "analogLib";
 *)

c661 ( \1:B10_DIS , GND );
cmodel #(.c(2.596e-15)) (*
integer library_binding = "analogLib";
 *)

c662 ( \2:RESETN , GND );
cmodel #(.c(2.461e-15)) (*
integer library_binding = "analogLib";
 *)

c663 ( \1:RESETN , GND );
cmodel #(.c(2.777e-14)) (*
integer library_binding = "analogLib";
 *)

c664 ( \3:I_REXT_100_NC , GND );
cmodel #(.c(1.568e-14)) (*
integer library_binding = "analogLib";
 *)

c665 ( \4:I_REXT_100_NC , GND );
cmodel #(.c(6.743e-14)) (*
integer library_binding = "analogLib";
 *)

c666 ( \5:I_RPOLY_REF100 , GND );
cmodel #(.c(1.571e-14)) (*
integer library_binding = "analogLib";
 *)

c667 ( \4:I_RPOLY_REF100 , GND );
cmodel #(.c(3.25e-14)) (*
integer library_binding = "analogLib";
 *)

c668 ( \2:I_REXT_50(1) , GND );
cmodel #(.c(1.68e-14)) (*
integer library_binding = "analogLib";
 *)

c669 ( \3:I_REXT_50(1) , GND );
cmodel #(.c(3.705e-14)) (*
integer library_binding = "analogLib";
 *)

c670 ( \3:I_REXT_50(0) , GND );
cmodel #(.c(1.613e-14)) (*
integer library_binding = "analogLib";
 *)

c671 ( \4:I_REXT_50(0) , GND );
cmodel #(.c(9.715e-15)) (*
integer library_binding = "analogLib";
 *)

c672 ( \2:I_RPOLY_100(2) , GND );
cmodel #(.c(7.951e-15)) (*
integer library_binding = "analogLib";
 *)

c673 ( \3:I_RPOLY_100(2) , GND );
cmodel #(.c(1.718e-14)) (*
integer library_binding = "analogLib";
 *)

c674 ( \1:GNDRX , GND );
cmodel #(.c(1.775e-16)) (*
integer library_binding = "analogLib";
 *)

c675 ( \4:GNDRX , GND );
cmodel #(.c(1.68e-15)) (*
integer library_binding = "analogLib";
 *)

c676 ( \3:GNDRX , GND );
cmodel #(.c(6.8e-15)) (*
integer library_binding = "analogLib";
 *)

c677 ( \1:VDDRX , GND );
cmodel #(.c(4.594e-15)) (*
integer library_binding = "analogLib";
 *)

c678 ( \3:VDDRX , GND );
cmodel #(.c(4.445e-16)) (*
integer library_binding = "analogLib";
 *)

c679 ( \1:PHASE_IN(10) , GND );
cmodel #(.c(5.473e-16)) (*
integer library_binding = "analogLib";
 *)

c680 ( \1:PHASE_IN(9) , GND );
cmodel #(.c(5.078e-16)) (*
integer library_binding = "analogLib";
 *)

c681 ( \1:PHASE_IN(8) , GND );
cmodel #(.c(4.757e-16)) (*
integer library_binding = "analogLib";
 *)

c682 ( \1:PHASE_IN(7) , GND );
cmodel #(.c(5.776e-16)) (*
integer library_binding = "analogLib";
 *)

c683 ( \1:PHASE_IN(6) , GND );
cmodel #(.c(5.24e-16)) (*
integer library_binding = "analogLib";
 *)

c684 ( \1:PHASE_IN(5) , GND );
cmodel #(.c(2.333e-16)) (*
integer library_binding = "analogLib";
 *)

c685 ( \1:PHASE_IN(2) , GND );
cmodel #(.c(3.12e-14)) (*
integer library_binding = "analogLib";
 *)

c686 ( \1:PHASE_IN(4) , GND );
cmodel #(.c(7.925e-14)) (*
integer library_binding = "analogLib";
 *)

c687 ( \1:I_REXT_REF100 , GND );
cmodel #(.c(3.112e-14)) (*
integer library_binding = "analogLib";
 *)

c688 ( \1:PHASE_IN(3) , GND );
cmodel #(.c(3.155e-14)) (*
integer library_binding = "analogLib";
 *)

c689 ( \1:PHASE_IN(1) , GND );
cmodel #(.c(3.09e-14)) (*
integer library_binding = "analogLib";
 *)

c690 ( \3:PHASE_IN(2) , GND );
cmodel #(.c(2.934e-15)) (*
integer library_binding = "analogLib";
 *)

c691 ( \2:PHASE_IN(2) , GND );
cmodel #(.c(3.108e-14)) (*
integer library_binding = "analogLib";
 *)

c692 ( \3:PHASE_IN(10) , GND );
cmodel #(.c(3.189e-15)) (*
integer library_binding = "analogLib";
 *)

c693 ( \2:PHASE_IN(10) , GND );
cmodel #(.c(3.263e-14)) (*
integer library_binding = "analogLib";
 *)

c694 ( \3:PHASE_IN(7) , GND );
cmodel #(.c(4.689e-15)) (*
integer library_binding = "analogLib";
 *)

c695 ( \2:PHASE_IN(7) , GND );
cmodel #(.c(3.453e-14)) (*
integer library_binding = "analogLib";
 *)

c696 ( \3:PHASE_IN(0) , GND );
cmodel #(.c(3.434e-14)) (*
integer library_binding = "analogLib";
 *)

c697 ( \3:PHASE_IN(8) , GND );
cmodel #(.c(6.438e-15)) (*
integer library_binding = "analogLib";
 *)

c698 ( \2:PHASE_IN(8) , GND );
cmodel #(.c(5.685e-15)) (*
integer library_binding = "analogLib";
 *)

c699 ( \2:PHASE_IN(5) , GND );
cmodel #(.c(3.358e-14)) (*
integer library_binding = "analogLib";
 *)

c700 ( \3:PHASE_IN(5) , GND );
cmodel #(.c(3.184e-14)) (*
integer library_binding = "analogLib";
 *)

c701 ( \3:PHASE_IN(9) , GND );
cmodel #(.c(4.015e-15)) (*
integer library_binding = "analogLib";
 *)

c702 ( \2:PHASE_IN(9) , GND );
cmodel #(.c(3.184e-14)) (*
integer library_binding = "analogLib";
 *)

c703 ( \3:PHASE_IN(6) , GND );
cmodel #(.c(3.533e-15)) (*
integer library_binding = "analogLib";
 *)

c704 ( \2:PHASE_IN(6) , GND );
cmodel #(.c(5.154e-14)) (*
integer library_binding = "analogLib";
 *)

c705 ( \3:I_REXT_400_TX , GND );
cmodel #(.c(9.491e-16)) (*
integer library_binding = "analogLib";
 *)

c706 ( \1:TENBT_FILTER_1p0(4) , GND );
cmodel #(.c(8.443e-16)) (*
integer library_binding = "analogLib";
 *)

c707 ( \1:TENBT_FILTER_1p0(1) , GND );
cmodel #(.c(3.987e-15)) (*
integer library_binding = "analogLib";
 *)

c708 ( \2:TENBT_FILTER_1p0(4) , GND );
cmodel #(.c(8.211e-16)) (*
integer library_binding = "analogLib";
 *)

c709 ( \1:TENBT_FILTER_1p0(0) , GND );
cmodel #(.c(4.622e-15)) (*
integer library_binding = "analogLib";
 *)

c710 ( \2:TENBT_FILTER_1p0(1) , GND );
cmodel #(.c(4.677e-15)) (*
integer library_binding = "analogLib";
 *)

c711 ( \2:TENBT_FILTER_1p0(0) , GND );
cmodel #(.c(1.571e-14)) (*
integer library_binding = "analogLib";
 *)

c712 ( \1:MLT3_TDATA_2p5(0) , GND );
cmodel #(.c(9.333e-15)) (*
integer library_binding = "analogLib";
 *)

c713 ( \1:MLT3_TDATA_2p5(1) , GND );
cmodel #(.c(1.213e-14)) (*
integer library_binding = "analogLib";
 *)

c714 ( \1:TP_DISC_2p5 , GND );
cmodel #(.c(3.151e-14)) (*
integer library_binding = "analogLib";
 *)

c715 ( \4:I_REXT_400_TX , GND );
cmodel #(.c(8.786e-15)) (*
integer library_binding = "analogLib";
 *)

c716 ( \2:AEQ_DIS_2p5 , GND );
cmodel #(.c(1.07e-14)) (*
integer library_binding = "analogLib";
 *)

c717 ( \1:AEQ_DIS_2p5 , GND );
cmodel #(.c(1.306e-14)) (*
integer library_binding = "analogLib";
 *)

c718 ( \2:WANDER_CNT(3) , GND );
cmodel #(.c(6.227e-15)) (*
integer library_binding = "analogLib";
 *)

c719 ( \3:TX100_DIS_2p5 , GND );
cmodel #(.c(1.582e-14)) (*
integer library_binding = "analogLib";
 *)

c720 ( \2:WANDER_CNT(6) , GND );
cmodel #(.c(1.664e-14)) (*
integer library_binding = "analogLib";
 *)

c721 ( \2:AEQ_CNT_ANLG(0) , GND );
cmodel #(.c(4.889e-16)) (*
integer library_binding = "analogLib";
 *)

c722 ( \3:AEQ_DIS_2p5 , GND );
cmodel #(.c(2.659e-16)) (*
integer library_binding = "analogLib";
 *)

c723 ( \3:AEQ_CNT_ANLG(0) , GND );
cmodel #(.c(1.493e-14)) (*
integer library_binding = "analogLib";
 *)

c724 ( \2:MR_BYPASS10RX_FILTER , GND );
cmodel #(.c(8.052e-16)) (*
integer library_binding = "analogLib";
 *)

c725 ( \5:BASEFX_DIS , GND );
cmodel #(.c(3.276e-15)) (*
integer library_binding = "analogLib";
 *)

c726 ( \1:RCLK125_TST , GND );
cmodel #(.c(3.671e-15)) (*
integer library_binding = "analogLib";
 *)

c727 ( \1:PHASE_250(10) , GND );
cmodel #(.c(4.083e-15)) (*
integer library_binding = "analogLib";
 *)

c728 ( \1:PHASE_250(9) , GND );
cmodel #(.c(3.908e-15)) (*
integer library_binding = "analogLib";
 *)

c729 ( \1:PHASE_250(8) , GND );
cmodel #(.c(2.88e-14)) (*
integer library_binding = "analogLib";
 *)

c730 ( \4:PHASE_IN(0) , GND );
cmodel #(.c(2.857e-14)) (*
integer library_binding = "analogLib";
 *)

c731 ( \2:PHASE_IN(1) , GND );
cmodel #(.c(4.054e-15)) (*
integer library_binding = "analogLib";
 *)

c732 ( \1:PHASE_250(4) , GND );
cmodel #(.c(3.815e-15)) (*
integer library_binding = "analogLib";
 *)

c733 ( \1:PHASE_250(3) , GND );
cmodel #(.c(1.275e-14)) (*
integer library_binding = "analogLib";
 *)

c734 ( \2:MLT3_TDATA_2p5(0) , GND );
cmodel #(.c(4.413e-15)) (*
integer library_binding = "analogLib";
 *)

c735 ( \1:PHASE_250(2) , GND );
cmodel #(.c(8.56e-15)) (*
integer library_binding = "analogLib";
 *)

c736 ( \2:MLT3_TDATA_2p5(1) , GND );
cmodel #(.c(1.141e-14)) (*
integer library_binding = "analogLib";
 *)

c737 ( \2:TP_DISC_2p5 , GND );
cmodel #(.c(2.192e-15)) (*
integer library_binding = "analogLib";
 *)

c738 ( \4:AEQ_DIS_2p5 , GND );
cmodel #(.c(1.958e-15)) (*
integer library_binding = "analogLib";
 *)

c739 ( \2:RCLK125_TST , GND );
cmodel #(.c(2.004e-15)) (*
integer library_binding = "analogLib";
 *)

c740 ( \2:PHASE_250(10) , GND );
cmodel #(.c(2.38e-15)) (*
integer library_binding = "analogLib";
 *)

c741 ( \2:PHASE_250(9) , GND );
cmodel #(.c(1.888e-15)) (*
integer library_binding = "analogLib";
 *)

c742 ( \2:PHASE_250(8) , GND );
cmodel #(.c(2.137e-15)) (*
integer library_binding = "analogLib";
 *)

c743 ( \2:PHASE_250(4) , GND );
cmodel #(.c(1.883e-15)) (*
integer library_binding = "analogLib";
 *)

c744 ( \2:PHASE_250(3) , GND );
cmodel #(.c(2.133e-15)) (*
integer library_binding = "analogLib";
 *)

c745 ( \2:PHASE_250(2) , GND );
cmodel #(.c(4.431e-15)) (*
integer library_binding = "analogLib";
 *)

c746 ( \6:TX100_DIS_2p5 , GND );
cmodel #(.c(2.034e-14)) (*
integer library_binding = "analogLib";
 *)

c747 ( \1:ADC_1p0(4) , GND );
cmodel #(.c(1.622e-14)) (*
integer library_binding = "analogLib";
 *)

c748 ( \1:ADC_1p0(1) , GND );
cmodel #(.c(1.248e-14)) (*
integer library_binding = "analogLib";
 *)

c749 ( \1:FLASH_1p0(1) , GND );
cmodel #(.c(1.714e-14)) (*
integer library_binding = "analogLib";
 *)

c750 ( \1:FLASH_1p0(0) , GND );
cmodel #(.c(1.654e-14)) (*
integer library_binding = "analogLib";
 *)

c751 ( \2:FLASH_1p0(2) , GND );
cmodel #(.c(1.435e-14)) (*
integer library_binding = "analogLib";
 *)

c752 ( \1:ADC_1p0(0) , GND );
cmodel #(.c(1.657e-14)) (*
integer library_binding = "analogLib";
 *)

c753 ( \1:RCLK125_1p0 , GND );
cmodel #(.c(1.607e-14)) (*
integer library_binding = "analogLib";
 *)

c754 ( \1:ADC_1p0(3) , GND );
cmodel #(.c(4.608e-15)) (*
integer library_binding = "analogLib";
 *)

c755 ( \1:I_RPOLY_100(3) , GND );
cmodel #(.c(3.844e-15)) (*
integer library_binding = "analogLib";
 *)

c756 ( \1:I_RPOLY_100(1) , GND );
cmodel #(.c(4.34e-15)) (*
integer library_binding = "analogLib";
 *)

c757 ( \1:I_REXT_100(3) , GND );
cmodel #(.c(1.768e-15)) (*
integer library_binding = "analogLib";
 *)

c758 ( \1:SLICER_OUT_2p5 , GND );
cmodel #(.c(1.789e-15)) (*
integer library_binding = "analogLib";
 *)

c759 ( \1:POS_DETECT_2p5 , GND );
cmodel #(.c(1.7e-15)) (*
integer library_binding = "analogLib";
 *)

c760 ( \1:NEG_DETECT_2p5 , GND );
cmodel #(.c(3.076e-14)) (*
integer library_binding = "analogLib";
 *)

c761 ( \4:ADC_1p0(4) , GND );
cmodel #(.c(1.223e-14)) (*
integer library_binding = "analogLib";
 *)

c762 ( \3:ADC_1p0(4) , GND );
cmodel #(.c(3.075e-14)) (*
integer library_binding = "analogLib";
 *)

c763 ( \4:ADC_1p0(2) , GND );
cmodel #(.c(3.705e-14)) (*
integer library_binding = "analogLib";
 *)

c764 ( \4:ADC_1p0(1) , GND );
cmodel #(.c(1.117e-14)) (*
integer library_binding = "analogLib";
 *)

c765 ( \3:ADC_1p0(1) , GND );
cmodel #(.c(1.356e-14)) (*
integer library_binding = "analogLib";
 *)

c766 ( \5:SIDDQ , GND );
cmodel #(.c(2.237e-14)) (*
integer library_binding = "analogLib";
 *)

c767 ( \3:I_RPOLY_100(1) , GND );
cmodel #(.c(2.261e-14)) (*
integer library_binding = "analogLib";
 *)

c768 ( \3:I_REXT_100(1) , GND );
cmodel #(.c(2.245e-14)) (*
integer library_binding = "analogLib";
 *)

c769 ( \2:I_REXT_100(6) , GND );
cmodel #(.c(1.88e-14)) (*
integer library_binding = "analogLib";
 *)

c770 ( \2:I_REXT_100(5) , GND );
cmodel #(.c(5.321e-14)) (*
integer library_binding = "analogLib";
 *)

c771 ( \3:I_REXT_REF100 , GND );
cmodel #(.c(2.35e-14)) (*
integer library_binding = "analogLib";
 *)

c772 ( \3:I_REXT_100(3) , GND );
cmodel #(.c(2.208e-14)) (*
integer library_binding = "analogLib";
 *)

c773 ( \2:I_REXT_100(3) , GND );
cmodel #(.c(2.194e-14)) (*
integer library_binding = "analogLib";
 *)

c774 ( \2:I_RPOLY_100(0) , GND );
cmodel #(.c(1.155e-14)) (*
integer library_binding = "analogLib";
 *)

c775 ( \3:I_RPOLY_100(3) , GND );
cmodel #(.c(1.023e-14)) (*
integer library_binding = "analogLib";
 *)

c776 ( \2:I_RPOLY_100(3) , GND );
cmodel #(.c(1.08e-14)) (*
integer library_binding = "analogLib";
 *)

c777 ( \2:I_REXT_100(4) , GND );
cmodel #(.c(3.88e-14)) (*
integer library_binding = "analogLib";
 *)

c778 ( \4:RCLK125_1p0 , GND );
cmodel #(.c(1.321e-14)) (*
integer library_binding = "analogLib";
 *)

c779 ( \3:RCLK125_1p0 , GND );
cmodel #(.c(3.96e-14)) (*
integer library_binding = "analogLib";
 *)

c780 ( \4:FLASH_1p0(0) , GND );
cmodel #(.c(1.677e-14)) (*
integer library_binding = "analogLib";
 *)

c781 ( \3:FLASH_1p0(0) , GND );
cmodel #(.c(4.28e-14)) (*
integer library_binding = "analogLib";
 *)

c782 ( \4:FLASH_1p0(2) , GND );
cmodel #(.c(1.659e-14)) (*
integer library_binding = "analogLib";
 *)

c783 ( \3:FLASH_1p0(2) , GND );
cmodel #(.c(1.664e-14)) (*
integer library_binding = "analogLib";
 *)

c784 ( \4:ADC_1p0(0) , GND );
cmodel #(.c(1.79e-14)) (*
integer library_binding = "analogLib";
 *)

c785 ( \3:ADC_1p0(3) , GND );
cmodel #(.c(1.548e-14)) (*
integer library_binding = "analogLib";
 *)

c786 ( \3:FLASH_1p0(1) , GND );
cmodel #(.c(1.63e-15)) (*
integer library_binding = "analogLib";
 *)

c787 ( \4:I_REXT_100(6) , GND );
cmodel #(.c(8.546e-16)) (*
integer library_binding = "analogLib";
 *)

c788 ( \4:I_RPOLY_100(3) , GND );
cmodel #(.c(1.647e-15)) (*
integer library_binding = "analogLib";
 *)

c789 ( \4:I_REXT_100(5) , GND );
cmodel #(.c(1.374e-15)) (*
integer library_binding = "analogLib";
 *)

c790 ( \4:I_REXT_100(1) , GND );
cmodel #(.c(1.069e-15)) (*
integer library_binding = "analogLib";
 *)

c791 ( \4:I_REXT_100(3) , GND );
cmodel #(.c(9.505e-16)) (*
integer library_binding = "analogLib";
 *)

c792 ( \4:I_REXT_100(4) , GND );
cmodel #(.c(9.561e-16)) (*
integer library_binding = "analogLib";
 *)

c793 ( \4:I_RPOLY_100(0) , GND );
cmodel #(.c(3.401e-14)) (*
integer library_binding = "analogLib";
 *)

c794 ( \5:FLASH_1p0(2) , GND );
cmodel #(.c(3.103e-14)) (*
integer library_binding = "analogLib";
 *)

c795 ( \5:FLASH_1p0(0) , GND );
cmodel #(.c(2.715e-14)) (*
integer library_binding = "analogLib";
 *)

c796 ( \5:ADC_1p0(4) , GND );
cmodel #(.c(2.678e-14)) (*
integer library_binding = "analogLib";
 *)

c797 ( \5:ADC_1p0(2) , GND );
cmodel #(.c(3.175e-14)) (*
integer library_binding = "analogLib";
 *)

c798 ( \5:ADC_1p0(1) , GND );
cmodel #(.c(3.248e-14)) (*
integer library_binding = "analogLib";
 *)

c799 ( \5:RCLK125_1p0 , GND );
cmodel #(.c(2.19e-14)) (*
integer library_binding = "analogLib";
 *)

c800 ( \6:ADC_1p0(4) , GND );
cmodel #(.c(2.169e-14)) (*
integer library_binding = "analogLib";
 *)

c801 ( \7:ADC_1p0(4) , GND );
cmodel #(.c(2.563e-14)) (*
integer library_binding = "analogLib";
 *)

c802 ( \6:ADC_1p0(3) , GND );
cmodel #(.c(2.189e-14)) (*
integer library_binding = "analogLib";
 *)

c803 ( \6:ADC_1p0(5) , GND );
cmodel #(.c(1.602e-14)) (*
integer library_binding = "analogLib";
 *)

c804 ( \6:FLASH_1p0(1) , GND );
cmodel #(.c(4.963e-16)) (*
integer library_binding = "analogLib";
 *)

c805 ( \5:VDDTX , GND );
cmodel #(.c(4.007e-15)) (*
integer library_binding = "analogLib";
 *)

c806 ( \1:TPOP , GND );
cmodel #(.c(4.007e-15)) (*
integer library_binding = "analogLib";
 *)

c807 ( \2:TPOP , GND );

resistor #(.w(1.4e-07), .r(32.2979)) (*
integer library_binding
 = "analogLib";
 *)
rf1 ( \1:BASE10_TX_DIS_1p0 , \2:BASE10_TX_DIS_1p0  );
resistor #(.w(1.892e-05), .r(0.005391)) (*
integer library_binding
 = "analogLib";
 *)
rf2 ( \1:VDDTX , \2:VDDTX  );
resistor #(.w(1.892e-05), .r(0.005391)) (*
integer library_binding
 = "analogLib";
 *)
rf3 ( \2:VDDTX , \3:VDDTX  );
resistor #(.w(1.2e-05), .r(0.06152)) (*
integer library_binding
 = "analogLib";
 *)
rf4 ( \27:VDDTX , \2:VDDTX  );
resistor #(.w(1.892e-05), .r(0.005391)) (*
integer library_binding
 = "analogLib";
 *)
rf5 ( \4:VDDTX , \5:VDDTX  );
resistor #(.w(1.892e-05), .r(0.005391)) (*
integer library_binding
 = "analogLib";
 *)
rf6 ( \5:VDDTX , \6:VDDTX  );
resistor #(.w(1.2e-05), .r(0.017)) (*
integer library_binding
 = "analogLib";
 *)
rf7 ( \2:VDDTX , \5:VDDTX  );
resistor #(.w(1.2e-05), .r(0.1125)) (*
integer library_binding
 = "analogLib";
 *)
rf8 ( VDDTX, \27:VDDTX  );
resistor #(.w(1.2e-05), .r(0.1125)) (*
integer library_binding
 = "analogLib";
 *)
rf9 ( \27:VDDTX , VDDTX );
resistor #(.w(1.2e-05), .r(0.1093)) (*
integer library_binding
 = "analogLib";
 *)
rf10 ( GNDTX, \8:GNDTX  );
resistor #(.w(1.2e-05), .r(0.1093)) (*
integer library_binding
 = "analogLib";
 *)
rf11 ( GNDTX, \8:GNDTX  );
resistor #(.w(1.2e-05), .r(0.1171)) (*
integer library_binding
 = "analogLib";
 *)
rf12 ( GNDTX, \8:GNDTX  );
resistor #(.w(1.2e-05), .r(0.1171)) (*
integer library_binding
 = "analogLib";
 *)
rf13 ( \8:GNDTX , GNDTX );
resistor #(.w(1.2e-05), .r(0.1171)) (*
integer library_binding
 = "analogLib";
 *)
rf14 ( GNDTX, \8:GNDTX  );
resistor #(.w(1.2e-05), .r(0.017)) (*
integer library_binding
 = "analogLib";
 *)
rf16 ( \1:GNDTX , \3:GNDTX  );
resistor #(.w(1.2e-05), .r(0.2748)) (*
integer library_binding
 = "analogLib";
 *)
rf18 ( \3:GNDTX , \8:GNDTX  );
resistor #(.w(1.2e-05), .r(0.1171)) (*
integer library_binding
 = "analogLib";
 *)
rf19 ( GNDTX, \8:GNDTX  );
resistor #(.w(3.735e-05), .r(0.002403)) (*
integer library_binding
 = "analogLib";
 *)
rf20 ( TPOP, \1:TPOP  );
resistor #(.w(3.735e-05), .r(0.002404)) (*
integer library_binding
 = "analogLib";
 *)
rf21 ( \2:TPOP , \3:TPOP  );
resistor #(.w(1.2e-05), .r(0.1267)) (*
integer library_binding
 = "analogLib";
 *)
rf22 ( \1:TPOP , \2:TPOP  );
resistor #(.w(1.2e-05), .r(0.1267)) (*
integer library_binding
 = "analogLib";
 *)
rf23 ( \1:TPON , TPON );
resistor #(.w(1.4e-07), .r(77.695)) (*
integer library_binding
 = "analogLib";
 *)
rf24 ( \1:MR_SQUELCH_DISB_2p5 ,
\2:MR_SQUELCH_DISB_2p5  );
resistor #(.w(1.4e-07), .r(76.8121)) (*
integer library_binding
 = "analogLib";
 *)
rf25 ( \1:MR_SQUELCH_RANGE_2p5(1) ,
\2:MR_SQUELCH_RANGE_2p5(1)  );
resistor #(.w(1.4e-07), .r(95.6129)) (*
integer library_binding
 = "analogLib";
 *)
rf26 ( \3:BASEFX_DIS , \1:BASEFX_DIS  );
resistor #(.w(1.4e-07), .r(78.2971)) (*
integer library_binding
 = "analogLib";
 *)
rf27 ( \1:RX10_PRESENT_2p5 , \2:RX10_PRESENT_2p5  );
resistor #(.w(1.4e-07), .r(77.4416)) (*
integer library_binding
 = "analogLib";
 *)
rf28 ( \3:X10_DIS_2p5 , \2:X10_DIS_2p5  );
resistor #(.w(1.4e-07), .r(11.99)) (*
integer library_binding
 = "analogLib";
 *)
rf29 ( \2:X10_DIS_2p5 , \5:X10_DIS_2p5  );
resistor #(.w(1.4e-07), .r(80.7757)) (*
integer library_binding
 = "analogLib";
 *)
rf30 ( \3:BLW_DIS_2p5 , \1:BLW_DIS_2p5  );
resistor #(.w(1.4e-07), .r(89.4934)) (*
integer library_binding
 = "analogLib";
 *)
rf31 ( \1:ADC_DIS_2p5 , \3:ADC_DIS_2p5  );
resistor #(.w(1.4e-07), .r(146.988)) (*
integer library_binding
 = "analogLib";
 *)
rf32 ( \3:WANDER_CNT(4) , \2:WANDER_CNT(4)  );
resistor #(.w(1.4e-07), .r(149.823)) (*
integer library_binding
 = "analogLib";
 *)
rf33 ( \3:WANDER_CNT(5) , \2:WANDER_CNT(5)  );
resistor #(.w(1.4e-07), .r(79.4471)) (*
integer library_binding
 = "analogLib";
 *)
rf34 ( \4:ADC_TEST_2p5 , \2:ADC_TEST_2p5  );
resistor #(.w(1.4e-07), .r(40.5093)) (*
integer library_binding
 = "analogLib";
 *)
rf35 ( \1:TXER , \2:TXER  );
resistor #(.w(1.4e-07), .r(29.69)) (*
integer library_binding
 = "analogLib";
 *)
rf36 ( \1:B10_DIS , \2:B10_DIS  );
resistor #(.w(1.4e-07), .r(35.4136)) (*
integer library_binding
 = "analogLib";
 *)
rf37 ( \1:RESETN , \2:RESETN  );
resistor #(.w(1.2e-05), .r(0.1315)) (*
integer library_binding
 = "analogLib";
 *)
rf38 ( \17:GNDRX , GNDRX );
resistor #(.w(1.2e-05), .r(0.1315)) (*
integer library_binding
 = "analogLib";
 *)
rf39 ( \17:GNDRX , GNDRX );
resistor #(.w(1.4e-07), .r(115.151)) (*
integer library_binding
 = "analogLib";
 *)
rf40 ( \4:I_REXT_100_NC , \3:I_REXT_100_NC  );
resistor #(.w(1.4e-07), .r(115.148)) (*
integer library_binding
 = "analogLib";
 *)
rf41 ( \4:I_RPOLY_REF100 , \5:I_RPOLY_REF100  );
resistor #(.w(1.4e-07), .r(120.05)) (*
integer library_binding
 = "analogLib";
 *)
rf42 ( \3:I_REXT_50(1) , \2:I_REXT_50(1)  );
resistor #(.w(1.4e-07), .r(114.346)) (*
integer library_binding
 = "analogLib";
 *)
rf43 ( \4:I_REXT_50(0) , \3:I_REXT_50(0)  );
resistor #(.w(1.2e-05), .r(0.1315)) (*
integer library_binding
 = "analogLib";
 *)
rf44 ( \17:GNDRX , GNDRX );
resistor #(.w(1.4e-07), .r(117.436)) (*
integer library_binding
 = "analogLib";
 *)
rf45 ( \3:I_RPOLY_100(2) , \2:I_RPOLY_100(2)  );
resistor #(.w(1.2e-05), .r(0.1315)) (*
integer library_binding
 = "analogLib";
 *)
rf46 ( \17:GNDRX , GNDRX );
resistor #(.w(1.2e-05), .r(0.1315)) (*
integer library_binding
 = "analogLib";
 *)
rf47 ( GNDRX, \17:GNDRX  );
resistor #(.w(2.2155e-05), .r(0.01059)) (*
integer library_binding
 = "analogLib";
 *)
rf48 ( \1:GNDRX , \2:GNDRX  );
resistor #(.w(2.2155e-05), .r(0.01059)) (*
integer library_binding
 = "analogLib";
 *)
rf49 ( \2:GNDRX , \3:GNDRX  );
resistor #(.w(1.2e-05), .r(0.06172)) (*
integer library_binding
 = "analogLib";
 *)
rf50 ( \17:GNDRX , \2:GNDRX  );
resistor #(.w(2.2155e-05), .r(0.01059)) (*
integer library_binding
 = "analogLib";
 *)
rf51 ( \4:GNDRX , \5:GNDRX  );
resistor #(.w(2.2155e-05), .r(0.01059)) (*
integer library_binding
 = "analogLib";
 *)
rf52 ( \5:GNDRX , \6:GNDRX  );
resistor #(.w(1.2e-05), .r(0.017)) (*
integer library_binding
 = "analogLib";
 *)
rf53 ( \2:GNDRX , \5:GNDRX  );
resistor #(.w(1.2e-05), .r(0.1315)) (*
integer library_binding
 = "analogLib";
 *)
rf54 ( \17:GNDRX , GNDRX );
resistor #(.w(3.0295e-05), .r(0.005387)) (*
integer library_binding
 = "analogLib";
 *)
rf55 ( \1:VDDRX , \2:VDDRX  );
resistor #(.w(3.0295e-05), .r(0.005387)) (*
integer library_binding
 = "analogLib";
 *)
rf56 ( \2:VDDRX , \3:VDDRX  );
resistor #(.w(1.2e-05), .r(0.1152)) (*
integer library_binding
 = "analogLib";
 *)
rf57 ( \7:VDDRX , \2:VDDRX  );
resistor #(.w(1.2e-05), .r(0.1315)) (*
integer library_binding
 = "analogLib";
 *)
rf58 ( \7:VDDRX , VDDRX );
resistor #(.w(1.2e-05), .r(0.1315)) (*
integer library_binding
 = "analogLib";
 *)
rf59 ( \7:VDDRX , VDDRX );
resistor #(.w(1.2e-05), .r(0.1315)) (*
integer library_binding
 = "analogLib";
 *)
rf60 ( \7:VDDRX , VDDRX );
resistor #(.w(1.2e-05), .r(0.1315)) (*
integer library_binding
 = "analogLib";
 *)
rf61 ( \7:VDDRX , VDDRX );
resistor #(.w(1e-05), .r(0.1515)) (*
integer library_binding
 = "analogLib";
 *)
rg1 ( \1:GNDA_250 , GNDA_250 );
resistor #(.w(1e-05), .r(0.1355)) (*
integer library_binding
 = "analogLib";
 *)
rg2 ( \1:GNDA_160 , GNDA_160 );
resistor #(.w(1.4e-07), .r(11.0379)) (*
integer library_binding
 = "analogLib";
 *)
rg3 ( \3:XTAL25 , XTAL25 );
resistor #(.w(5e-06), .r(0.2858)) (*
integer library_binding
 = "analogLib";
 *)
rg4 ( \1:RBIAS , RBIAS );
resistor #(.w(5e-06), .r(0.2858)) (*
integer library_binding
 = "analogLib";
 *)
rg5 ( \1:RBIAS_SENSE , RBIAS_SENSE );
resistor #(.w(1.4e-07), .r(10.9307)) (*
integer library_binding
 = "analogLib";
 *)
rg6 ( \1:BGTRIM(3) , \BGTRIM(3)  );
resistor #(.w(1.4e-07), .r(10.9307)) (*
integer library_binding
 = "analogLib";
 *)
rg7 ( \1:BGTRIM(2) , \BGTRIM(2)  );
resistor #(.w(1.4e-07), .r(10.9307)) (*
integer library_binding
 = "analogLib";
 *)
rg8 ( \1:BGTRIM(1) , \BGTRIM(1)  );
resistor #(.w(1.4e-07), .r(10.9307)) (*
integer library_binding
 = "analogLib";
 *)
rg9 ( \1:BGTRIM(0) , \BGTRIM(0)  );
resistor #(.w(1.4e-07), .r(10.9307)) (*
integer library_binding
 = "analogLib";
 *)
rg10 ( \8:SIDDQ , SIDDQ );
resistor #(.w(1.4e-07), .r(10.9307)) (*
integer library_binding
 = "analogLib";
 *)
rg11 ( \1:DISABLE10 , DISABLE10 );
resistor #(.w(1.4e-07), .r(11.1021)) (*
integer library_binding
 = "analogLib";
 *)
rg12 ( \1:DISABLE100 , DISABLE100 );
resistor #(.w(1e-05), .r(0.1623)) (*
integer library_binding
 = "analogLib";
 *)
rg13 ( \1:VDDA_160 , VDDA_160 );
resistor #(.w(1e-05), .r(0.1355)) (*
integer library_binding
 = "analogLib";
 *)
rg14 ( \1:VDDA_250 , VDDA_250 );
resistor #(.w(1.4e-07), .r(1.8364)) (*
integer library_binding
 = "analogLib";
 *)
rg15 ( \3:I_RPOLY_REF100 , \1:I_RPOLY_REF100  );
resistor #(.w(1.4e-07), .r(3.465)) (*
integer library_binding
 = "analogLib";
 *)
rg16 ( \2:PHASE_IN(0) , \1:PHASE_IN(0)  );
resistor #(.w(1.4e-07), .r(0.2188)) (*
integer library_binding
 = "analogLib";
 *)
rg17 ( \5:TENBT_CLK160_1p0 , \1:TENBT_CLK160_1p0  );
resistor #(.w(1.4e-07), .r(1.1732)) (*
integer library_binding
 = "analogLib";
 *)
rg18 ( \2:clkpll_sc , clkpll_sc );
resistor #(.w(1.4e-07), .r(1.6402)) (*
integer library_binding
 = "analogLib";
 *)
rg19 ( \5:BASE10_TX_DIS_1p0 ,
\1:BASE10_TX_DIS_1p0  );
resistor #(.w(1.4e-07), .r(7.745)) (*
integer library_binding
 = "analogLib";
 *)
rg20 ( \2:I_REXT_400_TX , \1:I_REXT_400_TX  );
resistor #(.w(1.5e-07), .r(8.6332)) (*
integer library_binding
 = "analogLib";
 *)
rg21 ( \9:SIDDQ , \1:SIDDQ  );
resistor #(.w(6.72e-06), .r(0.01518)) (*
integer library_binding
 = "analogLib";
 *)
rg22 ( \14:VDDTX , \15:VDDTX  );
resistor #(.w(6.72e-06), .r(0.01518)) (*
integer library_binding
 = "analogLib";
 *)
rg23 ( \15:VDDTX , \16:VDDTX  );
resistor #(.w(6.72e-06), .r(0.01518)) (*
integer library_binding
 = "analogLib";
 *)
rg26 ( \19:VDDTX , \20:VDDTX  );
resistor #(.w(6.72e-06), .r(0.01518)) (*
integer library_binding
 = "analogLib";
 *)
rg27 ( \20:VDDTX , \21:VDDTX  );
resistor #(.w(6.72e-06), .r(0.03036)) (*
integer library_binding
 = "analogLib";
 *)
rg30 ( \15:VDDTX , \20:VDDTX  );
resistor #(.w(3.36e-09), .r(0.014)) (*
integer library_binding
 = "analogLib";
 *)
rg31 ( \3:VDDTX , \16:VDDTX  );
resistor #(.w(3.36e-09), .r(0.014)) (*
integer library_binding
 = "analogLib";
 *)
rg32 ( \1:VDDTX , \14:VDDTX  );
resistor #(.w(3.36e-09), .r(0.014)) (*
integer library_binding
 = "analogLib";
 *)
rg33 ( \13:VDDTX , \16:VDDTX  );
resistor #(.w(3.36e-09), .r(0.014)) (*
integer library_binding
 = "analogLib";
 *)
rg34 ( \11:VDDTX , \19:VDDTX  );
resistor #(.w(3.36e-09), .r(0.014)) (*
integer library_binding
 = "analogLib";
 *)
rg35 ( \6:VDDTX , \21:VDDTX  );
resistor #(.w(3.36e-09), .r(0.014)) (*
integer library_binding
 = "analogLib";
 *)
rg36 ( \4:VDDTX , \19:VDDTX  );
resistor #(.w(3.36e-09), .r(0.014)) (*
integer library_binding
 = "analogLib";
 *)
rg37 ( \11:VDDTX , \21:VDDTX  );
resistor #(.w(1.4e-07), .r(41.0535)) (*
integer library_binding
 = "analogLib";
 *)
rg38 ( \3:BASE10_TX_DIS_1p0 ,
\2:BASE10_TX_DIS_1p0  );
resistor #(.w(1.4e-07), .r(42.9686)) (*
integer library_binding
 = "analogLib";
 *)
rg39 ( \3:TENBT_CLK160_1p0 , \2:TENBT_CLK160_1p0  );
resistor #(.w(1.4e-07), .r(1.5882)) (*
integer library_binding
 = "analogLib";
 *)
rg40 ( \2:TENBT_FILTER_1p0(3) ,
\1:TENBT_FILTER_1p0(3)  );
resistor #(.w(1.4e-07), .r(1.6439)) (*
integer library_binding
 = "analogLib";
 *)
rg41 ( \2:TENBT_FILTER_1p0(2) ,
\1:TENBT_FILTER_1p0(2)  );
resistor #(.w(1e-06), .r(0.03327)) (*
integer library_binding
 = "analogLib";
 *)
rg42 ( \5:I_REXT_400_TX , \7:I_REXT_400_TX  );
resistor #(.w(1e-06), .r(0.08727)) (*
integer library_binding
 = "analogLib";
 *)
rg43 ( \2:I_REXT_100_NC , I_REXT_100_NC );
resistor #(.w(1.4e-07), .r(0.8655)) (*
integer library_binding
 = "analogLib";
 *)
rg44 ( \I_REXT_50(0) , \2:I_REXT_50(0)  );
resistor #(.w(5e-07), .r(1.3917)) (*
integer library_binding
 = "analogLib";
 *)
rg45 ( \9:SIDDQ , \3:SIDDQ  );
resistor #(.w(1.4e-07), .r(88.9596)) (*
integer library_binding
 = "analogLib";
 *)
rg46 ( \2:TX100_DIS_2p5 , \1:TX100_DIS_2p5  );
resistor #(.w(1.4e-07), .r(90.2585)) (*
integer library_binding
 = "analogLib";
 *)
rg47 ( \2:X10_DIS_2p5 , \1:X10_DIS_2p5  );
resistor #(.w(1.4e-07), .r(2.5849)) (*
integer library_binding
 = "analogLib";
 *)
rg48 ( \1:BASEFX_DIS , \2:BASEFX_DIS  );
resistor #(.w(2.6e-07), .r(2.8)) (*
integer library_binding
 = "analogLib";
 *)
rg49 ( \1:BLW_DIS_2p5 , \2:BLW_DIS_2p5  );
resistor #(.w(6e-07), .r(1.05)) (*
integer library_binding
 = "analogLib";
 *)
rg50 ( \3:X10_DIS_2p5 , \4:X10_DIS_2p5  );
resistor #(.w(6e-07), .r(1.05)) (*
integer library_binding
 = "analogLib";
 *)
rg51 ( \1:ADC_DIS_2p5 , \2:ADC_DIS_2p5  );
resistor #(.w(2.6e-07), .r(2.8)) (*
integer library_binding
 = "analogLib";
 *)
rg52 ( \1:WANDER_CNT(4) , \2:WANDER_CNT(4)  );
resistor #(.w(1.4e-07), .r(1.64)) (*
integer library_binding
 = "analogLib";
 *)
rg53 ( \1:WANDER_CNT(1) , \3:WANDER_CNT(1)  );
resistor #(.w(2.6e-07), .r(2.8)) (*
integer library_binding
 = "analogLib";
 *)
rg54 ( \1:WANDER_CNT(5) , \2:WANDER_CNT(5)  );
resistor #(.w(1.4e-07), .r(2.8636)) (*
integer library_binding
 = "analogLib";
 *)
rg55 ( \3:T2_MODE , \2:T2_MODE  );
resistor #(.w(1.4e-07), .r(1.5805)) (*
integer library_binding
 = "analogLib";
 *)
rg56 ( \3:AEQ_CNT_ANLG(3) , \2:AEQ_CNT_ANLG(3)  );
resistor #(.w(1.4e-07), .r(2.1631)) (*
integer library_binding
 = "analogLib";
 *)
rg57 ( \3:MR_SQUELCH_DISB_2p5 ,
\2:MR_SQUELCH_DISB_2p5  );
resistor #(.w(6e-07), .r(0.7)) (*
integer library_binding
 = "analogLib";
 *)
rg58 ( \2:ADC_TEST_2p5 , \1:ADC_TEST_2p5  );
resistor #(.w(1.4e-07), .r(1.3393)) (*
integer library_binding
 = "analogLib";
 *)
rg59 ( \3:MR_SQUELCH_RANGE_2p5(1) ,
\2:MR_SQUELCH_RANGE_2p5(1)  );
resistor #(.w(1.4e-07), .r(1.0029)) (*
integer library_binding
 = "analogLib";
 *)
rg60 ( \3:RX10_PRESENT_2p5 , \2:RX10_PRESENT_2p5  );
resistor #(.w(1.4e-07), .r(2.6266)) (*
integer library_binding
 = "analogLib";
 *)
rg61 ( \5:TX100_DIS_2p5 , \4:TX100_DIS_2p5  );
resistor #(.w(1.4e-07), .r(0.913)) (*
integer library_binding
 = "analogLib";
 *)
rg62 ( \3:AEQ_CNT_ANLG(4) , \2:AEQ_CNT_ANLG(4)  );
resistor #(.w(1.4e-07), .r(3.0693)) (*
integer library_binding
 = "analogLib";
 *)
rg63 ( \4:BASEFX_DIS , \3:BASEFX_DIS  );
resistor #(.w(1.4e-07), .r(2.6593)) (*
integer library_binding
 = "analogLib";
 *)
rg64 ( \4:AEQ_CNT_ANLG(0) , \1:AEQ_CNT_ANLG(0)  );
resistor #(.w(1.4e-07), .r(2.6464)) (*
integer library_binding
 = "analogLib";
 *)
rg65 ( \2:AEQ_CNT_ANLG(2) , \1:AEQ_CNT_ANLG(2)  );
resistor #(.w(1.4e-07), .r(3.8379)) (*
integer library_binding
 = "analogLib";
 *)
rg66 ( \4:AEQ_CNT_ANLG(4) , \1:AEQ_CNT_ANLG(4)  );
resistor #(.w(1.4e-07), .r(4.4721)) (*
integer library_binding
 = "analogLib";
 *)
rg67 ( \2:AEQ_BYPASS , \1:AEQ_BYPASS  );
resistor #(.w(1.4e-07), .r(4.9736)) (*
integer library_binding
 = "analogLib";
 *)
rg68 ( \4:WANDER_CNT(5) , \3:WANDER_CNT(5)  );
resistor #(.w(1.4e-07), .r(8.6721)) (*
integer library_binding
 = "analogLib";
 *)
rg69 ( \3:WANDER_CNT(3) , \1:WANDER_CNT(3)  );
resistor #(.w(1.4e-07), .r(7.7764)) (*
integer library_binding
 = "analogLib";
 *)
rg70 ( \4:WANDER_CNT(1) , \2:WANDER_CNT(1)  );
resistor #(.w(1.4e-07), .r(9.39)) (*
integer library_binding
 = "analogLib";
 *)
rg71 ( \2:WANDER_CNT(0) , \1:WANDER_CNT(0)  );
resistor #(.w(1.4e-07), .r(9.6621)) (*
integer library_binding
 = "analogLib";
 *)
rg72 ( \2:WANDER_CNT(2) , \1:WANDER_CNT(2)  );
resistor #(.w(2e-06), .r(3.705)) (*
integer library_binding
 = "analogLib";
 *)
rg73 ( \9:GNDTX , \5:GNDTX  );
resistor #(.w(7e-06), .r(0.02914)) (*
integer library_binding
 = "analogLib";
 *)
rg75 ( \5:GNDTX , \7:GNDTX  );
resistor #(.w(7e-06), .r(0.014)) (*
integer library_binding
 = "analogLib";
 *)
rg76 ( \7:GNDTX , \3:GNDTX  );
resistor #(.w(2e-06), .r(0.014)) (*
integer library_binding
 = "analogLib";
 *)
rg77 ( \1:GNDTX , \5:GNDTX  );
resistor #(.w(7e-06), .r(0.014)) (*
integer library_binding
 = "analogLib";
 *)
rg78 ( \3:GNDTX , \5:GNDTX  );
resistor #(.w(7e-06), .r(0.014)) (*
integer library_binding
 = "analogLib";
 *)
rg79 ( \1:GNDTX , \7:GNDTX  );
resistor #(.w(2e-06), .r(5.4113)) (*
integer library_binding
 = "analogLib";
 *)
rg80 ( \28:VDDTX , \24:VDDTX  );
resistor #(.w(7e-06), .r(0.02914)) (*
integer library_binding
 = "analogLib";
 *)
rg82 ( \24:VDDTX , \26:VDDTX  );
resistor #(.w(7e-06), .r(0.014)) (*
integer library_binding
 = "analogLib";
 *)
rg83 ( \26:VDDTX , \9:VDDTX  );
resistor #(.w(2e-06), .r(0.014)) (*
integer library_binding
 = "analogLib";
 *)
rg84 ( \7:VDDTX , \24:VDDTX  );
resistor #(.w(7e-06), .r(0.014)) (*
integer library_binding
 = "analogLib";
 *)
rg85 ( \9:VDDTX , \24:VDDTX  );
resistor #(.w(7e-06), .r(0.014)) (*
integer library_binding
 = "analogLib";
 *)
rg86 ( \7:VDDTX , \26:VDDTX  );
resistor #(.w(1.4e-07), .r(263.546)) (*
integer library_binding
 = "analogLib";
 *)
rg87 ( \2:PLL_160_IN , \1:PLL_160_IN  );
resistor #(.w(1.4e-07), .r(9.4864)) (*
integer library_binding
 = "analogLib";
 *)
rg88 ( \4:WANDER_CNT(4) , \3:WANDER_CNT(4)  );
resistor #(.w(1.4e-07), .r(12.1671)) (*
integer library_binding
 = "analogLib";
 *)
rg89 ( \3:WANDER_CNT(6) , \1:WANDER_CNT(6)  );
resistor #(.w(1.4e-07), .r(12.3193)) (*
integer library_binding
 = "analogLib";
 *)
rg90 ( \4:T2_MODE , \1:T2_MODE  );
resistor #(.w(1.4e-07), .r(12.4607)) (*
integer library_binding
 = "analogLib";
 *)
rg91 ( \4:AEQ_CNT_ANLG(3) , \1:AEQ_CNT_ANLG(3)  );
resistor #(.w(1.4e-07), .r(12.7929)) (*
integer library_binding
 = "analogLib";
 *)
rg92 ( \4:ADC_DIS_2p5 , \3:ADC_DIS_2p5  );
resistor #(.w(1.4e-07), .r(12.5679)) (*
integer library_binding
 = "analogLib";
 *)
rg93 ( \2:AEQ_CNT_ANLG(1) , \1:AEQ_CNT_ANLG(1)  );
resistor #(.w(1.4e-07), .r(13.0221)) (*
integer library_binding
 = "analogLib";
 *)
rg94 ( \3:MR_BYPASS10RX_FILTER ,
\1:MR_BYPASS10RX_FILTER  );
resistor #(.w(1.4e-07), .r(14.5543)) (*
integer library_binding
 = "analogLib";
 *)
rg95 ( \4:BLW_DIS_2p5 , \3:BLW_DIS_2p5  );
resistor #(.w(1.4e-07), .r(7.7318)) (*
integer library_binding
 = "analogLib";
 *)
rg96 ( \2:RESET_DSP , \1:RESET_DSP  );
resistor #(.w(1.4e-07), .r(16.0443)) (*
integer library_binding
 = "analogLib";
 *)
rg97 ( \3:ADC_TEST_2p5 , \4:ADC_TEST_2p5  );
resistor #(.w(1.4e-07), .r(9.3129)) (*
integer library_binding
 = "analogLib";
 *)
rg98 ( \2:TIMING_UP_ANLG , \1:TIMING_UP_ANLG  );
resistor #(.w(1.4e-07), .r(16.4657)) (*
integer library_binding
 = "analogLib";
 *)
rg99 ( \4:RX10_PRESENT_2p5 , \1:RX10_PRESENT_2p5  );
resistor #(.w(1.4e-07), .r(10.6071)) (*
integer library_binding
 = "analogLib";
 *)
rg100 ( \2:TIMING_DN_ANLG , \1:TIMING_DN_ANLG  );
resistor #(.w(1.4e-07), .r(17.8436)) (*
integer library_binding
 = "analogLib";
 *)
rg101 ( \4:MR_SQUELCH_DISB_2p5 ,
\1:MR_SQUELCH_DISB_2p5  );
resistor #(.w(1.4e-07), .r(17.1729)) (*
integer library_binding
 = "analogLib";
 *)
rg102 ( \2:MR_SQUELCH_RANGE_2p5(0) ,
\1:MR_SQUELCH_RANGE_2p5(0)  );
resistor #(.w(1.4e-07), .r(19.2879)) (*
integer library_binding
 = "analogLib";
 *)
rg103 ( \4:MR_SQUELCH_RANGE_2p5(1) ,
\1:MR_SQUELCH_RANGE_2p5(1)  );
resistor #(.w(1.4e-07), .r(14.1949)) (*
integer library_binding
 = "analogLib";
 *)
rg104 ( \2:RCLK125_TST_SEL , \1:RCLK125_TST_SEL  );
resistor #(.w(1.4e-07), .r(15.1461)) (*
integer library_binding
 = "analogLib";
 *)
rg105 ( \2:PHASE_250(7) , \1:PHASE_250(7)  );
resistor #(.w(1.4e-07), .r(15.5252)) (*
integer library_binding
 = "analogLib";
 *)
rg106 ( \2:PHASE_250(6) , \1:PHASE_250(6)  );
resistor #(.w(1.4e-07), .r(15.7978)) (*
integer library_binding
 = "analogLib";
 *)
rg107 ( \2:PHASE_250(5) , \1:PHASE_250(5)  );
resistor #(.w(1.4e-07), .r(17.5182)) (*
integer library_binding
 = "analogLib";
 *)
rg108 ( \1:PHASE_250(1) , \2:PHASE_250(1)  );
resistor #(.w(1.4e-07), .r(17.9661)) (*
integer library_binding
 = "analogLib";
 *)
rg109 ( \1:PHASE_250(0) , \2:PHASE_250(0)  );
resistor #(.w(1.4e-07), .r(284.696)) (*
integer library_binding
 = "analogLib";
 *)
rg110 ( \2:XTAL25 , \1:XTAL25  );
resistor #(.w(1.4e-07), .r(34.6929)) (*
integer library_binding
 = "analogLib";
 *)
rg111 ( \6:X10_DIS_2p5 , \5:X10_DIS_2p5  );
resistor #(.w(1.4e-07), .r(40.3307)) (*
integer library_binding
 = "analogLib";
 *)
rg112 ( \4:SIDDQ , \2:SIDDQ  );
resistor #(.w(1.4e-07), .r(0.12)) (*
integer library_binding
 = "analogLib";
 *)
rg113 ( SCAN_MODE, \1:SCAN_MODE  );
resistor #(.w(1.4e-07), .r(0.12)) (*
integer library_binding
 = "analogLib";
 *)
rg114 ( SCANCLK1, \1:SCANCLK1  );
resistor #(.w(1.4e-07), .r(0.12)) (*
integer library_binding
 = "analogLib";
 *)
rg115 ( SCANCLK2, \1:SCANCLK2  );
resistor #(.w(1.4e-07), .r(0.12)) (*
integer library_binding
 = "analogLib";
 *)
rg116 ( SCANCLK3, \1:SCANCLK3  );
resistor #(.w(1.4e-07), .r(0.12)) (*
integer library_binding
 = "analogLib";
 *)
rg117 ( scan_set, \1:scan_set  );
resistor #(.w(1.4e-07), .r(0.12)) (*
integer library_binding
 = "analogLib";
 *)
rg118 ( SCAN_ENABLE, \1:SCAN_ENABLE  );
resistor #(.w(1.4e-07), .r(0.12)) (*
integer library_binding
 = "analogLib";
 *)
rg119 ( scan_reset, \1:scan_reset  );
resistor #(.w(1.4e-07), .r(0.12)) (*
integer library_binding
 = "analogLib";
 *)
rg120 ( MDIO_IN, \1:MDIO_IN  );
resistor #(.w(1.4e-07), .r(0.12)) (*
integer library_binding
 = "analogLib";
 *)
rg121 ( \PHY(4) , \1:PHY(4)  );
resistor #(.w(1.4e-07), .r(0.12)) (*
integer library_binding
 = "analogLib";
 *)
rg122 ( \PHY(3) , \1:PHY(3)  );
resistor #(.w(1.4e-07), .r(0.12)) (*
integer library_binding
 = "analogLib";
 *)
rg123 ( \PHY(2) , \1:PHY(2)  );
resistor #(.w(1.4e-07), .r(0.12)) (*
integer library_binding
 = "analogLib";
 *)
rg124 ( \PHY(1) , \1:PHY(1)  );
resistor #(.w(1.4e-07), .r(0.12)) (*
integer library_binding
 = "analogLib";
 *)
rg125 ( \PHY(0) , \1:PHY(0)  );
resistor #(.w(1.4e-07), .r(0.12)) (*
integer library_binding
 = "analogLib";
 *)
rg126 ( CRS, \1:CRS  );
resistor #(.w(1.4e-07), .r(0.12)) (*
integer library_binding
 = "analogLib";
 *)
rg127 ( MDINT, \1:MDINT  );
resistor #(.w(1.4e-07), .r(0.12)) (*
integer library_binding
 = "analogLib";
 *)
rg128 ( LEDL, \1:LEDL  );
resistor #(.w(1.4e-07), .r(0.12)) (*
integer library_binding
 = "analogLib";
 *)
rg129 ( LEDD, \1:LEDD  );
resistor #(.w(1.4e-07), .r(0.12)) (*
integer library_binding
 = "analogLib";
 *)
rg130 ( SYMBOL_MODE, \1:SYMBOL_MODE  );
resistor #(.w(1.4e-07), .r(0.12)) (*
integer library_binding
 = "analogLib";
 *)
rg131 ( RXDV, \1:RXDV  );
resistor #(.w(1.4e-07), .r(0.12)) (*
integer library_binding
 = "analogLib";
 *)
rg132 ( TRISTATE, \1:TRISTATE  );
resistor #(.w(1.4e-07), .r(0.12)) (*
integer library_binding
 = "analogLib";
 *)
rg133 ( RXC, \1:RXC  );
resistor #(.w(1.4e-07), .r(0.12)) (*
integer library_binding
 = "analogLib";
 *)
rg134 ( LEDT, \1:LEDT  );
resistor #(.w(1.4e-07), .r(0.12)) (*
integer library_binding
 = "analogLib";
 *)
rg135 ( LEDS, \1:LEDS  );
resistor #(.w(1.4e-07), .r(0.12)) (*
integer library_binding
 = "analogLib";
 *)
rg136 ( TXEN, \1:TXEN  );
resistor #(.w(1.4e-07), .r(0.12)) (*
integer library_binding
 = "analogLib";
 *)
rg137 ( COL, \1:COL  );
resistor #(.w(1.4e-07), .r(0.12)) (*
integer library_binding
 = "analogLib";
 *)
rg138 ( LEDC, \1:LEDC  );
resistor #(.w(1.4e-07), .r(0.12)) (*
integer library_binding
 = "analogLib";
 *)
rg139 ( MDIO_OE, \1:MDIO_OE  );
resistor #(.w(1.4e-07), .r(0.12)) (*
integer library_binding
 = "analogLib";
 *)
rg140 ( MDIO_OUT, \1:MDIO_OUT  );
resistor #(.w(1.4e-07), .r(0.12)) (*
integer library_binding
 = "analogLib";
 *)
rg141 ( MDC, \1:MDC  );
resistor #(.w(1.4e-07), .r(0.12)) (*
integer library_binding
 = "analogLib";
 *)
rg142 ( \TX_AMP_TRIM(1) , \1:TX_AMP_TRIM(1)  );
resistor #(.w(1.4e-07), .r(0.12)) (*
integer library_binding
 = "analogLib";
 *)
rg143 ( \TX_AMP_TRIM(0) , \1:TX_AMP_TRIM(0)  );
resistor #(.w(1.4e-07), .r(0.12)) (*
integer library_binding
 = "analogLib";
 *)
rg144 ( \TXD(4) , \1:TXD(4)  );
resistor #(.w(1.4e-07), .r(0.12)) (*
integer library_binding
 = "analogLib";
 *)
rg145 ( \TXD(3) , \1:TXD(3)  );
resistor #(.w(1.4e-07), .r(0.12)) (*
integer library_binding
 = "analogLib";
 *)
rg146 ( \TXD(2) , \1:TXD(2)  );
resistor #(.w(1.4e-07), .r(0.12)) (*
integer library_binding
 = "analogLib";
 *)
rg147 ( \TXD(1) , \1:TXD(1)  );
resistor #(.w(1.4e-07), .r(0.12)) (*
integer library_binding
 = "analogLib";
 *)
rg148 ( \TXD(0) , \1:TXD(0)  );
resistor #(.w(1.4e-07), .r(0.12)) (*
integer library_binding
 = "analogLib";
 *)
rg149 ( LEDR, \1:LEDR  );
resistor #(.w(1.4e-07), .r(0.12)) (*
integer library_binding
 = "analogLib";
 *)
rg150 ( ANLG_TST, \1:ANLG_TST  );
resistor #(.w(1.4e-07), .r(0.12)) (*
integer library_binding
 = "analogLib";
 *)
rg151 ( ANDIS, \1:ANDIS  );
resistor #(.w(1.4e-07), .r(0.12)) (*
integer library_binding
 = "analogLib";
 *)
rg152 ( \RXD(4) , \1:RXD(4)  );
resistor #(.w(1.4e-07), .r(0.12)) (*
integer library_binding
 = "analogLib";
 *)
rg153 ( \RXD(3) , \1:RXD(3)  );
resistor #(.w(1.4e-07), .r(0.12)) (*
integer library_binding
 = "analogLib";
 *)
rg154 ( \RXD(2) , \1:RXD(2)  );
resistor #(.w(1.4e-07), .r(0.12)) (*
integer library_binding
 = "analogLib";
 *)
rg155 ( \RXD(1) , \1:RXD(1)  );
resistor #(.w(1.4e-07), .r(0.12)) (*
integer library_binding
 = "analogLib";
 *)
rg156 ( \RXD(0) , \1:RXD(0)  );
resistor #(.w(1.4e-07), .r(0.12)) (*
integer library_binding
 = "analogLib";
 *)
rg157 ( RXER, \1:RXER  );
resistor #(.w(1.4e-07), .r(0.12)) (*
integer library_binding
 = "analogLib";
 *)
rg158 ( \TX_SLP_TRIM(1) , \1:TX_SLP_TRIM(1)  );
resistor #(.w(1.4e-07), .r(0.12)) (*
integer library_binding
 = "analogLib";
 *)
rg159 ( TXC, \1:TXC  );
resistor #(.w(1.4e-07), .r(1.52)) (*
integer library_binding
 = "analogLib";
 *)
rg160 ( \TX_SLP_TRIM(0) , \1:TX_SLP_TRIM(0)  );
resistor #(.w(1.4e-07), .r(0.5719)) (*
integer library_binding
 = "analogLib";
 *)
rg161 ( \7:ADC_1p0(2) , \2:ADC_1p0(2)  );
resistor #(.w(1.4e-07), .r(0.7434)) (*
integer library_binding
 = "analogLib";
 *)
rg162 ( \9:ADC_1p0(4) , \2:ADC_1p0(4)  );
resistor #(.w(1.4e-07), .r(0.8891)) (*
integer library_binding
 = "analogLib";
 *)
rg163 ( \7:ADC_1p0(1) , \2:ADC_1p0(1)  );
resistor #(.w(1.4e-07), .r(3.4755)) (*
integer library_binding
 = "analogLib";
 *)
rg164 ( \9:FLASH_1p0(1) , \2:FLASH_1p0(1)  );
resistor #(.w(1.4e-07), .r(4.3434)) (*
integer library_binding
 = "analogLib";
 *)
rg165 ( \9:ADC_1p0(5) , \2:ADC_1p0(5)  );
resistor #(.w(1.4e-07), .r(1.52)) (*
integer library_binding
 = "analogLib";
 *)
rg166 ( B100_DIS, \1:B100_DIS  );
resistor #(.w(1.4e-07), .r(1.52)) (*
integer library_binding
 = "analogLib";
 *)
rg167 ( TXER, \1:TXER  );
resistor #(.w(1.4e-07), .r(5.1019)) (*
integer library_binding
 = "analogLib";
 *)
rg168 ( \7:FLASH_1p0(0) , \2:FLASH_1p0(0)  );
resistor #(.w(1.4e-07), .r(6.7162)) (*
integer library_binding
 = "analogLib";
 *)
rg169 ( \7:FLASH_1p0(2) , \1:FLASH_1p0(2)  );
resistor #(.w(1.4e-07), .r(1.52)) (*
integer library_binding
 = "analogLib";
 *)
rg170 ( B10_DIS, \1:B10_DIS  );
resistor #(.w(1.4e-07), .r(1.52)) (*
integer library_binding
 = "analogLib";
 *)
rg171 ( RESETN, \1:RESETN  );
resistor #(.w(1.4e-07), .r(5.9976)) (*
integer library_binding
 = "analogLib";
 *)
rg172 ( \7:ADC_1p0(0) , \2:ADC_1p0(0)  );
resistor #(.w(1.4e-07), .r(6.2891)) (*
integer library_binding
 = "analogLib";
 *)
rg173 ( \7:RCLK125_1p0 , \2:RCLK125_1p0  );
resistor #(.w(1.4e-07), .r(6.5291)) (*
integer library_binding
 = "analogLib";
 *)
rg174 ( \10:ADC_1p0(3) , \2:ADC_1p0(3)  );
resistor #(.w(1.4e-07), .r(8.3148)) (*
integer library_binding
 = "analogLib";
 *)
rg175 ( \TX_AMPTRIM_1p0(1) , \1:TX_AMPTRIM_1p0(1)  );
resistor #(.w(1.4e-07), .r(8.4991)) (*
integer library_binding
 = "analogLib";
 *)
rg176 ( NEG_DETECT_1p0, \1:NEG_DETECT_1p0  );
resistor #(.w(1.4e-07), .r(8.4991)) (*
integer library_binding
 = "analogLib";
 *)
rg177 ( POS_DETECT_1p0, \1:POS_DETECT_1p0  );
resistor #(.w(1.4e-07), .r(7.2707)) (*
integer library_binding
 = "analogLib";
 *)
rg178 ( \2:SLICER_OUT_1p0 , SLICER_OUT_1p0 );
resistor #(.w(1.4e-07), .r(7.2707)) (*
integer library_binding
 = "analogLib";
 *)
rg179 ( \2:XTAL25_1p0 , XTAL25_1p0 );
resistor #(.w(1.4e-07), .r(7.2707)) (*
integer library_binding
 = "analogLib";
 *)
rg180 ( \2:X_125 , X_125 );
resistor #(.w(1.4e-07), .r(7.2707)) (*
integer library_binding
 = "analogLib";
 *)
rg181 ( \2:X_160 , X_160 );
resistor #(.w(1.4e-07), .r(7.2707)) (*
integer library_binding
 = "analogLib";
 *)
rg182 ( \2:MLT3_TDATA_1p0(0) , \MLT3_TDATA_1p0(0)  );
resistor #(.w(1.4e-07), .r(7.2707)) (*
integer library_binding
 = "analogLib";
 *)
rg183 ( \2:MLT3_TDATA_1p0(1) , \MLT3_TDATA_1p0(1)  );
resistor #(.w(1.4e-07), .r(7.2707)) (*
integer library_binding
 = "analogLib";
 *)
rg184 ( \2:MR_SQUELCH_DISB_1p0 ,
MR_SQUELCH_DISB_1p0 );
resistor #(.w(1.4e-07), .r(7.2707)) (*
integer library_binding
 = "analogLib";
 *)
rg185 ( \2:MR_SQUELCH_RANGE_1p0(0) ,
\MR_SQUELCH_RANGE_1p0(0)  );
resistor #(.w(1.4e-07), .r(7.2707)) (*
integer library_binding
 = "analogLib";
 *)
rg186 ( \2:MR_SQUELCH_RANGE_1p0(1) ,
\MR_SQUELCH_RANGE_1p0(1)  );
resistor #(.w(1.4e-07), .r(7.2707)) (*
integer library_binding
 = "analogLib";
 *)
rg187 ( \2:RX10_PRESENT_1p0 , RX10_PRESENT_1p0 );
resistor #(.w(1.4e-07), .r(7.2707)) (*
integer library_binding
 = "analogLib";
 *)
rg188 ( \2:TEST_MODE(0) , \TEST_MODE(0)  );
resistor #(.w(1.4e-07), .r(7.2707)) (*
integer library_binding
 = "analogLib";
 *)
rg189 ( \2:TEST_MODE(1) , \TEST_MODE(1)  );
resistor #(.w(1.4e-07), .r(7.2707)) (*
integer library_binding
 = "analogLib";
 *)
rg190 ( \2:TEST_MODE(2) , \TEST_MODE(2)  );
resistor #(.w(1.4e-07), .r(7.2707)) (*
integer library_binding
 = "analogLib";
 *)
rg191 ( \2:TP_DISC_1p0 , TP_DISC_1p0 );
resistor #(.w(1.4e-07), .r(7.2707)) (*
integer library_binding
 = "analogLib";
 *)
rg192 ( \2:TX_AMPTRIM_1p0(0) , \TX_AMPTRIM_1p0(0)  );
resistor #(.w(1.4e-07), .r(7.2707)) (*
integer library_binding
 = "analogLib";
 *)
rg193 ( \2:TX_SLOPETRIM_1p0(0) ,
\TX_SLOPETRIM_1p0(0)  );
resistor #(.w(1.4e-07), .r(7.2707)) (*
integer library_binding
 = "analogLib";
 *)
rg194 ( \2:TX_SLOPETRIM_1p0(1) ,
\TX_SLOPETRIM_1p0(1)  );
resistor #(.w(1.4e-07), .r(5.5091)) (*
integer library_binding
 = "analogLib";
 *)
rg195 ( \3:B10_DIS , \2:B10_DIS  );
resistor #(.w(1.8e-07), .r(1.3368)) (*
integer library_binding
 = "analogLib";
 *)
rg196 ( \2:B10_DIS , \4:B10_DIS  );
resistor #(.w(2.1e-07), .r(1.6278)) (*
integer library_binding
 = "analogLib";
 *)
rg197 ( \4:B100_DIS , \2:B100_DIS  );
resistor #(.w(1.4e-07), .r(4.8061)) (*
integer library_binding
 = "analogLib";
 *)
rg198 ( \2:B100_DIS , \3:B100_DIS  );
resistor #(.w(1.4e-07), .r(5.9719)) (*
integer library_binding
 = "analogLib";
 *)
rg199 ( \3:RESETN , \2:RESETN  );
resistor #(.w(2.4e-07), .r(0.7401)) (*
integer library_binding
 = "analogLib";
 *)
rg200 ( \2:RESETN , \4:RESETN  );
resistor #(.w(1.4e-07), .r(5.0141)) (*
integer library_binding
 = "analogLib";
 *)
rg201 ( \3:TXER , \2:TXER  );
resistor #(.w(2.4e-07), .r(1.2989)) (*
integer library_binding
 = "analogLib";
 *)
rg202 ( \2:TXER , \4:TXER  );
resistor #(.w(1.4e-07), .r(46.8921)) (*
integer library_binding
 = "analogLib";
 *)
rg203 ( \3:ADC_1p0(2) , \1:ADC_1p0(2)  );
resistor #(.w(1.4e-07), .r(178.582)) (*
integer library_binding
 = "analogLib";
 *)
rg204 ( \3:I_REXT_100_NC , \1:I_REXT_100_NC  );
resistor #(.w(1.4e-07), .r(419.934)) (*
integer library_binding
 = "analogLib";
 *)
rg205 ( \5:I_RPOLY_REF100 , \2:I_RPOLY_REF100  );
resistor #(.w(1.4e-07), .r(286.598)) (*
integer library_binding
 = "analogLib";
 *)
rg206 ( \2:I_REXT_50(1) , \1:I_REXT_50(1)  );
resistor #(.w(1.4e-07), .r(20.5575)) (*
integer library_binding
 = "analogLib";
 *)
rg207 ( \1:I_REXT_100(1) , \2:I_REXT_100(1)  );
resistor #(.w(1.4e-07), .r(179.585)) (*
integer library_binding
 = "analogLib";
 *)
rg208 ( \3:I_REXT_50(0) , \1:I_REXT_50(0)  );
resistor #(.w(1.4e-07), .r(18.8257)) (*
integer library_binding
 = "analogLib";
 *)
rg209 ( \3:I_REXT_100(0) , \1:I_REXT_100(0)  );
resistor #(.w(1.4e-07), .r(21.5621)) (*
integer library_binding
 = "analogLib";
 *)
rg210 ( \3:I_REXT_100(6) , \1:I_REXT_100(6)  );
resistor #(.w(1.4e-07), .r(21.2792)) (*
integer library_binding
 = "analogLib";
 *)
rg211 ( \3:I_REXT_100(5) , \1:I_REXT_100(5)  );
resistor #(.w(1.4e-07), .r(25.8411)) (*
integer library_binding
 = "analogLib";
 *)
rg212 ( \1:I_RPOLY_100(5) , \3:I_RPOLY_100(5)  );
resistor #(.w(1.4e-07), .r(25.5135)) (*
integer library_binding
 = "analogLib";
 *)
rg213 ( \1:I_RPOLY_100(4) , \3:I_RPOLY_100(4)  );
resistor #(.w(1.4e-07), .r(24.1164)) (*
integer library_binding
 = "analogLib";
 *)
rg214 ( \3:I_RPOLY_100(0) , \1:I_RPOLY_100(0)  );
resistor #(.w(1.4e-07), .r(22.1535)) (*
integer library_binding
 = "analogLib";
 *)
rg215 ( \3:I_REXT_100(2) , \1:I_REXT_100(2)  );
resistor #(.w(1.4e-07), .r(24.1139)) (*
integer library_binding
 = "analogLib";
 *)
rg216 ( \1:I_REXT_100(4) , \3:I_REXT_100(4)  );
resistor #(.w(1.4e-07), .r(32.1742)) (*
integer library_binding
 = "analogLib";
 *)
rg217 ( \2:I_RPOLY_100(2) , \1:I_RPOLY_100(2)  );
resistor #(.w(1.4e-07), .r(57.0236)) (*
integer library_binding
 = "analogLib";
 *)
rg218 ( \3:ADC_1p0(5) , \1:ADC_1p0(5)  );
resistor #(.w(1.4e-07), .r(11.8293)) (*
integer library_binding
 = "analogLib";
 *)
rg219 ( \4:I_REXT_50(1) , \3:I_REXT_50(1)  );
resistor #(.w(1.4e-07), .r(3.665)) (*
integer library_binding
 = "analogLib";
 *)
rg220 ( \4:I_RPOLY_100(2) , \3:I_RPOLY_100(2)  );
resistor #(.w(1.4e-07), .r(13.0229)) (*
integer library_binding
 = "analogLib";
 *)
rg221 ( \6:I_RPOLY_REF100 , \4:I_RPOLY_REF100  );
resistor #(.w(1.4e-07), .r(9.9414)) (*
integer library_binding
 = "analogLib";
 *)
rg222 ( \4:I_RPOLY_100(5) , \2:I_RPOLY_100(5)  );
resistor #(.w(1.4e-07), .r(9.9414)) (*
integer library_binding
 = "analogLib";
 *)
rg223 ( \4:I_RPOLY_100(4) , \2:I_RPOLY_100(4)  );
resistor #(.w(1.4e-07), .r(12.4628)) (*
integer library_binding
 = "analogLib";
 *)
rg224 ( \6:SIDDQ , \7:SIDDQ  );
resistor #(.w(1.4e-07), .r(12.2664)) (*
integer library_binding
 = "analogLib";
 *)
rg225 ( \4:I_RPOLY_100(1) , \2:I_RPOLY_100(1)  );
resistor #(.w(1.4e-07), .r(9.5)) (*
integer library_binding
 = "analogLib";
 *)
rg226 ( \4:I_REXT_100(2) , \2:I_REXT_100(2)  );
resistor #(.w(1.4e-07), .r(11.975)) (*
integer library_binding
 = "analogLib";
 *)
rg227 ( \4:I_REXT_100(0) , \2:I_REXT_100(0)  );
resistor #(.w(1.4e-07), .r(13.3614)) (*
integer library_binding
 = "analogLib";
 *)
rg228 ( \5:I_REXT_100_NC , \4:I_REXT_100_NC  );
resistor #(.w(1.4e-07), .r(11.9986)) (*
integer library_binding
 = "analogLib";
 *)
rg229 ( \5:I_REXT_50(0) , \4:I_REXT_50(0)  );
resistor #(.w(1.4e-07), .r(10.8864)) (*
integer library_binding
 = "analogLib";
 *)
rg230 ( \4:I_REXT_REF100 , \2:I_REXT_REF100  );
resistor #(.w(1.62e-06), .r(0.056)) (*
integer library_binding
 = "analogLib";
 *)
rg231 ( \19:GNDRX , \7:GNDRX  );
resistor #(.w(7e-06), .r(0.07761)) (*
integer library_binding
 = "analogLib";
 *)
rg233 ( \8:GNDRX , \10:GNDRX  );
resistor #(.w(7e-06), .r(0.03351)) (*
integer library_binding
 = "analogLib";
 *)
rg235 ( \10:GNDRX , \12:GNDRX  );
resistor #(.w(7e-06), .r(0.03351)) (*
integer library_binding
 = "analogLib";
 *)
rg237 ( \12:GNDRX , \14:GNDRX  );
resistor #(.w(5e-06), .r(0.5791)) (*
integer library_binding
 = "analogLib";
 *)
rg239 ( \14:GNDRX , \18:GNDRX  );
resistor #(.w(7e-06), .r(0.01167)) (*
integer library_binding
 = "analogLib";
 *)
rg240 ( \6:GNDRX , \10:GNDRX  );
resistor #(.w(7e-06), .r(0.01167)) (*
integer library_binding
 = "analogLib";
 *)
rg241 ( \3:GNDRX , \10:GNDRX  );
resistor #(.w(7e-06), .r(0.01273)) (*
integer library_binding
 = "analogLib";
 *)
rg242 ( \5:GNDRX , \12:GNDRX  );
resistor #(.w(7e-06), .r(0.01273)) (*
integer library_binding
 = "analogLib";
 *)
rg243 ( \2:GNDRX , \12:GNDRX  );
resistor #(.w(7e-06), .r(0.01167)) (*
integer library_binding
 = "analogLib";
 *)
rg244 ( \4:GNDRX , \14:GNDRX  );
resistor #(.w(7e-06), .r(0.01167)) (*
integer library_binding
 = "analogLib";
 *)
rg245 ( \1:GNDRX , \14:GNDRX  );
resistor #(.w(5e-06), .r(0.8877)) (*
integer library_binding
 = "analogLib";
 *)
rg247 ( \8:VDDRX , \6:VDDRX  );
resistor #(.w(5e-06), .r(0.0531)) (*
integer library_binding
 = "analogLib";
 *)
rg248 ( \6:VDDRX , \4:VDDRX  );
resistor #(.w(5e-06), .r(0.01843)) (*
integer library_binding
 = "analogLib";
 *)
rg249 ( \4:VDDRX , \3:VDDRX  );
resistor #(.w(5e-06), .r(0.00625)) (*
integer library_binding
 = "analogLib";
 *)
rg250 ( \1:VDDRX , \6:VDDRX  );
resistor #(.w(1.4e-07), .r(239.931)) (*
integer library_binding
 = "analogLib";
 *)
rg251 ( \5:ADC_1p0(0) , \3:ADC_1p0(0)  );
resistor #(.w(1.4e-07), .r(4.2397)) (*
integer library_binding
 = "analogLib";
 *)
rg252 ( \7:ADC_1p0(3) , \ADC_1p0(3)  );
resistor #(.w(1.4e-07), .r(237.121)) (*
integer library_binding
 = "analogLib";
 *)
rg253 ( \ADC_1p0(3) , \4:ADC_1p0(3)  );
resistor #(.w(1.4e-07), .r(0.4667)) (*
integer library_binding
 = "analogLib";
 *)
rg254 ( \5:ADC_1p0(3) , \ADC_1p0(3)  );
resistor #(.w(1.4e-07), .r(234.593)) (*
integer library_binding
 = "analogLib";
 *)
rg255 ( \5:ADC_1p0(5) , \4:ADC_1p0(5)  );
resistor #(.w(1.4e-07), .r(6.2071)) (*
integer library_binding
 = "analogLib";
 *)
rg256 ( \5:ADC_1p0(5) , \7:ADC_1p0(5)  );
resistor #(.w(1.4e-07), .r(233.067)) (*
integer library_binding
 = "analogLib";
 *)
rg257 ( \5:FLASH_1p0(1) , \4:FLASH_1p0(1)  );
resistor #(.w(1.4e-07), .r(8.6797)) (*
integer library_binding
 = "analogLib";
 *)
rg258 ( \5:FLASH_1p0(1) , \7:FLASH_1p0(1)  );
resistor #(.w(3e-07), .r(1.4759)) (*
integer library_binding
 = "analogLib";
 *)
rh1 ( \1:PHASE_IN(0) , \PHASE_IN(0)  );
resistor #(.w(3e-07), .r(1.4759)) (*
integer library_binding
 = "analogLib";
 *)
rh2 ( \1:I_RPOLY_REF100 , I_RPOLY_REF100 );
resistor #(.w(3e-07), .r(1.4759)) (*
integer library_binding
 = "analogLib";
 *)
rh3 ( \1:I_REXT_400_TX , I_REXT_400_TX );
resistor #(.w(3e-07), .r(1.4839)) (*
integer library_binding
 = "analogLib";
 *)
rh4 ( \1:PHASE_IN(2) , \PHASE_IN(2)  );
resistor #(.w(3e-07), .r(1.4839)) (*
integer library_binding
 = "analogLib";
 *)
rh5 ( \1:PHASE_IN(5) , \PHASE_IN(5)  );
resistor #(.w(3e-07), .r(1.4839)) (*
integer library_binding
 = "analogLib";
 *)
rh6 ( \1:PHASE_IN(6) , \PHASE_IN(6)  );
resistor #(.w(3e-07), .r(1.4839)) (*
integer library_binding
 = "analogLib";
 *)
rh7 ( \1:PHASE_IN(7) , \PHASE_IN(7)  );
resistor #(.w(3e-07), .r(1.4839)) (*
integer library_binding
 = "analogLib";
 *)
rh8 ( \1:PHASE_IN(8) , \PHASE_IN(8)  );
resistor #(.w(3e-07), .r(1.4839)) (*
integer library_binding
 = "analogLib";
 *)
rh9 ( \1:PHASE_IN(9) , \PHASE_IN(9)  );
resistor #(.w(3e-07), .r(1.4839)) (*
integer library_binding
 = "analogLib";
 *)
rh10 ( \1:PHASE_IN(10) , \PHASE_IN(10)  );
resistor #(.w(1.4e-07), .r(3.5989)) (*
integer library_binding
 = "analogLib";
 *)
rh11 ( \8:SIDDQ , \1:SIDDQ  );
resistor #(.w(1.4e-07), .r(37.078)) (*
integer library_binding
 = "analogLib";
 *)
rh12 ( \PHASE_IN(4) , \1:PHASE_IN(4)  );
resistor #(.w(1.4e-07), .r(88.3643)) (*
integer library_binding
 = "analogLib";
 *)
rh13 ( \3:XTAL25 , \1:XTAL25  );
resistor #(.w(1.4e-07), .r(274.172)) (*
integer library_binding
 = "analogLib";
 *)
rh14 ( PLL_160_IN, \1:PLL_160_IN  );
resistor #(.w(1.4e-07), .r(396.25)) (*
integer library_binding
 = "analogLib";
 *)
rh15 ( I_REXT_REF100, \1:I_REXT_REF100  );
resistor #(.w(1.4e-07), .r(37.9688)) (*
integer library_binding
 = "analogLib";
 *)
rh16 ( \PHASE_IN(3) , \1:PHASE_IN(3)  );
resistor #(.w(1.4e-07), .r(35.6927)) (*
integer library_binding
 = "analogLib";
 *)
rh17 ( \PHASE_IN(1) , \1:PHASE_IN(1)  );
resistor #(.w(1.4e-07), .r(346.677)) (*
integer library_binding
 = "analogLib";
 *)
rh18 ( \2:I_RPOLY_REF100 , \3:I_RPOLY_REF100  );
resistor #(.w(1.4e-07), .r(38.2207)) (*
integer library_binding
 = "analogLib";
 *)
rh19 ( \2:PHASE_IN(2) , \3:PHASE_IN(2)  );
resistor #(.w(1.4e-07), .r(33.0821)) (*
integer library_binding
 = "analogLib";
 *)
rh20 ( \2:PHASE_IN(10) , \3:PHASE_IN(10)  );
resistor #(.w(1.4e-07), .r(35.0107)) (*
integer library_binding
 = "analogLib";
 *)
rh21 ( \2:PHASE_IN(7) , \3:PHASE_IN(7)  );
resistor #(.w(1.4e-07), .r(37.1479)) (*
integer library_binding
 = "analogLib";
 *)
rh22 ( \2:PHASE_IN(0) , \3:PHASE_IN(0)  );
resistor #(.w(1.4e-07), .r(34.3679)) (*
integer library_binding
 = "analogLib";
 *)
rh23 ( \2:PHASE_IN(8) , \3:PHASE_IN(8)  );
resistor #(.w(1.4e-07), .r(36.2921)) (*
integer library_binding
 = "analogLib";
 *)
rh24 ( \3:PHASE_IN(5) , \2:PHASE_IN(5)  );
resistor #(.w(1.4e-07), .r(33.725)) (*
integer library_binding
 = "analogLib";
 *)
rh25 ( \2:PHASE_IN(9) , \3:PHASE_IN(9)  );
resistor #(.w(1.4e-07), .r(37.0493)) (*
integer library_binding
 = "analogLib";
 *)
rh26 ( \2:PHASE_IN(6) , \3:PHASE_IN(6)  );
resistor #(.w(1.4e-07), .r(31.7543)) (*
integer library_binding
 = "analogLib";
 *)
rh27 ( \1:TENBT_CLK160_1p0 , \2:TENBT_CLK160_1p0  );
resistor #(.w(1.4e-07), .r(385.567)) (*
integer library_binding
 = "analogLib";
 *)
rh28 ( \3:I_REXT_400_TX , \2:I_REXT_400_TX  );
resistor #(.w(7e-06), .r(0.02914)) (*
integer library_binding
 = "analogLib";
 *)
rh30 ( \7:VDDTX , \9:VDDTX  );
resistor #(.w(7e-06), .r(0.3993)) (*
integer library_binding
 = "analogLib";
 *)
rh32 ( \9:VDDTX , \11:VDDTX  );
resistor #(.w(7e-06), .r(0.02914)) (*
integer library_binding
 = "analogLib";
 *)
rh34 ( \11:VDDTX , \13:VDDTX  );
resistor #(.w(7e-06), .r(0.014)) (*
integer library_binding
 = "analogLib";
 *)
rh35 ( \13:VDDTX , \14:VDDTX  );
resistor #(.w(5e-07), .r(3.5438)) (*
integer library_binding
 = "analogLib";
 *)
rh36 ( BASE10_TX_DIS_1p0, \3:BASE10_TX_DIS_1p0  );
resistor #(.w(2e-06), .r(0.7979)) (*
integer library_binding
 = "analogLib";
 *)
rh37 ( TENBT_CLK160_1p0, \3:TENBT_CLK160_1p0  );
resistor #(.w(1.4e-07), .r(8.9364)) (*
integer library_binding
 = "analogLib";
 *)
rh38 ( \4:TENBT_FILTER_1p0(4) ,
\1:TENBT_FILTER_1p0(4)  );
resistor #(.w(1.4e-07), .r(38.5667)) (*
integer library_binding
 = "analogLib";
 *)
rh39 ( RESET_10BT, \2:RESET_10BT  );
resistor #(.w(1.4e-07), .r(27.8493)) (*
integer library_binding
 = "analogLib";
 *)
rh40 ( \4:TENBT_FILTER_1p0(3) ,
\1:TENBT_FILTER_1p0(3)  );
resistor #(.w(1.4e-07), .r(28.1407)) (*
integer library_binding
 = "analogLib";
 *)
rh41 ( \4:TENBT_FILTER_1p0(2) ,
\1:TENBT_FILTER_1p0(2)  );
resistor #(.w(1.4e-07), .r(8.0364)) (*
integer library_binding
 = "analogLib";
 *)
rh42 ( \4:TENBT_FILTER_1p0(1) ,
\1:TENBT_FILTER_1p0(1)  );
resistor #(.w(1.4e-07), .r(7.7364)) (*
integer library_binding
 = "analogLib";
 *)
rh43 ( \4:TENBT_FILTER_1p0(0) ,
\1:TENBT_FILTER_1p0(0)  );
resistor #(.w(5e-07), .r(9.2269)) (*
integer library_binding
 = "analogLib";
 *)
rh44 ( \TENBT_FILTER_1p0(4) ,
\2:TENBT_FILTER_1p0(4)  );
resistor #(.w(5e-07), .r(3.9265)) (*
integer library_binding
 = "analogLib";
 *)
rh45 ( \TENBT_FILTER_1p0(3) ,
\2:TENBT_FILTER_1p0(3)  );
resistor #(.w(5e-07), .r(3.8449)) (*
integer library_binding
 = "analogLib";
 *)
rh46 ( \TENBT_FILTER_1p0(2) ,
\2:TENBT_FILTER_1p0(2)  );
resistor #(.w(5e-07), .r(8.7747)) (*
integer library_binding
 = "analogLib";
 *)
rh47 ( \TENBT_FILTER_1p0(1) ,
\2:TENBT_FILTER_1p0(1)  );
resistor #(.w(5e-07), .r(8.8569)) (*
integer library_binding
 = "analogLib";
 *)
rh48 ( \TENBT_FILTER_1p0(0) ,
\2:TENBT_FILTER_1p0(0)  );
resistor #(.w(1e-06), .r(2.1419)) (*
integer library_binding
 = "analogLib";
 *)
rh49 ( \MLT3_TDATA_2p5(0) , \1:MLT3_TDATA_2p5(0)  );
resistor #(.w(1e-06), .r(2.0243)) (*
integer library_binding
 = "analogLib";
 *)
rh50 ( \MLT3_TDATA_2p5(1) , \1:MLT3_TDATA_2p5(1)  );
resistor #(.w(1e-06), .r(1.214)) (*
integer library_binding
 = "analogLib";
 *)
rh51 ( \I_REXT_50(1) , \1:I_REXT_50(1)  );
resistor #(.w(5e-07), .r(0.749)) (*
integer library_binding
 = "analogLib";
 *)
rh52 ( X10_DIS_2p5, \1:X10_DIS_2p5  );
resistor #(.w(5e-07), .r(3.1387)) (*
integer library_binding
 = "analogLib";
 *)
rh53 ( TP_DISC_2p5, \1:TP_DISC_2p5  );
resistor #(.w(5e-07), .r(0.7915)) (*
integer library_binding
 = "analogLib";
 *)
rh54 ( TX100_DIS_2p5, \1:TX100_DIS_2p5  );
resistor #(.w(1.4e-07), .r(80.1221)) (*
integer library_binding
 = "analogLib";
 *)
rh55 ( \4:I_REXT_400_TX , \5:I_REXT_400_TX  );
resistor #(.w(1.4e-07), .r(91.0323)) (*
integer library_binding
 = "analogLib";
 *)
rh56 ( \1:I_REXT_100_NC , \2:I_REXT_100_NC  );
resistor #(.w(1.4e-07), .r(102.181)) (*
integer library_binding
 = "analogLib";
 *)
rh57 ( \1:I_REXT_50(0) , \2:I_REXT_50(0)  );
resistor #(.w(1.4e-07), .r(104.827)) (*
integer library_binding
 = "analogLib";
 *)
rh58 ( \2:SIDDQ , \3:SIDDQ  );
resistor #(.w(1.4e-07), .r(88.3107)) (*
integer library_binding
 = "analogLib";
 *)
rh59 ( \1:AEQ_DIS_2p5 , \2:AEQ_DIS_2p5  );
resistor #(.w(1.4e-07), .r(154.011)) (*
integer library_binding
 = "analogLib";
 *)
rh60 ( \1:WANDER_CNT(3) , \2:WANDER_CNT(3)  );
resistor #(.w(1.4e-07), .r(12.5921)) (*
integer library_binding
 = "analogLib";
 *)
rh61 ( \3:TX100_DIS_2p5 , \2:TX100_DIS_2p5  );
resistor #(.w(1.4e-07), .r(75.7657)) (*
integer library_binding
 = "analogLib";
 *)
rh62 ( \2:TX100_DIS_2p5 , \4:TX100_DIS_2p5  );
resistor #(.w(1.4e-07), .r(150.745)) (*
integer library_binding
 = "analogLib";
 *)
rh63 ( \1:WANDER_CNT(6) , \2:WANDER_CNT(6)  );
resistor #(.w(1.4e-07), .r(113.076)) (*
integer library_binding
 = "analogLib";
 *)
rh64 ( \1:T2_MODE , \2:T2_MODE  );
resistor #(.w(1.4e-07), .r(110.479)) (*
integer library_binding
 = "analogLib";
 *)
rh65 ( \1:AEQ_CNT_ANLG(0) , \2:AEQ_CNT_ANLG(0)  );
resistor #(.w(1.4e-07), .r(110.556)) (*
integer library_binding
 = "analogLib";
 *)
rh66 ( \1:AEQ_CNT_ANLG(3) , \2:AEQ_CNT_ANLG(3)  );
resistor #(.w(1.4e-07), .r(111.07)) (*
integer library_binding
 = "analogLib";
 *)
rh67 ( \1:AEQ_CNT_ANLG(4) , \2:AEQ_CNT_ANLG(4)  );
resistor #(.w(1.4e-07), .r(156.423)) (*
integer library_binding
 = "analogLib";
 *)
rh68 ( \1:WANDER_CNT(1) , \2:WANDER_CNT(1)  );
resistor #(.w(1.4e-07), .r(107.956)) (*
integer library_binding
 = "analogLib";
 *)
rh69 ( \1:MR_BYPASS10RX_FILTER ,
\2:MR_BYPASS10RX_FILTER  );
resistor #(.w(1.4e-07), .r(2.5045)) (*
integer library_binding
 = "analogLib";
 *)
rh70 ( \WANDER_CNT(5) , \1:WANDER_CNT(5)  );
resistor #(.w(1.4e-07), .r(0.623)) (*
integer library_binding
 = "analogLib";
 *)
rh71 ( \WANDER_CNT(1) , \3:WANDER_CNT(1)  );
resistor #(.w(1.4e-07), .r(2.9202)) (*
integer library_binding
 = "analogLib";
 *)
rh72 ( \WANDER_CNT(4) , \1:WANDER_CNT(4)  );
resistor #(.w(2.6e-07), .r(1.4855)) (*
integer library_binding
 = "analogLib";
 *)
rh73 ( RX10_PRESENT_2p5, \3:RX10_PRESENT_2p5  );
resistor #(.w(2.4e-07), .r(0.6781)) (*
integer library_binding
 = "analogLib";
 *)
rh74 ( AEQ_DIS_2p5, \3:AEQ_DIS_2p5  );
resistor #(.w(6e-07), .r(0.7455)) (*
integer library_binding
 = "analogLib";
 *)
rh75 ( \8:TX100_DIS_2p5 , \5:TX100_DIS_2p5  );
resistor #(.w(6e-07), .r(0.2686)) (*
integer library_binding
 = "analogLib";
 *)
rh76 ( \8:X10_DIS_2p5 , \4:X10_DIS_2p5  );
resistor #(.w(6e-07), .r(0.3255)) (*
integer library_binding
 = "analogLib";
 *)
rh77 ( BASEFX_DIS, \2:BASEFX_DIS  );
resistor #(.w(6.2e-07), .r(1.46)) (*
integer library_binding
 = "analogLib";
 *)
rh78 ( \3:MR_SQUELCH_RANGE_2p5(1) ,
\MR_SQUELCH_RANGE_2p5(1)  );
resistor #(.w(1.4e-07), .r(132.421)) (*
integer library_binding
 = "analogLib";
 *)
rh79 ( \WANDER_CNT(0) , \1:WANDER_CNT(0)  );
resistor #(.w(6.2e-07), .r(0.7383)) (*
integer library_binding
 = "analogLib";
 *)
rh80 ( \AEQ_CNT_ANLG(4) , \3:AEQ_CNT_ANLG(4)  );
resistor #(.w(1.4e-07), .r(76.1191)) (*
integer library_binding
 = "analogLib";
 *)
rh81 ( \MR_SQUELCH_RANGE_2p5(0) ,
\1:MR_SQUELCH_RANGE_2p5(0)  );
resistor #(.w(1.4e-07), .r(0.2921)) (*
integer library_binding
 = "analogLib";
 *)
rh82 ( \AEQ_CNT_ANLG(0) , \3:AEQ_CNT_ANLG(0)  );
resistor #(.w(6.2e-07), .r(0.05956)) (*
integer library_binding
 = "analogLib";
 *)
rh83 ( \3:MR_SQUELCH_DISB_2p5 ,
MR_SQUELCH_DISB_2p5 );
resistor #(.w(1.4e-07), .r(109.758)) (*
integer library_binding
 = "analogLib";
 *)
rh84 ( \AEQ_CNT_ANLG(1) , \1:AEQ_CNT_ANLG(1)  );
resistor #(.w(6.2e-07), .r(0.07989)) (*
integer library_binding
 = "analogLib";
 *)
rh85 ( \AEQ_CNT_ANLG(3) , \3:AEQ_CNT_ANLG(3)  );
resistor #(.w(1.4e-07), .r(0.3654)) (*
integer library_binding
 = "analogLib";
 *)
rh86 ( T2_MODE, \3:T2_MODE  );
resistor #(.w(1.4e-07), .r(110.607)) (*
integer library_binding
 = "analogLib";
 *)
rh87 ( \AEQ_CNT_ANLG(2) , \1:AEQ_CNT_ANLG(2)  );
resistor #(.w(1.4e-07), .r(108.09)) (*
integer library_binding
 = "analogLib";
 *)
rh88 ( AEQ_BYPASS, \1:AEQ_BYPASS  );
resistor #(.w(1.4e-07), .r(155.608)) (*
integer library_binding
 = "analogLib";
 *)
rh89 ( \WANDER_CNT(2) , \1:WANDER_CNT(2)  );
resistor #(.w(6e-07), .r(0.4311)) (*
integer library_binding
 = "analogLib";
 *)
rh90 ( ADC_TEST_2p5, \1:ADC_TEST_2p5  );
resistor #(.w(6e-07), .r(0.3186)) (*
integer library_binding
 = "analogLib";
 *)
rh91 ( BLW_DIS_2p5, \2:BLW_DIS_2p5  );
resistor #(.w(6e-07), .r(0.2291)) (*
integer library_binding
 = "analogLib";
 *)
rh92 ( ADC_DIS_2p5, \2:ADC_DIS_2p5  );
resistor #(.w(1.4e-07), .r(19.3606)) (*
integer library_binding
 = "analogLib";
 *)
rh93 ( \7:BASEFX_DIS , \4:BASEFX_DIS  );
resistor #(.w(2.6e-07), .r(1.4)) (*
integer library_binding
 = "analogLib";
 *)
rh94 ( \4:BASEFX_DIS , \5:BASEFX_DIS  );
resistor #(.w(1.4e-07), .r(2.12)) (*
integer library_binding
 = "analogLib";
 *)
rh95 ( \6:AEQ_CNT_ANLG(0) , \4:AEQ_CNT_ANLG(0)  );
resistor #(.w(1.4e-07), .r(1.8629)) (*
integer library_binding
 = "analogLib";
 *)
rh96 ( \4:AEQ_CNT_ANLG(2) , \2:AEQ_CNT_ANLG(2)  );
resistor #(.w(1.4e-07), .r(3.4186)) (*
integer library_binding
 = "analogLib";
 *)
rh97 ( \6:AEQ_CNT_ANLG(4) , \4:AEQ_CNT_ANLG(4)  );
resistor #(.w(1.4e-07), .r(6.125)) (*
integer library_binding
 = "analogLib";
 *)
rh98 ( \4:AEQ_BYPASS , \2:AEQ_BYPASS  );
resistor #(.w(6.2e-07), .r(2.3974)) (*
integer library_binding
 = "analogLib";
 *)
rh99 ( RCLK125_TST_SEL, \1:RCLK125_TST_SEL  );
resistor #(.w(1.4e-07), .r(3.7764)) (*
integer library_binding
 = "analogLib";
 *)
rh100 ( \6:WANDER_CNT(5) , \4:WANDER_CNT(5)  );
resistor #(.w(1.4e-07), .r(33.9104)) (*
integer library_binding
 = "analogLib";
 *)
rh101 ( TIMING_DN_ANLG, \1:TIMING_DN_ANLG  );
resistor #(.w(1.4e-07), .r(36.1818)) (*
integer library_binding
 = "analogLib";
 *)
rh102 ( TIMING_UP_ANLG, \1:TIMING_UP_ANLG  );
resistor #(.w(1.4e-07), .r(3.9221)) (*
integer library_binding
 = "analogLib";
 *)
rh103 ( \5:WANDER_CNT(3) , \3:WANDER_CNT(3)  );
resistor #(.w(6.2e-07), .r(2.0839)) (*
integer library_binding
 = "analogLib";
 *)
rh104 ( RCLK125_TST, \1:RCLK125_TST  );
resistor #(.w(6.2e-07), .r(7.4277)) (*
integer library_binding
 = "analogLib";
 *)
rh105 ( RESET_DSP, \1:RESET_DSP  );
resistor #(.w(1.4e-07), .r(2.9129)) (*
integer library_binding
 = "analogLib";
 *)
rh106 ( \6:WANDER_CNT(1) , \4:WANDER_CNT(1)  );
resistor #(.w(6.2e-07), .r(2.5106)) (*
integer library_binding
 = "analogLib";
 *)
rh107 ( \PHASE_250(10) , \1:PHASE_250(10)  );
resistor #(.w(6.2e-07), .r(2.6432)) (*
integer library_binding
 = "analogLib";
 *)
rh108 ( \PHASE_250(9) , \1:PHASE_250(9)  );
resistor #(.w(1.4e-07), .r(27.5579)) (*
integer library_binding
 = "analogLib";
 *)
rh109 ( \4:WANDER_CNT(0) , \2:WANDER_CNT(0)  );
resistor #(.w(6.2e-07), .r(2.7826)) (*
integer library_binding
 = "analogLib";
 *)
rh110 ( \PHASE_250(8) , \1:PHASE_250(8)  );
resistor #(.w(1.4e-07), .r(1.8789)) (*
integer library_binding
 = "analogLib";
 *)
rh111 ( \6:PHASE_IN(0) , \4:PHASE_IN(0)  );
resistor #(.w(6.2e-07), .r(1.1481)) (*
integer library_binding
 = "analogLib";
 *)
rh112 ( \PHASE_250(7) , \1:PHASE_250(7)  );
resistor #(.w(1.4e-07), .r(3.1657)) (*
integer library_binding
 = "analogLib";
 *)
rh113 ( \4:WANDER_CNT(2) , \2:WANDER_CNT(2)  );
resistor #(.w(6.2e-07), .r(2.7308)) (*
integer library_binding
 = "analogLib";
 *)
rh114 ( \PHASE_250(6) , \1:PHASE_250(6)  );
resistor #(.w(1.4e-07), .r(1.9529)) (*
integer library_binding
 = "analogLib";
 *)
rh115 ( \4:PLL_160_IN , \2:PLL_160_IN  );
resistor #(.w(1.4e-07), .r(2.1543)) (*
integer library_binding
 = "analogLib";
 *)
rh116 ( \4:PHASE_IN(1) , \2:PHASE_IN(1)  );
resistor #(.w(6.2e-07), .r(0.8006)) (*
integer library_binding
 = "analogLib";
 *)
rh117 ( \PHASE_250(5) , \1:PHASE_250(5)  );
resistor #(.w(1.4e-07), .r(6.905)) (*
integer library_binding
 = "analogLib";
 *)
rh118 ( \6:WANDER_CNT(4) , \4:WANDER_CNT(4)  );
resistor #(.w(6.2e-07), .r(2.7173)) (*
integer library_binding
 = "analogLib";
 *)
rh119 ( \PHASE_250(4) , \1:PHASE_250(4)  );
resistor #(.w(1.4e-07), .r(1.7171)) (*
integer library_binding
 = "analogLib";
 *)
rh120 ( \4:MLT3_TDATA_2p5(0) ,
\2:MLT3_TDATA_2p5(0)  );
resistor #(.w(6.2e-07), .r(2.5929)) (*
integer library_binding
 = "analogLib";
 *)
rh121 ( \PHASE_250(3) , \1:PHASE_250(3)  );
resistor #(.w(1.4e-07), .r(5.9793)) (*
integer library_binding
 = "analogLib";
 *)
rh122 ( \5:WANDER_CNT(6) , \3:WANDER_CNT(6)  );
resistor #(.w(6.2e-07), .r(2.4792)) (*
integer library_binding
 = "analogLib";
 *)
rh123 ( \PHASE_250(2) , \1:PHASE_250(2)  );
resistor #(.w(1.4e-07), .r(2.5571)) (*
integer library_binding
 = "analogLib";
 *)
rh124 ( \4:MLT3_TDATA_2p5(1) ,
\2:MLT3_TDATA_2p5(1)  );
resistor #(.w(6.2e-07), .r(2.4298)) (*
integer library_binding
 = "analogLib";
 *)
rh125 ( \PHASE_250(1) , \1:PHASE_250(1)  );
resistor #(.w(1.4e-07), .r(1.5843)) (*
integer library_binding
 = "analogLib";
 *)
rh126 ( \6:T2_MODE , \4:T2_MODE  );
resistor #(.w(6.2e-07), .r(2.6974)) (*
integer library_binding
 = "analogLib";
 *)
rh127 ( \PHASE_250(0) , \1:PHASE_250(0)  );
resistor #(.w(1.4e-07), .r(4.9079)) (*
integer library_binding
 = "analogLib";
 *)
rh128 ( \4:TP_DISC_2p5 , \2:TP_DISC_2p5  );
resistor #(.w(1.4e-07), .r(3.5643)) (*
integer library_binding
 = "analogLib";
 *)
rh129 ( \6:AEQ_CNT_ANLG(3) , \4:AEQ_CNT_ANLG(3)  );
resistor #(.w(1.4e-07), .r(2.0986)) (*
integer library_binding
 = "analogLib";
 *)
rh130 ( \6:ADC_DIS_2p5 , \4:ADC_DIS_2p5  );
resistor #(.w(1.4e-07), .r(2.2657)) (*
integer library_binding
 = "analogLib";
 *)
rh131 ( \4:AEQ_CNT_ANLG(1) , \2:AEQ_CNT_ANLG(1)  );
resistor #(.w(1.4e-07), .r(2.7073)) (*
integer library_binding
 = "analogLib";
 *)
rh132 ( \6:AEQ_DIS_2p5 , \4:AEQ_DIS_2p5  );
resistor #(.w(1.4e-07), .r(2.4114)) (*
integer library_binding
 = "analogLib";
 *)
rh133 ( \5:MR_BYPASS10RX_FILTER ,
\3:MR_BYPASS10RX_FILTER  );
resistor #(.w(1.4e-07), .r(8.9579)) (*
integer library_binding
 = "analogLib";
 *)
rh134 ( \6:BLW_DIS_2p5 , \4:BLW_DIS_2p5  );
resistor #(.w(1.4e-07), .r(6.7593)) (*
integer library_binding
 = "analogLib";
 *)
rh135 ( \4:RESET_DSP , \2:RESET_DSP  );
resistor #(.w(1.4e-07), .r(8.6086)) (*
integer library_binding
 = "analogLib";
 *)
rh136 ( \6:ADC_TEST_2p5 , \3:ADC_TEST_2p5  );
resistor #(.w(1.4e-07), .r(1.7964)) (*
integer library_binding
 = "analogLib";
 *)
rh137 ( \4:TIMING_UP_ANLG , \2:TIMING_UP_ANLG  );
resistor #(.w(1.4e-07), .r(8.1993)) (*
integer library_binding
 = "analogLib";
 *)
rh138 ( \6:RX10_PRESENT_2p5 , \4:RX10_PRESENT_2p5  );
resistor #(.w(1.4e-07), .r(4.0679)) (*
integer library_binding
 = "analogLib";
 *)
rh139 ( \4:TIMING_DN_ANLG , \2:TIMING_DN_ANLG  );
resistor #(.w(1.4e-07), .r(7.9079)) (*
integer library_binding
 = "analogLib";
 *)
rh140 ( \6:MR_SQUELCH_DISB_2p5 ,
\4:MR_SQUELCH_DISB_2p5  );
resistor #(.w(1.4e-07), .r(7.7621)) (*
integer library_binding
 = "analogLib";
 *)
rh141 ( \4:MR_SQUELCH_RANGE_2p5(0) ,
\2:MR_SQUELCH_RANGE_2p5(0)  );
resistor #(.w(1.4e-07), .r(8.0536)) (*
integer library_binding
 = "analogLib";
 *)
rh142 ( \6:MR_SQUELCH_RANGE_2p5(1) ,
\4:MR_SQUELCH_RANGE_2p5(1)  );
resistor #(.w(1.4e-07), .r(3.2836)) (*
integer library_binding
 = "analogLib";
 *)
rh143 ( \4:RCLK125_TST_SEL , \2:RCLK125_TST_SEL  );
resistor #(.w(1.4e-07), .r(3.2721)) (*
integer library_binding
 = "analogLib";
 *)
rh144 ( \4:RCLK125_TST , \2:RCLK125_TST  );
resistor #(.w(1.4e-07), .r(1.3821)) (*
integer library_binding
 = "analogLib";
 *)
rh145 ( \4:PHASE_250(10) , \2:PHASE_250(10)  );
resistor #(.w(1.4e-07), .r(0.7886)) (*
integer library_binding
 = "analogLib";
 *)
rh146 ( \4:PHASE_250(9) , \2:PHASE_250(9)  );
resistor #(.w(1.4e-07), .r(1.5843)) (*
integer library_binding
 = "analogLib";
 *)
rh147 ( \4:PHASE_250(8) , \2:PHASE_250(8)  );
resistor #(.w(1.4e-07), .r(8.8121)) (*
integer library_binding
 = "analogLib";
 *)
rh148 ( \4:PHASE_250(7) , \2:PHASE_250(7)  );
resistor #(.w(1.4e-07), .r(1.8071)) (*
integer library_binding
 = "analogLib";
 *)
rh149 ( \4:PHASE_250(6) , \2:PHASE_250(6)  );
resistor #(.w(1.4e-07), .r(10.355)) (*
integer library_binding
 = "analogLib";
 *)
rh150 ( \4:PHASE_250(5) , \2:PHASE_250(5)  );
resistor #(.w(1.4e-07), .r(0.4607)) (*
integer library_binding
 = "analogLib";
 *)
rh151 ( \4:PHASE_250(4) , \2:PHASE_250(4)  );
resistor #(.w(1.4e-07), .r(1.0243)) (*
integer library_binding
 = "analogLib";
 *)
rh152 ( \4:PHASE_250(3) , \2:PHASE_250(3)  );
resistor #(.w(1.4e-07), .r(2.915)) (*
integer library_binding
 = "analogLib";
 *)
rh153 ( \4:PHASE_250(2) , \2:PHASE_250(2)  );
resistor #(.w(1.4e-07), .r(3.1379)) (*
integer library_binding
 = "analogLib";
 *)
rh154 ( \4:PHASE_250(1) , \2:PHASE_250(1)  );
resistor #(.w(1.4e-07), .r(1.9529)) (*
integer library_binding
 = "analogLib";
 *)
rh155 ( \4:PHASE_250(0) , \2:PHASE_250(0)  );
resistor #(.w(1.4e-07), .r(2.6579)) (*
integer library_binding
 = "analogLib";
 *)
rh156 ( \4:XTAL25 , \2:XTAL25  );
resistor #(.w(1.4e-07), .r(2.8036)) (*
integer library_binding
 = "analogLib";
 *)
rh157 ( \9:X10_DIS_2p5 , \6:X10_DIS_2p5  );
resistor #(.w(1.4e-07), .r(2.0557)) (*
integer library_binding
 = "analogLib";
 *)
rh158 ( \9:TX100_DIS_2p5 , \6:TX100_DIS_2p5  );
resistor #(.w(1.4e-07), .r(1.6614)) (*
integer library_binding
 = "analogLib";
 *)
rh159 ( \10:SIDDQ , \4:SIDDQ  );
resistor #(.w(1.4e-07), .r(6.5471)) (*
integer library_binding
 = "analogLib";
 *)
rh160 ( \2:SCAN_MODE , \1:SCAN_MODE  );
resistor #(.w(1.4e-07), .r(6.5471)) (*
integer library_binding
 = "analogLib";
 *)
rh161 ( \2:SCANCLK1 , \1:SCANCLK1  );
resistor #(.w(1.4e-07), .r(6.5471)) (*
integer library_binding
 = "analogLib";
 *)
rh162 ( \2:SCANCLK2 , \1:SCANCLK2  );
resistor #(.w(1.4e-07), .r(6.5471)) (*
integer library_binding
 = "analogLib";
 *)
rh163 ( \2:SCANCLK3 , \1:SCANCLK3  );
resistor #(.w(1.4e-07), .r(6.5471)) (*
integer library_binding
 = "analogLib";
 *)
rh164 ( \2:scan_set , \1:scan_set  );
resistor #(.w(1.4e-07), .r(6.5471)) (*
integer library_binding
 = "analogLib";
 *)
rh165 ( \2:SCAN_ENABLE , \1:SCAN_ENABLE  );
resistor #(.w(1.4e-07), .r(6.5471)) (*
integer library_binding
 = "analogLib";
 *)
rh166 ( \2:scan_reset , \1:scan_reset  );
resistor #(.w(7e-06), .r(0.2273)) (*
integer library_binding
 = "analogLib";
 *)
rh167 ( TPIP, \1:TPIP  );
resistor #(.w(1.4e-07), .r(6.5471)) (*
integer library_binding
 = "analogLib";
 *)
rh168 ( \2:MDIO_IN , \1:MDIO_IN  );
resistor #(.w(1.4e-07), .r(6.5471)) (*
integer library_binding
 = "analogLib";
 *)
rh169 ( \2:PHY(4) , \1:PHY(4)  );
resistor #(.w(1.4e-07), .r(6.5471)) (*
integer library_binding
 = "analogLib";
 *)
rh170 ( \2:PHY(3) , \1:PHY(3)  );
resistor #(.w(1.4e-07), .r(6.5471)) (*
integer library_binding
 = "analogLib";
 *)
rh171 ( \2:PHY(2) , \1:PHY(2)  );
resistor #(.w(1.4e-07), .r(6.5471)) (*
integer library_binding
 = "analogLib";
 *)
rh172 ( \2:PHY(1) , \1:PHY(1)  );
resistor #(.w(1.4e-07), .r(6.5471)) (*
integer library_binding
 = "analogLib";
 *)
rh173 ( \2:PHY(0) , \1:PHY(0)  );
resistor #(.w(8e-06), .r(0.2181)) (*
integer library_binding
 = "analogLib";
 *)
rh174 ( TPIN, \1:TPIN  );
resistor #(.w(1.4e-07), .r(6.5471)) (*
integer library_binding
 = "analogLib";
 *)
rh175 ( \2:CRS , \1:CRS  );
resistor #(.w(1.4e-07), .r(6.5471)) (*
integer library_binding
 = "analogLib";
 *)
rh176 ( \2:MDINT , \1:MDINT  );
resistor #(.w(1.4e-07), .r(6.5471)) (*
integer library_binding
 = "analogLib";
 *)
rh177 ( \2:LEDL , \1:LEDL  );
resistor #(.w(1.4e-07), .r(6.5471)) (*
integer library_binding
 = "analogLib";
 *)
rh178 ( \2:LEDD , \1:LEDD  );
resistor #(.w(1.4e-07), .r(6.5471)) (*
integer library_binding
 = "analogLib";
 *)
rh179 ( \2:SYMBOL_MODE , \1:SYMBOL_MODE  );
resistor #(.w(1.4e-07), .r(6.5471)) (*
integer library_binding
 = "analogLib";
 *)
rh180 ( \2:RXDV , \1:RXDV  );
resistor #(.w(1.4e-07), .r(6.5471)) (*
integer library_binding
 = "analogLib";
 *)
rh181 ( \2:TRISTATE , \1:TRISTATE  );
resistor #(.w(1.4e-07), .r(6.5471)) (*
integer library_binding
 = "analogLib";
 *)
rh182 ( \2:RXC , \1:RXC  );
resistor #(.w(1.4e-07), .r(6.5471)) (*
integer library_binding
 = "analogLib";
 *)
rh183 ( \2:LEDT , \1:LEDT  );
resistor #(.w(1.4e-07), .r(6.5471)) (*
integer library_binding
 = "analogLib";
 *)
rh184 ( \2:LEDS , \1:LEDS  );
resistor #(.w(1.4e-07), .r(6.5471)) (*
integer library_binding
 = "analogLib";
 *)
rh185 ( \2:TXEN , \1:TXEN  );
resistor #(.w(1.4e-07), .r(6.5471)) (*
integer library_binding
 = "analogLib";
 *)
rh186 ( \2:COL , \1:COL  );
resistor #(.w(1.4e-07), .r(6.5471)) (*
integer library_binding
 = "analogLib";
 *)
rh187 ( \2:LEDC , \1:LEDC  );
resistor #(.w(1.4e-07), .r(6.5471)) (*
integer library_binding
 = "analogLib";
 *)
rh188 ( \2:MDIO_OE , \1:MDIO_OE  );
resistor #(.w(1.4e-07), .r(6.5471)) (*
integer library_binding
 = "analogLib";
 *)
rh189 ( \2:MDIO_OUT , \1:MDIO_OUT  );
resistor #(.w(1.4e-07), .r(6.5471)) (*
integer library_binding
 = "analogLib";
 *)
rh190 ( \2:MDC , \1:MDC  );
resistor #(.w(1.4e-07), .r(6.5471)) (*
integer library_binding
 = "analogLib";
 *)
rh191 ( \2:TX_AMP_TRIM(1) , \1:TX_AMP_TRIM(1)  );
resistor #(.w(1.4e-07), .r(6.5471)) (*
integer library_binding
 = "analogLib";
 *)
rh192 ( \2:TX_AMP_TRIM(0) , \1:TX_AMP_TRIM(0)  );
resistor #(.w(1.4e-07), .r(6.5471)) (*
integer library_binding
 = "analogLib";
 *)
rh193 ( \2:TXD(4) , \1:TXD(4)  );
resistor #(.w(1.4e-07), .r(6.5471)) (*
integer library_binding
 = "analogLib";
 *)
rh194 ( \2:TXD(3) , \1:TXD(3)  );
resistor #(.w(1.4e-07), .r(6.5471)) (*
integer library_binding
 = "analogLib";
 *)
rh195 ( \2:TXD(2) , \1:TXD(2)  );
resistor #(.w(1.4e-07), .r(6.5471)) (*
integer library_binding
 = "analogLib";
 *)
rh196 ( \2:TXD(1) , \1:TXD(1)  );
resistor #(.w(1.4e-07), .r(6.5471)) (*
integer library_binding
 = "analogLib";
 *)
rh197 ( \2:TXD(0) , \1:TXD(0)  );
resistor #(.w(1.4e-07), .r(6.5471)) (*
integer library_binding
 = "analogLib";
 *)
rh198 ( \2:LEDR , \1:LEDR  );
resistor #(.w(1.4e-07), .r(6.5471)) (*
integer library_binding
 = "analogLib";
 *)
rh199 ( \2:ANLG_TST , \1:ANLG_TST  );
resistor #(.w(1.4e-07), .r(6.5471)) (*
integer library_binding
 = "analogLib";
 *)
rh200 ( \2:ANDIS , \1:ANDIS  );
resistor #(.w(1.4e-07), .r(6.5471)) (*
integer library_binding
 = "analogLib";
 *)
rh201 ( \2:RXD(4) , \1:RXD(4)  );
resistor #(.w(1.4e-07), .r(6.5471)) (*
integer library_binding
 = "analogLib";
 *)
rh202 ( \2:RXD(3) , \1:RXD(3)  );
resistor #(.w(1.4e-07), .r(6.5471)) (*
integer library_binding
 = "analogLib";
 *)
rh203 ( \2:RXD(2) , \1:RXD(2)  );
resistor #(.w(1.4e-07), .r(6.5471)) (*
integer library_binding
 = "analogLib";
 *)
rh204 ( \2:RXD(1) , \1:RXD(1)  );
resistor #(.w(1.4e-07), .r(6.5471)) (*
integer library_binding
 = "analogLib";
 *)
rh205 ( \2:RXD(0) , \1:RXD(0)  );
resistor #(.w(1.4e-07), .r(6.5471)) (*
integer library_binding
 = "analogLib";
 *)
rh206 ( \2:RXER , \1:RXER  );
resistor #(.w(1.4e-07), .r(6.5471)) (*
integer library_binding
 = "analogLib";
 *)
rh207 ( \2:TX_SLP_TRIM(1) , \1:TX_SLP_TRIM(1)  );
resistor #(.w(1.4e-07), .r(6.5471)) (*
integer library_binding
 = "analogLib";
 *)
rh208 ( \2:TXC , \1:TXC  );
resistor #(.w(1.4e-07), .r(5.1471)) (*
integer library_binding
 = "analogLib";
 *)
rh209 ( \2:TX_SLP_TRIM(0) , \1:TX_SLP_TRIM(0)  );
resistor #(.w(1.4e-07), .r(80.6457)) (*
integer library_binding
 = "analogLib";
 *)
rh210 ( \1:ADC_1p0(2) , \2:ADC_1p0(2)  );
resistor #(.w(1.4e-07), .r(81.6571)) (*
integer library_binding
 = "analogLib";
 *)
rh211 ( \1:ADC_1p0(4) , \2:ADC_1p0(4)  );
resistor #(.w(1.4e-07), .r(78.5029)) (*
integer library_binding
 = "analogLib";
 *)
rh212 ( \1:ADC_1p0(1) , \2:ADC_1p0(1)  );
resistor #(.w(1.4e-07), .r(76.6814)) (*
integer library_binding
 = "analogLib";
 *)
rh213 ( \1:FLASH_1p0(1) , \2:FLASH_1p0(1)  );
resistor #(.w(1.4e-07), .r(77.4186)) (*
integer library_binding
 = "analogLib";
 *)
rh214 ( \1:ADC_1p0(5) , \2:ADC_1p0(5)  );
resistor #(.w(1.4e-07), .r(30.41)) (*
integer library_binding
 = "analogLib";
 *)
rh215 ( \1:B100_DIS , \2:B100_DIS  );
resistor #(.w(1.4e-07), .r(82.2164)) (*
integer library_binding
 = "analogLib";
 *)
rh216 ( \1:FLASH_1p0(0) , \2:FLASH_1p0(0)  );
resistor #(.w(1.4e-07), .r(82.4643)) (*
integer library_binding
 = "analogLib";
 *)
rh217 ( \2:FLASH_1p0(2) , \1:FLASH_1p0(2)  );
resistor #(.w(1.4e-07), .r(79.5636)) (*
integer library_binding
 = "analogLib";
 *)
rh218 ( \1:ADC_1p0(0) , \2:ADC_1p0(0)  );
resistor #(.w(1.4e-07), .r(79.03)) (*
integer library_binding
 = "analogLib";
 *)
rh219 ( \1:RCLK125_1p0 , \2:RCLK125_1p0  );
resistor #(.w(1.4e-07), .r(78.0164)) (*
integer library_binding
 = "analogLib";
 *)
rh220 ( \1:ADC_1p0(3) , \2:ADC_1p0(3)  );
resistor #(.w(1.4e-07), .r(0.1202)) (*
integer library_binding
 = "analogLib";
 *)
rh221 ( \3:NEG_DETECT_1p0 , \1:NEG_DETECT_1p0  );
resistor #(.w(1.4e-07), .r(0.1202)) (*
integer library_binding
 = "analogLib";
 *)
rh222 ( \3:POS_DETECT_1p0 , \1:POS_DETECT_1p0  );
resistor #(.w(1.4e-07), .r(0.3723)) (*
integer library_binding
 = "analogLib";
 *)
rh223 ( \3:TX_AMPTRIM_1p0(1) ,
\1:TX_AMPTRIM_1p0(1)  );
resistor #(.w(6.2e-07), .r(2.4395)) (*
integer library_binding
 = "analogLib";
 *)
rh224 ( \I_RPOLY_100(5) , \1:I_RPOLY_100(5)  );
resistor #(.w(6.2e-07), .r(2.56)) (*
integer library_binding
 = "analogLib";
 *)
rh225 ( \I_RPOLY_100(4) , \1:I_RPOLY_100(4)  );
resistor #(.w(6.2e-07), .r(2.0829)) (*
integer library_binding
 = "analogLib";
 *)
rh226 ( \I_RPOLY_100(3) , \1:I_RPOLY_100(3)  );
resistor #(.w(6.2e-07), .r(2.5179)) (*
integer library_binding
 = "analogLib";
 *)
rh227 ( \I_RPOLY_100(2) , \1:I_RPOLY_100(2)  );
resistor #(.w(6.2e-07), .r(2.4623)) (*
integer library_binding
 = "analogLib";
 *)
rh228 ( \I_RPOLY_100(1) , \1:I_RPOLY_100(1)  );
resistor #(.w(6.2e-07), .r(0.8998)) (*
integer library_binding
 = "analogLib";
 *)
rh229 ( \I_RPOLY_100(0) , \1:I_RPOLY_100(0)  );
resistor #(.w(6.2e-07), .r(0.8442)) (*
integer library_binding
 = "analogLib";
 *)
rh230 ( \I_REXT_100(6) , \1:I_REXT_100(6)  );
resistor #(.w(6.2e-07), .r(0.7885)) (*
integer library_binding
 = "analogLib";
 *)
rh231 ( \I_REXT_100(5) , \1:I_REXT_100(5)  );
resistor #(.w(6.2e-07), .r(0.7552)) (*
integer library_binding
 = "analogLib";
 *)
rh232 ( \I_REXT_100(4) , \1:I_REXT_100(4)  );
resistor #(.w(6.2e-07), .r(2.3684)) (*
integer library_binding
 = "analogLib";
 *)
rh233 ( \I_REXT_100(3) , \1:I_REXT_100(3)  );
resistor #(.w(6.2e-07), .r(2.3742)) (*
integer library_binding
 = "analogLib";
 *)
rh234 ( \I_REXT_100(2) , \1:I_REXT_100(2)  );
resistor #(.w(6.2e-07), .r(2.4066)) (*
integer library_binding
 = "analogLib";
 *)
rh235 ( \I_REXT_100(1) , \1:I_REXT_100(1)  );
resistor #(.w(6.2e-07), .r(2.6718)) (*
integer library_binding
 = "analogLib";
 *)
rh236 ( \I_REXT_100(0) , \1:I_REXT_100(0)  );
resistor #(.w(1.4e-07), .r(10.7139)) (*
integer library_binding
 = "analogLib";
 *)
rh237 ( SLICER_OUT_2p5, \1:SLICER_OUT_2p5  );
resistor #(.w(1.4e-07), .r(10.4654)) (*
integer library_binding
 = "analogLib";
 *)
rh238 ( POS_DETECT_2p5, \1:POS_DETECT_2p5  );
resistor #(.w(1.4e-07), .r(8.2939)) (*
integer library_binding
 = "analogLib";
 *)
rh239 ( NEG_DETECT_2p5, \1:NEG_DETECT_2p5  );
resistor #(.w(1.4e-07), .r(68.0986)) (*
integer library_binding
 = "analogLib";
 *)
rh240 ( \3:ADC_1p0(4) , \4:ADC_1p0(4)  );
resistor #(.w(1.4e-07), .r(68.9136)) (*
integer library_binding
 = "analogLib";
 *)
rh241 ( \3:ADC_1p0(2) , \4:ADC_1p0(2)  );
resistor #(.w(1.4e-07), .r(75.5236)) (*
integer library_binding
 = "analogLib";
 *)
rh242 ( \3:ADC_1p0(1) , \4:ADC_1p0(1)  );
resistor #(.w(1.4e-07), .r(95.4329)) (*
integer library_binding
 = "analogLib";
 *)
rh243 ( \6:SIDDQ , \5:SIDDQ  );
resistor #(.w(1.4e-07), .r(118.834)) (*
integer library_binding
 = "analogLib";
 *)
rh244 ( \2:I_RPOLY_100(1) , \3:I_RPOLY_100(1)  );
resistor #(.w(1.4e-07), .r(115.94)) (*
integer library_binding
 = "analogLib";
 *)
rh245 ( \3:I_REXT_100(1) , \2:I_REXT_100(1)  );
resistor #(.w(1.4e-07), .r(115.919)) (*
integer library_binding
 = "analogLib";
 *)
rh246 ( \2:I_REXT_100(0) , \3:I_REXT_100(0)  );
resistor #(.w(1.4e-07), .r(123.844)) (*
integer library_binding
 = "analogLib";
 *)
rh247 ( \2:I_REXT_100(6) , \3:I_REXT_100(6)  );
resistor #(.w(1.4e-07), .r(124.261)) (*
integer library_binding
 = "analogLib";
 *)
rh248 ( \2:I_REXT_100(5) , \3:I_REXT_100(5)  );
resistor #(.w(1.4e-07), .r(117.156)) (*
integer library_binding
 = "analogLib";
 *)
rh249 ( \2:I_REXT_REF100 , \3:I_REXT_REF100  );
resistor #(.w(1.4e-07), .r(119.804)) (*
integer library_binding
 = "analogLib";
 *)
rh250 ( \2:I_RPOLY_100(5) , \3:I_RPOLY_100(5)  );
resistor #(.w(1.4e-07), .r(119.037)) (*
integer library_binding
 = "analogLib";
 *)
rh251 ( \2:I_RPOLY_100(4) , \3:I_RPOLY_100(4)  );
resistor #(.w(1.4e-07), .r(118.009)) (*
integer library_binding
 = "analogLib";
 *)
rh252 ( \2:I_REXT_100(3) , \3:I_REXT_100(3)  );
resistor #(.w(1.4e-07), .r(125.506)) (*
integer library_binding
 = "analogLib";
 *)
rh253 ( \2:I_RPOLY_100(0) , \3:I_RPOLY_100(0)  );
resistor #(.w(1.4e-07), .r(117.734)) (*
integer library_binding
 = "analogLib";
 *)
rh254 ( \2:I_REXT_100(2) , \3:I_REXT_100(2)  );
resistor #(.w(1.4e-07), .r(120.279)) (*
integer library_binding
 = "analogLib";
 *)
rh255 ( \2:I_RPOLY_100(3) , \3:I_RPOLY_100(3)  );
resistor #(.w(1.4e-07), .r(125.399)) (*
integer library_binding
 = "analogLib";
 *)
rh256 ( \2:I_REXT_100(4) , \3:I_REXT_100(4)  );
resistor #(.w(1.4e-07), .r(74.015)) (*
integer library_binding
 = "analogLib";
 *)
rh257 ( \3:RCLK125_1p0 , \4:RCLK125_1p0  );
resistor #(.w(1.4e-07), .r(74.015)) (*
integer library_binding
 = "analogLib";
 *)
rh258 ( \3:FLASH_1p0(0) , \4:FLASH_1p0(0)  );
resistor #(.w(1.4e-07), .r(77.0564)) (*
integer library_binding
 = "analogLib";
 *)
rh259 ( \3:FLASH_1p0(2) , \4:FLASH_1p0(2)  );
resistor #(.w(1.4e-07), .r(76.2357)) (*
integer library_binding
 = "analogLib";
 *)
rh260 ( \3:ADC_1p0(0) , \4:ADC_1p0(0)  );
resistor #(.w(1.4e-07), .r(77.1421)) (*
integer library_binding
 = "analogLib";
 *)
rh261 ( \3:ADC_1p0(3) , \4:ADC_1p0(3)  );
resistor #(.w(1.4e-07), .r(76.6279)) (*
integer library_binding
 = "analogLib";
 *)
rh262 ( \3:FLASH_1p0(1) , \4:FLASH_1p0(1)  );
resistor #(.w(1.4e-07), .r(77.5921)) (*
integer library_binding
 = "analogLib";
 *)
rh263 ( \3:ADC_1p0(5) , \4:ADC_1p0(5)  );
resistor #(.w(1.4e-07), .r(0.3506)) (*
integer library_binding
 = "analogLib";
 *)
rh264 ( \6:I_RPOLY_100(3) , \4:I_RPOLY_100(3)  );
resistor #(.w(1.4e-07), .r(0.1202)) (*
integer library_binding
 = "analogLib";
 *)
rh265 ( \11:SIDDQ , \7:SIDDQ  );
resistor #(.w(1.4e-07), .r(0.1202)) (*
integer library_binding
 = "analogLib";
 *)
rh266 ( \6:I_RPOLY_100(1) , \4:I_RPOLY_100(1)  );
resistor #(.w(1.4e-07), .r(1.5202)) (*
integer library_binding
 = "analogLib";
 *)
rh267 ( \6:I_RPOLY_100(0) , \4:I_RPOLY_100(0)  );
resistor #(.w(1.4e-07), .r(1.5202)) (*
integer library_binding
 = "analogLib";
 *)
rh268 ( \6:I_REXT_100(4) , \4:I_REXT_100(4)  );
resistor #(.w(1.4e-07), .r(1.5202)) (*
integer library_binding
 = "analogLib";
 *)
rh269 ( \6:I_REXT_100(3) , \4:I_REXT_100(3)  );
resistor #(.w(1.4e-07), .r(0.1202)) (*
integer library_binding
 = "analogLib";
 *)
rh270 ( \6:I_REXT_100(2) , \4:I_REXT_100(2)  );
resistor #(.w(1.4e-07), .r(1.5202)) (*
integer library_binding
 = "analogLib";
 *)
rh271 ( \6:I_REXT_100(1) , \4:I_REXT_100(1)  );
resistor #(.w(1.4e-07), .r(0.1202)) (*
integer library_binding
 = "analogLib";
 *)
rh272 ( \6:I_REXT_100(0) , \4:I_REXT_100(0)  );
resistor #(.w(1.4e-07), .r(0.1202)) (*
integer library_binding
 = "analogLib";
 *)
rh273 ( \7:I_REXT_100_NC , \5:I_REXT_100_NC  );
resistor #(.w(1.4e-07), .r(0.1202)) (*
integer library_binding
 = "analogLib";
 *)
rh274 ( \7:I_REXT_50(0) , \5:I_REXT_50(0)  );
resistor #(.w(1.4e-07), .r(0.1202)) (*
integer library_binding
 = "analogLib";
 *)
rh275 ( \6:I_REXT_REF100 , \4:I_REXT_REF100  );
resistor #(.w(1.4e-07), .r(0.1765)) (*
integer library_binding
 = "analogLib";
 *)
rh276 ( \6:I_RPOLY_100(4) , \4:I_RPOLY_100(4)  );
resistor #(.w(1.4e-07), .r(0.2874)) (*
integer library_binding
 = "analogLib";
 *)
rh277 ( \6:I_RPOLY_100(5) , \4:I_RPOLY_100(5)  );
resistor #(.w(1.4e-07), .r(0.3225)) (*
integer library_binding
 = "analogLib";
 *)
rh278 ( \8:I_RPOLY_REF100 , \6:I_RPOLY_REF100  );
resistor #(.w(1.4e-07), .r(0.3131)) (*
integer library_binding
 = "analogLib";
 *)
rh279 ( \6:I_RPOLY_100(2) , \4:I_RPOLY_100(2)  );
resistor #(.w(1.4e-07), .r(1.583)) (*
integer library_binding
 = "analogLib";
 *)
rh280 ( \6:I_REXT_100(5) , \4:I_REXT_100(5)  );
resistor #(.w(1.4e-07), .r(0.4352)) (*
integer library_binding
 = "analogLib";
 *)
rh281 ( \6:I_REXT_50(1) , \4:I_REXT_50(1)  );
resistor #(.w(1.4e-07), .r(2.2259)) (*
integer library_binding
 = "analogLib";
 *)
rh282 ( \6:I_REXT_100(6) , \4:I_REXT_100(6)  );
resistor #(.w(2e-06), .r(0.13)) (*
integer library_binding
 = "analogLib";
 *)
rh283 ( \8:GNDRX , \16:GNDRX  );
resistor #(.w(2e-06), .r(0.4452)) (*
integer library_binding
 = "analogLib";
 *)
rh284 ( \16:GNDRX , \19:GNDRX  );
resistor #(.w(2e-06), .r(0.0021)) (*
integer library_binding
 = "analogLib";
 *)
rh285 ( \19:GNDRX , \7:GNDRX  );
resistor #(.w(1e-09), .r(0.028)) (*
integer library_binding
 = "analogLib";
 *)
rh286 ( \8:GNDRX , \16:GNDRX  );
resistor #(.w(2e-06), .r(0.2447)) (*
integer library_binding
 = "analogLib";
 *)
rh287 ( \4:VDDRX , \9:VDDRX  );
resistor #(.w(1e-06), .r(0.0657)) (*
integer library_binding
 = "analogLib";
 *)
rh289 ( \FLASH_1p0(2) , \5:FLASH_1p0(2)  );
resistor #(.w(1e-06), .r(0.6404)) (*
integer library_binding
 = "analogLib";
 *)
rh290 ( \FLASH_1p0(1) , \5:FLASH_1p0(1)  );
resistor #(.w(1e-06), .r(0.6449)) (*
integer library_binding
 = "analogLib";
 *)
rh291 ( \FLASH_1p0(0) , \5:FLASH_1p0(0)  );
resistor #(.w(1e-06), .r(0.4841)) (*
integer library_binding
 = "analogLib";
 *)
rh292 ( \ADC_1p0(5) , \5:ADC_1p0(5)  );
resistor #(.w(1e-06), .r(1.5392)) (*
integer library_binding
 = "analogLib";
 *)
rh293 ( \ADC_1p0(4) , \5:ADC_1p0(4)  );
resistor #(.w(1e-06), .r(0.07035)) (*
integer library_binding
 = "analogLib";
 *)
rh294 ( \9:ADC_1p0(3) , \5:ADC_1p0(3)  );
resistor #(.w(1e-06), .r(1.1307)) (*
integer library_binding
 = "analogLib";
 *)
rh295 ( \ADC_1p0(2) , \5:ADC_1p0(2)  );
resistor #(.w(1e-06), .r(0.7564)) (*
integer library_binding
 = "analogLib";
 *)
rh296 ( \ADC_1p0(1) , \5:ADC_1p0(1)  );
resistor #(.w(1e-06), .r(0.5249)) (*
integer library_binding
 = "analogLib";
 *)
rh297 ( \ADC_1p0(0) , \5:ADC_1p0(0)  );
resistor #(.w(1e-06), .r(0.2205)) (*
integer library_binding
 = "analogLib";
 *)
rh298 ( RCLK125_1p0, \5:RCLK125_1p0  );
resistor #(.w(1.4e-07), .r(250.822)) (*
integer library_binding
 = "analogLib";
 *)
rh299 ( \7:ADC_1p0(4) , \6:ADC_1p0(4)  );
resistor #(.w(1.4e-07), .r(252.241)) (*
integer library_binding
 = "analogLib";
 *)
rh300 ( \7:ADC_1p0(3) , \6:ADC_1p0(3)  );
resistor #(.w(1.4e-07), .r(237.623)) (*
integer library_binding
 = "analogLib";
 *)
rh301 ( \7:ADC_1p0(5) , \6:ADC_1p0(5)  );
resistor #(.w(1.4e-07), .r(224.427)) (*
integer library_binding
 = "analogLib";
 *)
rh302 ( \7:FLASH_1p0(1) , \6:FLASH_1p0(1)  );
resistor #(.w(1.2e-07), .r(5.3567)) (*
integer library_binding
 = "analogLib";
 *)
ri1 ( \2:PHASE_IN(2) , \1:PHASE_IN(2)  );
resistor #(.w(1.2e-07), .r(6.06)) (*
integer library_binding
 = "analogLib";
 *)
ri2 ( \2:PHASE_IN(10) , \1:PHASE_IN(10)  );
resistor #(.w(1.2e-07), .r(6.5133)) (*
integer library_binding
 = "analogLib";
 *)
ri3 ( \2:PHASE_IN(7) , \1:PHASE_IN(7)  );
resistor #(.w(1.2e-07), .r(7.0033)) (*
integer library_binding
 = "analogLib";
 *)
ri4 ( \2:PHASE_IN(8) , \1:PHASE_IN(8)  );
resistor #(.w(1.2e-07), .r(7.23)) (*
integer library_binding
 = "analogLib";
 *)
ri5 ( \2:PHASE_IN(5) , \1:PHASE_IN(5)  );
resistor #(.w(1.2e-07), .r(7.6033)) (*
integer library_binding
 = "analogLib";
 *)
ri6 ( \2:PHASE_IN(9) , \1:PHASE_IN(9)  );
resistor #(.w(1.2e-07), .r(6.6567)) (*
integer library_binding
 = "analogLib";
 *)
ri7 ( \2:PHASE_IN(6) , \1:PHASE_IN(6)  );
resistor #(.w(1.2e-07), .r(2.5134)) (*
integer library_binding
 = "analogLib";
 *)
ri8 ( \2:TENBT_FILTER_1p0(4) ,
\1:TENBT_FILTER_1p0(4)  );
resistor #(.w(1.2e-07), .r(3.085)) (*
integer library_binding
 = "analogLib";
 *)
ri9 ( \2:TENBT_FILTER_1p0(1) ,
\1:TENBT_FILTER_1p0(1)  );
resistor #(.w(1.2e-07), .r(3.2101)) (*
integer library_binding
 = "analogLib";
 *)
ri10 ( \2:TENBT_FILTER_1p0(0) ,
\1:TENBT_FILTER_1p0(0)  );
resistor #(.w(1.2e-07), .r(369.64)) (*
integer library_binding
 = "analogLib";
 *)
ri11 ( \4:I_REXT_400_TX , \3:I_REXT_400_TX  );
resistor #(.w(1.2e-07), .r(4.2073)) (*
integer library_binding
 = "analogLib";
 *)
ri12 ( \3:AEQ_DIS_2p5 , \2:AEQ_DIS_2p5  );
resistor #(.w(1.2e-07), .r(3.2567)) (*
integer library_binding
 = "analogLib";
 *)
ri13 ( \3:AEQ_CNT_ANLG(0) , \2:AEQ_CNT_ANLG(0)  );
resistor #(.w(1.2e-07), .r(2.2028)) (*
integer library_binding
 = "analogLib";
 *)
ri14 ( MR_BYPASS10RX_FILTER,
\2:MR_BYPASS10RX_FILTER  );
resistor #(.w(1.2e-07), .r(4.0903)) (*
integer library_binding
 = "analogLib";
 *)
ri15 ( \WANDER_CNT(6) , \2:WANDER_CNT(6)  );
resistor #(.w(1.2e-07), .r(5.0487)) (*
integer library_binding
 = "analogLib";
 *)
ri16 ( \WANDER_CNT(3) , \2:WANDER_CNT(3)  );
resistor #(.w(1.2e-07), .r(402.644)) (*
integer library_binding
 = "analogLib";
 *)
ri17 ( \5:PHASE_IN(6) , \3:PHASE_IN(6)  );
resistor #(.w(1.2e-07), .r(403.097)) (*
integer library_binding
 = "analogLib";
 *)
ri18 ( \5:PHASE_IN(9) , \3:PHASE_IN(9)  );
resistor #(.w(1.2e-07), .r(403.43)) (*
integer library_binding
 = "analogLib";
 *)
ri19 ( \5:PHASE_IN(5) , \3:PHASE_IN(5)  );
resistor #(.w(1.2e-07), .r(403.697)) (*
integer library_binding
 = "analogLib";
 *)
ri20 ( \5:PHASE_IN(8) , \3:PHASE_IN(8)  );
resistor #(.w(1.2e-07), .r(404.187)) (*
integer library_binding
 = "analogLib";
 *)
ri21 ( \5:PHASE_IN(7) , \3:PHASE_IN(7)  );
resistor #(.w(1.2e-07), .r(404.64)) (*
integer library_binding
 = "analogLib";
 *)
ri22 ( \5:PHASE_IN(10) , \3:PHASE_IN(10)  );
resistor #(.w(1.2e-07), .r(405.344)) (*
integer library_binding
 = "analogLib";
 *)
ri23 ( \5:PHASE_IN(2) , \3:PHASE_IN(2)  );
resistor #(.w(1.2e-07), .r(408.3)) (*
integer library_binding
 = "analogLib";
 *)
ri24 ( \3:PHASE_IN(3) , \1:PHASE_IN(3)  );
resistor #(.w(1.2e-07), .r(409.127)) (*
integer library_binding
 = "analogLib";
 *)
ri25 ( \3:PHASE_IN(4) , \1:PHASE_IN(4)  );
resistor #(.w(1.4e-07), .r(9.9031)) (*
integer library_binding
 = "analogLib";
 *)
ri26 ( \8:BASEFX_DIS , \5:BASEFX_DIS  );
resistor #(.w(1.2e-07), .r(403.883)) (*
integer library_binding
 = "analogLib";
 *)
ri27 ( \4:PHASE_IN(0) , \3:PHASE_IN(0)  );
resistor #(.w(1.2e-07), .r(408.997)) (*
integer library_binding
 = "analogLib";
 *)
ri28 ( \2:PHASE_IN(1) , \1:PHASE_IN(1)  );
resistor #(.w(1.2e-07), .r(200.786)) (*
integer library_binding
 = "analogLib";
 *)
ri29 ( \2:MLT3_TDATA_2p5(0) ,
\1:MLT3_TDATA_2p5(0)  );
resistor #(.w(1.2e-07), .r(200.94)) (*
integer library_binding
 = "analogLib";
 *)
ri30 ( \2:MLT3_TDATA_2p5(1) ,
\1:MLT3_TDATA_2p5(1)  );
resistor #(.w(1.2e-07), .r(158.597)) (*
integer library_binding
 = "analogLib";
 *)
ri31 ( \2:TP_DISC_2p5 , \1:TP_DISC_2p5  );
resistor #(.w(1.4e-07), .r(21.6323)) (*
integer library_binding
 = "analogLib";
 *)
ri32 ( \4:AEQ_DIS_2p5 , \1:AEQ_DIS_2p5  );
resistor #(.w(1.2e-07), .r(22.844)) (*
integer library_binding
 = "analogLib";
 *)
ri33 ( \2:RCLK125_TST , \1:RCLK125_TST  );
resistor #(.w(1.2e-07), .r(22.8773)) (*
integer library_binding
 = "analogLib";
 *)
ri34 ( \2:PHASE_250(10) , \1:PHASE_250(10)  );
resistor #(.w(1.2e-07), .r(23.4334)) (*
integer library_binding
 = "analogLib";
 *)
ri35 ( \2:PHASE_250(9) , \1:PHASE_250(9)  );
resistor #(.w(1.2e-07), .r(22.7268)) (*
integer library_binding
 = "analogLib";
 *)
ri36 ( \2:PHASE_250(8) , \1:PHASE_250(8)  );
resistor #(.w(1.2e-07), .r(26.7134)) (*
integer library_binding
 = "analogLib";
 *)
ri37 ( \2:PHASE_250(4) , \1:PHASE_250(4)  );
resistor #(.w(1.2e-07), .r(27.4134)) (*
integer library_binding
 = "analogLib";
 *)
ri38 ( \2:PHASE_250(3) , \1:PHASE_250(3)  );
resistor #(.w(1.2e-07), .r(26.7101)) (*
integer library_binding
 = "analogLib";
 *)
ri39 ( \2:PHASE_250(2) , \1:PHASE_250(2)  );
resistor #(.w(1.2e-07), .r(55.5733)) (*
integer library_binding
 = "analogLib";
 *)
ri40 ( \6:TX100_DIS_2p5 , \3:TX100_DIS_2p5  );
resistor #(.w(1.2e-07), .r(10.5914)) (*
integer library_binding
 = "analogLib";
 *)
ri41 ( \3:SLICER_OUT_2p5 , \1:SLICER_OUT_2p5  );
resistor #(.w(1.2e-07), .r(11.3347)) (*
integer library_binding
 = "analogLib";
 *)
ri42 ( \3:POS_DETECT_2p5 , \1:POS_DETECT_2p5  );
resistor #(.w(1.2e-07), .r(14.2914)) (*
integer library_binding
 = "analogLib";
 *)
ri43 ( \3:NEG_DETECT_2p5 , \1:NEG_DETECT_2p5  );
resistor #(.w(1.2e-07), .r(71.8233)) (*
integer library_binding
 = "analogLib";
 *)
ri44 ( \1:ADC_1p0(4) , \3:ADC_1p0(4)  );
resistor #(.w(1.2e-07), .r(76.1967)) (*
integer library_binding
 = "analogLib";
 *)
ri45 ( \3:ADC_1p0(1) , \1:ADC_1p0(1)  );
resistor #(.w(1.2e-07), .r(11.1897)) (*
integer library_binding
 = "analogLib";
 *)
ri46 ( \5:SIDDQ , \10:SIDDQ  );
resistor #(.w(1.2e-07), .r(34.124)) (*
integer library_binding
 = "analogLib";
 *)
ri47 ( \3:I_RPOLY_100(1) , \1:I_RPOLY_100(1)  );
resistor #(.w(1.2e-07), .r(658.67)) (*
integer library_binding
 = "analogLib";
 *)
ri48 ( \3:I_REXT_REF100 , \1:I_REXT_REF100  );
resistor #(.w(1.2e-07), .r(34.6207)) (*
integer library_binding
 = "analogLib";
 *)
ri49 ( \3:I_REXT_100(3) , \1:I_REXT_100(3)  );
resistor #(.w(1.4e-07), .r(34.7088)) (*
integer library_binding
 = "analogLib";
 *)
ri50 ( \3:I_RPOLY_100(3) , \1:I_RPOLY_100(3)  );
resistor #(.w(1.2e-07), .r(80.4133)) (*
integer library_binding
 = "analogLib";
 *)
ri51 ( \3:RCLK125_1p0 , \1:RCLK125_1p0  );
resistor #(.w(1.2e-07), .r(84.1)) (*
integer library_binding
 = "analogLib";
 *)
ri52 ( \3:FLASH_1p0(0) , \1:FLASH_1p0(0)  );
resistor #(.w(1.2e-07), .r(82.5967)) (*
integer library_binding
 = "analogLib";
 *)
ri53 ( \3:FLASH_1p0(2) , \2:FLASH_1p0(2)  );
resistor #(.w(1.2e-07), .r(84.65)) (*
integer library_binding
 = "analogLib";
 *)
ri54 ( \4:ADC_1p0(0) , \1:ADC_1p0(0)  );
resistor #(.w(1.2e-07), .r(84.05)) (*
integer library_binding
 = "analogLib";
 *)
ri55 ( \3:ADC_1p0(3) , \1:ADC_1p0(3)  );
resistor #(.w(1.2e-07), .r(89.7733)) (*
integer library_binding
 = "analogLib";
 *)
ri56 ( \3:FLASH_1p0(1) , \1:FLASH_1p0(1)  );
resistor #(.w(1.2e-07), .r(16.8367)) (*
integer library_binding
 = "analogLib";
 *)
ri57 ( \4:I_REXT_100(6) , \2:I_REXT_100(6)  );
resistor #(.w(1.4e-07), .r(11.2286)) (*
integer library_binding
 = "analogLib";
 *)
ri58 ( \4:I_RPOLY_100(3) , \2:I_RPOLY_100(3)  );
resistor #(.w(1.2e-07), .r(16.9567)) (*
integer library_binding
 = "analogLib";
 *)
ri59 ( \4:I_REXT_100(5) , \2:I_REXT_100(5)  );
resistor #(.w(1.2e-07), .r(12.8533)) (*
integer library_binding
 = "analogLib";
 *)
ri60 ( \4:I_RPOLY_100(0) , \2:I_RPOLY_100(0)  );
resistor #(.w(1.2e-07), .r(10.95)) (*
integer library_binding
 = "analogLib";
 *)
ri61 ( \4:I_REXT_100(4) , \2:I_REXT_100(4)  );
resistor #(.w(1.2e-07), .r(13.08)) (*
integer library_binding
 = "analogLib";
 *)
ri62 ( \4:I_REXT_100(3) , \2:I_REXT_100(3)  );
resistor #(.w(1.2e-07), .r(16.6633)) (*
integer library_binding
 = "analogLib";
 *)
ri63 ( \4:I_REXT_100(1) , \3:I_REXT_100(1)  );
resistor #(.w(1.2e-07), .r(365.945)) (*
integer library_binding
 = "analogLib";
 *)
ri64 ( \4:FLASH_1p0(2) , \5:FLASH_1p0(2)  );
resistor #(.w(1.2e-07), .r(368.395)) (*
integer library_binding
 = "analogLib";
 *)
ri65 ( \5:FLASH_1p0(0) , \4:FLASH_1p0(0)  );
resistor #(.w(1.2e-07), .r(391.003)) (*
integer library_binding
 = "analogLib";
 *)
ri66 ( \5:ADC_1p0(2) , \4:ADC_1p0(2)  );
resistor #(.w(1.2e-07), .r(389.61)) (*
integer library_binding
 = "analogLib";
 *)
ri67 ( \5:ADC_1p0(1) , \4:ADC_1p0(1)  );
resistor #(.w(1.2e-07), .r(380.026)) (*
integer library_binding
 = "analogLib";
 *)
ri68 ( \5:RCLK125_1p0 , \4:RCLK125_1p0  );
resistor #(.w(1.2e-07), .r(8.7997)) (*
integer library_binding
 = "analogLib";
 *)
ri69 ( \6:ADC_1p0(4) , \5:ADC_1p0(4)  );
resistor #(.w(1.2e-07), .r(390.106)) (*
integer library_binding
 = "analogLib";
 *)
ri70 ( \5:ADC_1p0(4) , \4:ADC_1p0(4)  );

top_common #(.lxPlacementStatus(4), .ieIO("output"), .ieLib("schroeder_sims"),
 .\.usim_opt ("sim_mode=ms acc=2 analog=2")) (*
integer
library_binding = "ether";
 *)
I22 ( .CLKXTAL( \3:XTAL25  ), .SIDDQ(
\8:SIDDQ  ), .I_RPOLY_100( I_RPOLY_REF100 ), .PHASE( { \PHASE_IN(10) ,
\PHASE_IN(9) ,\PHASE_IN(8) ,\PHASE_IN(7) ,\PHASE_IN(6) ,\PHASE_IN(5) ,
\PHASE_IN(4) ,\PHASE_IN(3) ,\PHASE_IN(2) ,\PHASE_IN(1) ,\PHASE_IN(0)  } ),
.I_REXT_100( I_REXT_REF100 ), .I_REXT_400_TX( I_REXT_400_TX ), .RBIAS_SENSE(
\1:RBIAS_SENSE  ), .RBIAS( \1:RBIAS  ), .DISABLE10( \1:DISABLE10  ), .PLL160(
PLL_160_IN ), .VDDA_250( \1:VDDA_250  ), .VDDA_160( \1:VDDA_160  ), .GNDA_160(
\1:GNDA_160  ), .GNDA_250( \1:GNDA_250  ), .DISABLE100( \1:DISABLE100  ),
.BGTRIM( { \1:BGTRIM(3) ,\1:BGTRIM(2) ,\1:BGTRIM(1) ,\1:BGTRIM(0)  } ) );

top_1_port_transmit #(.lxPlacementStatus(4)) (*
integer
library_binding = "ether";
 *)
I46 ( .TENBT_CLK_160( TENBT_CLK160_1p0 ),
.SIDDQ( \9:SIDDQ  ), .TPON( \1:TPON  ), .X10_DIS_2p5( X10_DIS_2p5 ), .I_REXT_400_TX(
\7:I_REXT_400_TX  ), .BASE10_TX_DIS( BASE10_TX_DIS_1p0 ), .TENBT_FILTER( { \TENBT_FILTER_1p0(4) ,
\TENBT_FILTER_1p0(3) ,\TENBT_FILTER_1p0(2) ,\TENBT_FILTER_1p0(1) ,
\TENBT_FILTER_1p0(0)  } ), .TPOP( \3:TPOP  ), .VDD( VDD ), .TP_DIS(
TP_DISC_2p5 ), .VDDTX( \27:VDDTX  ), .I_REXT_50u( { \I_REXT_50(1) ,
\I_REXT_50(0)  } ), .RESET_10BT( RESET_10BT ), .TX100_DIS_2p5(
TX100_DIS_2p5 ), .I_100u_Rext_NC( I_REXT_100_NC ), .GNDTX( \8:GNDTX  ),
.GND( GND ), .MLT3ENC_DATA( { \MLT3_TDATA_2p5(1) ,
\MLT3_TDATA_2p5(0)  } ) );

top_1_port_receive #(.lxPlacementStatus(4)) (*
integer library_binding
 = "ether";
 *)
I44 ( .MR_SQUELCH_DISB( MR_SQUELCH_DISB_2p5 ), .RX10_SLICER_OUT(
SLICER_OUT_2p5 ), .I_RPOLY_100( { \I_RPOLY_100(5) ,
\I_RPOLY_100(4) ,\I_RPOLY_100(3) ,\I_RPOLY_100(2) ,\I_RPOLY_100(1) ,
\I_RPOLY_100(0)  } ), .RX10_PRESENT( RX10_PRESENT_2p5 ), .ADC_TEST_2p5(
ADC_TEST_2p5 ), .ADC_DIS_2p5( ADC_DIS_2p5 ), .X10_DIS_2p5(
\8:X10_DIS_2p5  ), .ADC( { \ADC_1p0(5) ,
\ADC_1p0(4) ,\9:ADC_1p0(3) ,\ADC_1p0(2) ,\ADC_1p0(1) ,\ADC_1p0(0)  } ),
.RX10_NEG_SIG_DET( POS_DETECT_2p5 ), .RESET_DSP( RESET_DSP ), .BASE100TX_DIS(
\8:TX100_DIS_2p5  ), .TIMING_DN( TIMING_DN_ANLG ), .AEQ_CNT( { \AEQ_CNT_ANLG(4) ,
\AEQ_CNT_ANLG(3) ,\AEQ_CNT_ANLG(2) ,\AEQ_CNT_ANLG(1) ,
\AEQ_CNT_ANLG(0)  } ), .PHASE_250( { \PHASE_250(10) ,
\PHASE_250(9) ,\PHASE_250(8) ,\PHASE_250(7) ,\PHASE_250(6) ,
\PHASE_250(5) ,\PHASE_250(4) ,\PHASE_250(3) ,\PHASE_250(2) ,
\PHASE_250(1) ,\PHASE_250(0)  } ), .I_REXT_100( { \I_REXT_100(6) ,
\I_REXT_100(5) ,\I_REXT_100(4) ,\I_REXT_100(3) ,\I_REXT_100(2) ,
\I_REXT_100(1) ,\I_REXT_100(0)  } ), .RCLK_125( RCLK125_1p0 ), .MR_SQUELCH_RANGE( { \MR_SQUELCH_RANGE_2p5(1) ,
\MR_SQUELCH_RANGE_2p5(0)  } ), .VDDRX( \7:VDDRX  ), .TIMING_UP(
TIMING_UP_ANLG ), .RCLK125_TST_SEL( RCLK125_TST_SEL ), .VDD( VDD ), .FLASH( { \FLASH_1p0(2) ,
\FLASH_1p0(1) ,\FLASH_1p0(0)  } ), .MR_10BT_FILTER(
MR_BYPASS10RX_FILTER ), .MR_AEQ_BYPASS( AEQ_BYPASS ), .BASEFX_DIS(
BASEFX_DIS ), .TPIP( \1:TPIP  ), .RCLK125_TST( RCLK125_TST ), .GNDRX(
\17:GNDRX  ), .AEQ_DIS_2p5( AEQ_DIS_2p5 ), .BLW_DIS_2p5( BLW_DIS_2p5 ),
.T2_MODE( T2_MODE ), .TPIN( \1:TPIN  ), .WANDER_CNT( { \WANDER_CNT(6) ,
\WANDER_CNT(5) ,\WANDER_CNT(4) ,\WANDER_CNT(3) ,\WANDER_CNT(2) ,
\WANDER_CNT(1) ,\WANDER_CNT(0)  } ), .GND( GND ), .RX10_POS_SIG_DET(
NEG_DETECT_2p5 ) );

top_1_port_pnr #(.lxPlacementStatus(4)) (*
integer library_binding
 = "ether";
integer cds_net_set[0:1] = { "VDD","VSS" };
integer VDD
 = "VDD";
integer VSS = "GND";
 *)
I45 ( .AEQ_BYPASS( \4:AEQ_BYPASS  ),
.TX_AMPTRIM( { \TX_AMPTRIM_1p0(1) ,\TX_AMPTRIM_1p0(0)  } ), .TEST_MODE( { \TEST_MODE(2) ,
\TEST_MODE(1) ,\TEST_MODE(0)  } ), .TXC( \2:TXC  ), .SCAN_CLK1(
\2:SCANCLK1  ), .MR_SQUELCH_DISB( MR_SQUELCH_DISB_1p0 ), .RXDV(
\2:RXDV  ), .ANLG_TST( \2:ANLG_TST  ), .TXER( \3:TXER  ), .XTAL25(
XTAL25_1p0 ), .LEDL( \2:LEDL  ), .LEDR( \2:LEDR  ), .RESET(
\2:RESET_10BT  ), .RXC( \2:RXC  ), .ANDIS( \2:ANDIS  ), .X_160( X_160 ),
.MR_BYPASS10RX_FILTER( \5:MR_BYPASS10RX_FILTER  ), .CLKPLL_SC(
\2:clkpll_sc  ), .RX10_PRESENT( RX10_PRESENT_1p0 ), .SCAN_MODE(
\2:SCAN_MODE  ), .TXEN( \2:TXEN  ), .ADC( { \9:ADC_1p0(5) ,
\9:ADC_1p0(4) ,\10:ADC_1p0(3) ,\7:ADC_1p0(2) ,\7:ADC_1p0(1) ,
\7:ADC_1p0(0)  } ), .TIMING_DN_ANLG( \4:TIMING_DN_ANLG  ), .MLT3_TDATA( { \MLT3_TDATA_1p0(1) ,
\MLT3_TDATA_1p0(0)  } ), .SCAN_ENABLE( \2:SCAN_ENABLE  ), .scan_reset(
\2:scan_reset  ), .MDIO_IN( \2:MDIO_IN  ), .BASE10_DIS( \3:B10_DIS  ),
.RESET_DSP( \4:RESET_DSP  ), .TP_DISC( TP_DISC_1p0 ), .BASE100TX_DIS(
\3:B100_DIS  ), .SCAN_CLK3( \2:SCANCLK3  ), .TENBT_CLK160(
\5:TENBT_CLK160_1p0  ), .TX_SLP_TRIM( { \2:TX_SLP_TRIM(1) ,
\2:TX_SLP_TRIM(0)  } ), .LEDT( \2:LEDT  ), .LEDS( \2:LEDS  ), .MDINT(
\2:MDINT  ), .TIMING_UP_ANLG( \4:TIMING_UP_ANLG  ), .MR_SQUELCH_RANGE( { \MR_SQUELCH_RANGE_1p0(1) ,
\MR_SQUELCH_RANGE_1p0(0)  } ), .BASE10_TX_DIS( \5:BASE10_TX_DIS_1p0  ),
.LEDC( \2:LEDC  ), .MDIX( MDIX ), .SCAN_CLK2( \2:SCANCLK2  ), .scan_set(
\2:scan_set  ), .RESETN( \3:RESETN  ), .PHY( { \2:PHY(4) ,
\2:PHY(3) ,\2:PHY(2) ,\2:PHY(1) ,\2:PHY(0)  } ), .LEDD( \2:LEDD  ), .TENBT_FILTER( { \4:TENBT_FILTER_1p0(4) ,
\4:TENBT_FILTER_1p0(3) ,\4:TENBT_FILTER_1p0(2) ,
\4:TENBT_FILTER_1p0(1) ,\4:TENBT_FILTER_1p0(0)  } ), .POS_DETECT(
POS_DETECT_1p0 ), .TRISTATE( \2:TRISTATE  ), .VDD( VDD ), .X_125(
X_125 ), .FLASH( { \7:FLASH_1p0(2) ,
\9:FLASH_1p0(1) ,\7:FLASH_1p0(0)  } ), .SYMBOL_MODE( \2:SYMBOL_MODE  ),
.BASEFX_DIS( \7:BASEFX_DIS  ), .COL( \2:COL  ), .RCLK125(
\7:RCLK125_1p0  ), .WANDER_CNT_ANLG( { \5:WANDER_CNT(6) ,
\6:WANDER_CNT(5) ,\6:WANDER_CNT(4) ,\5:WANDER_CNT(3) ,
\4:WANDER_CNT(2) ,\6:WANDER_CNT(1) ,\4:WANDER_CNT(0)  } ), .AEQ_CNT_ANLG( { \6:AEQ_CNT_ANLG(4) ,
\6:AEQ_CNT_ANLG(3) ,\4:AEQ_CNT_ANLG(2) ,\4:AEQ_CNT_ANLG(1) ,
\6:AEQ_CNT_ANLG(0)  } ), .MDIO_OE( \2:MDIO_OE  ), .TX_SLOPETRIM( { \TX_SLOPETRIM_1p0(1) ,
\TX_SLOPETRIM_1p0(0)  } ), .MDC( \2:MDC  ), .NEG_DETECT(
NEG_DETECT_1p0 ), .TX_AMP_TRIM( { \2:TX_AMP_TRIM(1) ,
\2:TX_AMP_TRIM(0)  } ), .T2_MODE( \6:T2_MODE  ), .TXD( { \2:TXD(4) ,
\2:TXD(3) ,\2:TXD(2) ,\2:TXD(1) ,\2:TXD(0)  } ), .CLKPLL_IN( clkpll_sc ),
.GND( GND ), .MDIO_OUT( \2:MDIO_OUT  ), .SLICER_OUT( SLICER_OUT_1p0 ),
.CRS( \2:CRS  ), .RXER( \2:RXER  ), .RXD( { \2:RXD(4) ,
\2:RXD(3) ,\2:RXD(2) ,\2:RXD(1) ,\2:RXD(0)  } ) );

anlg_cntl #(.lxPlacementStatus(4)) (*
integer library_binding
 = "ether";
 *)
I42 ( .PHASE_IN( { \5:PHASE_IN(10) ,
\5:PHASE_IN(9) ,\5:PHASE_IN(8) ,\5:PHASE_IN(7) ,\5:PHASE_IN(6) ,
\5:PHASE_IN(5) ,\3:PHASE_IN(4) ,\3:PHASE_IN(3) ,\5:PHASE_IN(2) ,
\4:PHASE_IN(1) ,\6:PHASE_IN(0)  } ), .TEST_MODE( { \2:TEST_MODE(2) ,
\2:TEST_MODE(1) ,\2:TEST_MODE(0)  } ), .PHASE_125( { \PHASE_125(10) ,
\PHASE_125(9) ,\PHASE_125(8) ,\PHASE_125(7) ,\PHASE_125(6) ,
\PHASE_125(5) ,\PHASE_125(4) ,\PHASE_125(3) ,\PHASE_125(2) ,
\PHASE_125(1) ,\PHASE_125(0)  } ), .XTAL25( \2:XTAL25_1p0  ), .TXER(
\4:TXER  ), .X_160( \2:X_160  ), .SIDDQ( \10:SIDDQ  ), .TP_DISC_1p0(
\2:TP_DISC_1p0  ), .RX10_PRESENT_2p5( \6:RX10_PRESENT_2p5  ), .MR_SQUELCH_RANGE_1p0( { \2:MR_SQUELCH_RANGE_1p0(1) ,
\2:MR_SQUELCH_RANGE_1p0(0)  } ), .MLT3_TDATA_2p5( { \4:MLT3_TDATA_2p5(1) ,
\4:MLT3_TDATA_2p5(0)  } ), .ADC_DIS_2p5( \6:ADC_DIS_2p5  ), .ADC_TEST_2p5(
\6:ADC_TEST_2p5  ), .SLICER_OUT_2p5( \3:SLICER_OUT_2p5  ), .X10_DIS_2p5(
\9:X10_DIS_2p5  ), .BASE10_DIS( \4:B10_DIS  ), .TP_DISC_2p5(
\4:TP_DISC_2p5  ), .BASE100TX_DIS( \4:B100_DIS  ), .PHASE_250( { \4:PHASE_250(10) ,
\4:PHASE_250(9) ,\4:PHASE_250(8) ,\4:PHASE_250(7) ,\4:PHASE_250(6) ,
\4:PHASE_250(5) ,\4:PHASE_250(4) ,\4:PHASE_250(3) ,\4:PHASE_250(2) ,
\4:PHASE_250(1) ,\4:PHASE_250(0)  } ), .RX10_PRESENT_1p0(
\2:RX10_PRESENT_1p0  ), .TX_AMPTRIM_1p0( { \3:TX_AMPTRIM_1p0(1) ,
\2:TX_AMPTRIM_1p0(0)  } ), .POS_DETECT_1p0( \3:POS_DETECT_1p0  ), .MLT3_TDATA_1p0( { \2:MLT3_TDATA_1p0(1) ,
\2:MLT3_TDATA_1p0(0)  } ), .SLICER_OUT_1p0( \2:SLICER_OUT_1p0  ), .VDDRX(
\8:VDDRX  ), .MR_SQUELCH_DISB_2p5( \6:MR_SQUELCH_DISB_2p5  ), .NEG_DETECT_2p5(
\3:NEG_DETECT_2p5  ), .NEG_DETECT_1p0( \3:NEG_DETECT_1p0  ), .RESETN(
\4:RESETN  ), .RCLK125_TST_SEL( \4:RCLK125_TST_SEL  ), .VDD( VDD ), .MR_SQUELCH_DISB_1p0(
\2:MR_SQUELCH_DISB_1p0  ), .X_125( \2:X_125  ), .PLL_160_IN(
\4:PLL_160_IN  ), .BASEFX_DIS( \8:BASEFX_DIS  ), .VDDTX( \28:VDDTX  ),
.RCLK125_TST( \4:RCLK125_TST  ), .GNDRX( \18:GNDRX  ), .MR_SQUELCH_RANGE_2p5( { \6:MR_SQUELCH_RANGE_2p5(1) ,
\4:MR_SQUELCH_RANGE_2p5(0)  } ), .XTAL25_IN( \4:XTAL25  ), .POS_DETECT_2p5(
\3:POS_DETECT_2p5  ), .AEQ_DIS_2p5( \6:AEQ_DIS_2p5  ), .BLW_DIS_2p5(
\6:BLW_DIS_2p5  ), .TX100_DIS_2p5( \9:TX100_DIS_2p5  ), .TX_SLOPETRIM_1p0( { \2:TX_SLOPETRIM_1p0(1) ,
\2:TX_SLOPETRIM_1p0(0)  } ), .GND( GND ), .GNDTX( \9:GNDTX  ) );

Bias_port #(.lxPlacementStatus(4)) (*
integer library_binding
 = "ether";
 *)
I36 ( .I_REXT_REF100( \6:I_REXT_REF100  ), .SIDDQ(
\11:SIDDQ  ), .I_RPOLY_100( { \6:I_RPOLY_100(5) ,
\6:I_RPOLY_100(4) ,\6:I_RPOLY_100(3) ,\6:I_RPOLY_100(2) ,
\6:I_RPOLY_100(1) ,\6:I_RPOLY_100(0)  } ), .I_REXT_100( { \6:I_REXT_100(6) ,
\6:I_REXT_100(5) ,\6:I_REXT_100(4) ,\6:I_REXT_100(3) ,
\6:I_REXT_100(2) ,\6:I_REXT_100(1) ,\6:I_REXT_100(0)  } ), .I_REXT_50( { \6:I_REXT_50(1) ,
\7:I_REXT_50(0)  } ), .VDD( \9:VDDRX  ), .I_RPOLY_REF100(
\8:I_RPOLY_REF100  ), .VSS( \19:GNDRX  ), .I_REXT_100_NC(
\7:I_REXT_100_NC  ) );

endmodule
