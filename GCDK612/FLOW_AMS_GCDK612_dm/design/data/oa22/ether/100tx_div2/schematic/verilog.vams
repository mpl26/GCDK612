// Verilog-AMS netlist generated by the AMS netlister, version  IC6.1.4.431 .
// Cadence Design Systems, Inc.

`include "disciplines.vams"

(* cds_ams_schematic *)
module \100tx_div2  ( XTAL25,TAP,RESETN,IN );

input   XTAL25;
output [10:0]  TAP;
input   RESETN;
input [10:0]
 IN;

clkbuf_1x_hv #(.ieIO("output"), .d2a_tf("100p"), .d2a_vh("2.5"), .a2d_tx("100p"),
 .a2d_v0("0.5"), .a2d_v1("0.8"), .d2a_tr("100p")) (*
integer
library_binding = "ether";
 *)
I18 ( .Y( RESETN_INT ), .A( RESETN ) );

and2_1x_hv #(.ieIO("output"), .d2a_tf("100p"), .d2a_vh("2.5"), .a2d_tx("100p"),
 .a2d_v0("0.5"), .a2d_v1("0.8"), .d2a_tr("100p")) (*
integer
library_binding = "ether";
 *)
I40 ( .Y( RSTb ), .A( net014 ), .B(
RESETN_INT ) );

dff_1x_hv #(.ieIO("output"), .d2a_tf("100p"), .d2a_vh("2.5"), .a2d_tx("100p"),
 .a2d_v0("0.5"), .a2d_v1("0.8"), .d2a_tr("100p")) (*
integer
library_binding = "ether";
 *)
I32 ( .QN( net011 ), .CK( XTAL25 ), .D(
net03 ), .Q( net018 ) );
dff_1x_hv #(.ieIO("output"), .d2a_tf("100p"), .d2a_vh("2.5"), .a2d_tx("100p"),
 .a2d_v0("0.5"), .a2d_v1("0.8"), .d2a_tr("100p")) (*
integer
library_binding = "ether";
 *)
I31 ( .QN( net021 ), .CK( XTAL25 ), .D(
RESETN_INT ), .Q( net03 ) );
dff_1x_hv #(.ieIO("output"), .d2a_tf("100p"), .d2a_vh("2.5"), .a2d_tx("100p"),
 .a2d_v0("0.5"), .a2d_v1("0.8"), .d2a_tr("100p")) (*
integer
library_binding = "ether";
 *)
I37 ( .QN( net06 ), .CK( XTAL25 ), .D(
net018 ), .Q( net014 ) );

dffr_2x_hv #(.ieIO("output"), .d2a_tf("100p"), .d2a_vh("2.5"), .a2d_tx("100p"),
 .a2d_v1("0.8"), .a2d_v0("0.5"), .d2a_tr("100p")) (*
integer
library_binding = "ether";
 *)
I24 ( .QN( TAP2b ), .CK( IN[4] ), .D(
TAP[8] ), .RN( RSTb ), .Q( TAP[2] ) );
dffr_2x_hv #(.ieIO("output"), .d2a_tf("100p"), .d2a_vh("2.5"), .a2d_tx("100p"),
 .a2d_v1("0.8"), .a2d_v0("0.5"), .d2a_tr("100p")) (*
integer
library_binding = "ether";
 *)
I23 ( .QN( TAP[7] ), .CK( IN[3] ), .D(
TAP2b ), .RN( RSTb ), .Q( net38 ) );
dffr_2x_hv #(.ieIO("output"), .d2a_tf("100p"), .d2a_vh("2.5"), .a2d_tx("100p"),
 .a2d_v1("0.8"), .a2d_v0("0.5"), .d2a_tr("100p")) (*
integer
library_binding = "ether";
 *)
I27 ( .QN( TAP[9] ), .CK( IN[7] ), .D(
TAP4b ), .RN( RSTb ), .Q( net024 ) );
dffr_2x_hv #(.ieIO("output"), .d2a_tf("100p"), .d2a_vh("2.5"), .a2d_tx("100p"),
 .a2d_v1("0.8"), .a2d_v0("0.5"), .d2a_tr("100p")) (*
integer
library_binding = "ether";
 *)
I22 ( .QN( TAP1b ), .CK( IN[2] ), .D(
TAP[7] ), .RN( RSTb ), .Q( TAP[1] ) );
dffr_2x_hv #(.ieIO("output"), .d2a_tf("100p"), .d2a_vh("2.5"), .a2d_tx("100p"),
 .a2d_v0("0.5"), .a2d_v1("0.8"), .d2a_tr("100p")) (*
integer
library_binding = "ether";
 *)
I19 ( .QN( TAP5b ), .CK( IN[10] ), .D(
TAP5b ), .RN( RSTb ), .Q( TAP[5] ) );
dffr_2x_hv #(.ieIO("output"), .d2a_tf("100p"), .d2a_vh("2.5"), .a2d_tx("100p"),
 .a2d_v1("0.8"), .a2d_v0("0.5"), .d2a_tr("100p")) (*
integer
library_binding = "ether";
 *)
I25 ( .QN( TAP[10] ), .CK( IN[9] ), .D(
TAP5b ), .RN( RSTb ), .Q( net012 ) );
dffr_2x_hv #(.ieIO("output"), .d2a_tf("100p"), .d2a_vh("2.5"), .a2d_tx("100p"),
 .a2d_v0("0.5"), .a2d_v1("0.8"), .d2a_tr("100p")) (*
integer
library_binding = "ether";
 *)
I26 ( .QN( TAP4b ), .CK( IN[8] ), .D(
TAP[10] ), .RN( RSTb ), .Q( TAP[4] ) );
dffr_2x_hv #(.ieIO("output"), .d2a_tf("100p"), .d2a_vh("2.5"), .a2d_tx("100p"),
 .a2d_v1("0.8"), .a2d_v0("0.5"), .d2a_tr("100p")) (*
integer
library_binding = "ether";
 *)
I29 ( .QN( TAP[8] ), .CK( IN[5] ), .D(
TAP3b ), .RN( RSTb ), .Q( net036 ) );
dffr_2x_hv #(.ieIO("output"), .d2a_tf("100p"), .d2a_vh("2.5"), .a2d_tx("100p"),
 .a2d_v1("0.8"), .a2d_v0("0.5"), .d2a_tr("100p")) (*
integer
library_binding = "ether";
 *)
I28 ( .QN( TAP3b ), .CK( IN[6] ), .D(
TAP[9] ), .RN( RSTb ), .Q( TAP[3] ) );
dffr_2x_hv #(.ieIO("output"), .d2a_tf("100p"), .d2a_vh("2.5"), .a2d_tx("100p"),
 .a2d_v1("0.8"), .a2d_v0("0.5"), .d2a_tr("100p")) (*
integer
library_binding = "ether";
 *)
I20 ( .QN( net51 ), .CK( IN[0] ), .D(
TAP[6] ), .RN( RSTb ), .Q( TAP[0] ) );
dffr_2x_hv #(.ieIO("output"), .d2a_tf("100p"), .d2a_vh("2.5"), .a2d_tx("100p"),
 .a2d_v1("0.8"), .a2d_v0("0.5"), .d2a_tr("100p")) (*
integer
library_binding = "ether";
 *)
I21 ( .QN( TAP[6] ), .CK( IN[1] ), .D(
TAP1b ), .RN( RSTb ), .Q( net48 ) );

endmodule
