// Verilog-AMS netlist generated by the AMS netlister, version  IC6.1.5.500.7 .
// Cadence Design Systems, Inc.

`include "disciplines.vams"

(* cds_ams_schematic *)
module Analog_eq2 ( I_rext_100_1,I_rext_100_3,
timing_mode,I_rext_100_2,I_rext_100_4,dvdd,avdd,agc_eq,outp,dgnd,outm,
agc_eq_bypass,inm,fdbk_in,agnd,fdbk_out,siddq,Vref,inp );

input   I_rext_100_1;
input   I_rext_100_3;
input   timing_mode;

input   I_rext_100_2;
input   I_rext_100_4;
input   dvdd;
input
 avdd;
input [4:0]  agc_eq;
output   outp;
input   dgnd;
output
 outm;
input   agc_eq_bypass;
input   inm;
input   fdbk_in;
input
 agnd;
output   fdbk_out;
input   siddq;
input   Vref;
input   inp;

wire [4:0] gain_1p0;
wire [4:0] gain;
wire [4:0] agc_eq_tieoff;
wire [6:0] zero;
wire [1:0] pole;
wire [1:0] pole_1p0;
wire [6:0] zero_1p0;

parameter strobes_on="";

gpdk090_resnsppoly #(.r(9.99991K), .w(5u), .l(124.993u)) (*
integer
library_binding = "gpdk090";
 *)
R1 ( outm, fdbk_out, agnd );
gpdk090_resnsppoly #(.r(9.99991K), .w(5u), .l(124.993u)) (*
integer
library_binding = "gpdk090";
 *)
R2 ( fdbk_out, outp, agnd );

TIEHI (*
integer library_binding = "gsclib090";
integer cds_net_set
[0:1] = { "VSS","VDD" };
integer VSS = "dgnd";
integer VDD = "dvdd";

 *)
I111 ( .Y( agc_eq_tieoff[1] ) );

TIELO (*
integer library_binding = "gsclib090";
integer cds_net_set
[0:1] = { "VDD","VSS" };
integer VDD = "dvdd";
integer VSS = "dgnd";

 *)
I126 ( .Y( agc_eq_tieoff[4] ) );
TIELO (*
integer library_binding = "gsclib090";
integer cds_net_set
[0:1] = { "VSS","VDD" };
integer VSS = "dgnd";
integer VDD = "dvdd";

 *)
I125 ( .Y( agc_eq_tieoff[3] ) );
TIELO (*
integer library_binding = "gsclib090";
integer cds_net_set
[0:1] = { "VDD","VSS" };
integer VDD = "dvdd";
integer VSS = "dgnd";

 *)
I114 ( .Y( agc_eq_tieoff[2] ) );
TIELO (*
integer library_binding = "gsclib090";
integer cds_net_set
[0:1] = { "VSS","VDD" };
integer VSS = "dgnd";
integer VDD = "dvdd";

 *)
I113 ( .Y( agc_eq_tieoff[0] ) );

gpdk090_pmos2v #(.ad(6p), .pd(20.6u), .as(9p), .m(2 * 4), .ps(30.9u),
.w(20u), .l(280.0n)) (*
integer library_binding = "gpdk090";
integer
passed_mfactor = "m";
 *)
PM13 ( net233, siddq, Vref, avdd );
gpdk090_pmos2v #(.ad(4.8p), .pd(16.6u), .as(6p), .m(2 * 8), .ps(20.75u),
 .w(16u), .l(5u)) (*
integer library_binding = "gpdk090";
integer
passed_mfactor = "m";
 *)
PM2 ( net210, vbiasp2, avdd, avdd );
gpdk090_pmos2v #(.ad(3.4995p), .pd(12.265u), .as(6.999p), .m(1 * 2), .ps(24.53u),
 .w(11.665u), .l(280.0n)) (*
integer library_binding = "gpdk090";

integer passed_mfactor = "m";
 *)
PM8 ( agnd, net150, net303, net303 );
gpdk090_pmos2v #(.ad(3.4995p), .pd(12.265u), .as(6.999p), .m(1 * 2), .ps(24.53u),
 .w(11.665u), .l(280.0n)) (*
integer library_binding = "gpdk090";

integer passed_mfactor = "m";
 *)
PM11 ( agnd, net138, net210, net210 );
gpdk090_pmos2v #(.ad(4.48p), .pd(15.7333u), .as(4.48p), .m(8 * 3), .ps(15.7333u),
 .w(11.2u), .l(280.0n)) (*
integer library_binding = "gpdk090";

integer passed_mfactor = "m";
 *)
PM4 ( net150, vbiaspc, net301, avdd );
gpdk090_pmos2v #(.ad(4.48p), .pd(15.7333u), .as(4.48p), .m(8 * 3), .ps(15.7333u),
 .w(11.2u), .l(280.0n)) (*
integer library_binding = "gpdk090";

integer passed_mfactor = "m";
 *)
PM3 ( net138, vbiaspc, net297, avdd );
gpdk090_pmos2v #(.ad(2.88p), .pd(10.32u), .as(2.88p), .m(12 * 5), .ps(10.32u),
 .w(8u), .l(800n)) (*
integer library_binding = "gpdk090";
integer
passed_mfactor = "m";
 *)
PM1 ( net297, vbiasp, avdd, avdd );
gpdk090_pmos2v #(.ad(2.88p), .pd(10.32u), .as(2.88p), .m(12 * 5), .ps(10.32u),
 .w(8u), .l(800n)) (*
integer library_binding = "gpdk090";
integer
passed_mfactor = "m";
 *)
PM0 ( net301, vbiasp, avdd, avdd );
gpdk090_pmos2v #(.ad(4.8p), .pd(16.6u), .as(6p), .m(2 * 8), .ps(20.75u),
 .w(16u), .l(5u)) (*
integer library_binding = "gpdk090";
integer
passed_mfactor = "m";
 *)
PM5 ( net303, vbiasp2, avdd, avdd );

gpdk090_nmos2v #(.ad(699f), .pd(3.53u), .as(699f), .m(1 * 1), .ps(3.53u),
 .w(1.165u), .l(280.0n)) (*
integer library_binding = "gpdk090";

integer passed_mfactor = "m";
 *)
NM24 ( net138, siddq, agnd, agnd );
gpdk090_nmos2v #(.ad(3.584p), .pd(12.7467u), .as(3.584p), .m(4 * 3), .ps(12.7467u),
 .w(8.96u), .l(280.0n)) (*
integer library_binding = "gpdk090";

integer passed_mfactor = "m";
 *)
NM14 ( net150, vbiasnc, net182, agnd );
gpdk090_nmos2v #(.ad(3.584p), .pd(12.7467u), .as(3.584p), .m(4 * 3), .ps(12.7467u),
 .w(8.96u), .l(280.0n)) (*
integer library_binding = "gpdk090";

integer passed_mfactor = "m";
 *)
NM11 ( net138, vbiasnc, net190, agnd );
gpdk090_nmos2v #(.ad(699f), .pd(3.53u), .as(699f), .m(1 * 1), .ps(3.53u),
 .w(1.165u), .l(280.0n)) (*
integer library_binding = "gpdk090";

integer passed_mfactor = "m";
 *)
NM25 ( net150, siddq, agnd, agnd );
gpdk090_nmos2v #(.ad(699f), .pd(3.53u), .as(699f), .m(1 * 1), .ps(3.53u),
 .w(1.165u), .l(280.0n)) (*
integer library_binding = "gpdk090";

integer passed_mfactor = "m";
 *)
NM15 ( net313, siddq, agnd, agnd );
gpdk090_nmos2v #(.ad(1.5p), .pd(5.6u), .as(2.25p), .m(3 * 4), .ps(8.4u),
 .w(5u), .l(1u)) (*
integer library_binding = "gpdk090";
integer
passed_mfactor = "m";
 *)
NM8 ( outp, vbiasn2, agnd, agnd );
gpdk090_nmos2v #(.ad(12p), .pd(41.2u), .as(12p), .m(2 * 1), .ps(41.2u),
 .w(20u), .l(400n)) (*
integer library_binding = "gpdk090";
integer
passed_mfactor = "m";
 *)
NM6 ( avdd, net210, outp, agnd );
gpdk090_nmos2v #(.ad(1.5p), .pd(5.6u), .as(2.25p), .m(3 * 4), .ps(8.4u),
 .w(5u), .l(1u)) (*
integer library_binding = "gpdk090";
integer
passed_mfactor = "m";
 *)
NM7 ( outm, vbiasn2, agnd, agnd );
gpdk090_nmos2v #(.ad(12p), .pd(41.2u), .as(12p), .m(2 * 1), .ps(41.2u),
 .w(20u), .l(400n)) (*
integer library_binding = "gpdk090";
integer
passed_mfactor = "m";
 *)
NM5 ( avdd, net303, outm, agnd );
gpdk090_nmos2v #(.ad(7.5p), .pd(25.6u), .as(15p), .m(4 * 2), .ps(51.2u),
 .w(25u), .l(500n)) (*
integer library_binding = "gpdk090";
integer
passed_mfactor = "m";
 *)
NM9 ( net297, inm, Rminus, agnd );
gpdk090_nmos2v #(.ad(3p), .pd(10.6u), .as(6p), .m(3 * 2), .ps(21.2u),
.w(10u), .l(1u)) (*
integer library_binding = "gpdk090";
integer
passed_mfactor = "m";
 *)
NM3 ( Rplus, vbiasn3, agnd, agnd );
gpdk090_nmos2v #(.ad(3.6p), .pd(12.6u), .as(7.2p), .m(6 * 2), .ps(25.2u),
 .w(12u), .l(1u)) (*
integer library_binding = "gpdk090";
integer
passed_mfactor = "m";
 *)
NM17 ( net182, vbiasn, agnd, agnd );
gpdk090_nmos2v #(.ad(3p), .pd(10.6u), .as(6p), .m(3 * 2), .ps(21.2u),
.w(10u), .l(1u)) (*
integer library_binding = "gpdk090";
integer
passed_mfactor = "m";
 *)
NM2 ( Rminus, vbiasn3, agnd, agnd );
gpdk090_nmos2v #(.ad(3.6p), .pd(12.6u), .as(7.2p), .m(6 * 2), .ps(25.2u),
 .w(12u), .l(1u)) (*
integer library_binding = "gpdk090";
integer
passed_mfactor = "m";
 *)
NM10 ( net190, vbiasn, agnd, agnd );
gpdk090_nmos2v #(.ad(7.5p), .pd(25.6u), .as(15p), .m(4 * 2), .ps(51.2u),
 .w(25u), .l(500n)) (*
integer library_binding = "gpdk090";
integer
passed_mfactor = "m";
 *)
NM4 ( net301, inp, Rplus, agnd );

gpdk090_nmoscap2v #(.m(1 * 4), .w(6.415u), .l(6.435u)) (*
integer
library_binding = "gpdk090";
integer passed_mfactor = "m";
 *)
C0 (
agnd, net313, agnd, agnd );

analog_eq_cm_res (*
integer library_binding = "ether";
 *)
I42 ( .out(
net313 ), .gnd( agnd ), .vdd( net233 ) );

Analog_eq_bias (*
integer library_binding = "ether";
 *)
I95 ( .I_rext_100_1(
I_rext_100_1 ), .I_rext_100_3( I_rext_100_3 ), .I_rext_100_2(
I_rext_100_2 ), .vbiasn( vbiasn ), .I_rext_100_4( I_rext_100_4 ), .avdd(
avdd ), .Vbiasn3( vbiasn3 ), .Vbiasp2( vbiasp2 ), .vbiasn2( vbiasn2 ),
.vbiasp( vbiasp ), .agnd( agnd ), .siddq( siddq ), .vbiaspc( vbiaspc ),
.vbiasnc( vbiasnc ) );

AEQ_Dec #(.Vthr(1.0), .Vhigh(1), .Vlow(0)) (*
integer library_binding
 = "ether";
integer cds_net_set[0:1] = { "VDD","VSS" };
integer VDD
 = "dvdd";
integer VSS = "dgnd";
 *)
I96 ( .timing_mode( timing_mode ),
.gain( gain_1p0[4:0] ), .zero( zero_1p0[6:0] ), .pole( pole_1p0[1:0] ),
.agc_eq( agc_eq_tieoff[4:0] ), .agc_eq_bypass( agc_eq_bypass ) );

Analog_eq_pcaps_zero (*
integer library_binding = "ether";
 *)
I101 (
.zero( zero[6:0] ), .bot( Rminus ), .top( Rplus ), .gnd( agnd ), .vdd(
avdd ) );

Analog_eq_pole (*
integer library_binding = "ether";
 *)
I108 ( .plus(
net150 ), .pole( pole[1:0] ), .minus( net138 ), .gnd( agnd ), .vdd(
avdd ) );

Analog_eq_cmf (*
integer library_binding = "ether";
 *)
I100 ( .OutP1(
net182 ), .In_N( fdbk_in ), .OutP2( net190 ), .In_P( net313 ), .vbiasp(
vbiasp ), .siddq( siddq ), .gnd( agnd ), .vdd( avdd ) );

Analog_eq_gain (*
integer library_binding = "ether";
 *)
I94 ( .Rplus(
Rplus ), .gain( gain[4:0] ), .plus( net150 ), .minus( net138 ), .Rminus(
Rminus ), .gnd( agnd ) );

AEQ_lvlshft_1p0_to_2p5 #(.mag(0.5)) (*
integer library_binding
 = "ether";
 *)
I109 ( .VDD_1p0( dvdd ), .gain_2p5( gain[4:0] ), .gain_1p0(
gain_1p0[4:0] ), .pole_1p0( pole_1p0[1:0] ), .zero_1p0( zero_1p0[6:0] ),
.VDD_2p5( avdd ), .zero_2p5( zero[6:0] ), .VSS( dgnd ), .pole_2p5(
pole[1:0] ) );

capacitor #(.c(51f)) (*
integer library_binding = "analogLib";
 *)
C1
 ( Rplus, agnd );
capacitor #(.c(51f)) (*
integer library_binding = "analogLib";
 *)
C2
 ( Rminus, agnd );
capacitor #(.c(51f)) (*
integer library_binding = "analogLib";
 *)
C6
 ( net297, agnd );
capacitor #(.c(18f)) (*
integer library_binding = "analogLib";
 *)
C9
 ( net301, Rplus );
capacitor #(.c(18f)) (*
integer library_binding = "analogLib";
 *)
C10
 ( net297, Rminus );
capacitor #(.c(24f)) (*
integer library_binding = "analogLib";
 *)
C8
 ( net210, agnd );
capacitor #(.c(51f)) (*
integer library_binding = "analogLib";
 *)
C5
 ( net301, agnd );
capacitor #(.c(24f)) (*
integer library_binding = "analogLib";
 *)
C7
 ( net303, agnd );
capacitor #(.c(30f)) (*
integer library_binding = "analogLib";
 *)
C3
 ( net150, agnd );
capacitor #(.c(30f)) (*
integer library_binding = "analogLib";
 *)
C4
 ( net138, agnd );
capacitor #(.c(6f)) (*
integer library_binding = "analogLib";
 *)
C12
 ( net138, net297 );
capacitor #(.c(6f)) (*
integer library_binding = "analogLib";
 *)
C11
 ( net150, net301 );
capacitor #(.c(9f)) (*
integer library_binding = "analogLib";
 *)
C13
 ( net313, net182 );

endmodule
