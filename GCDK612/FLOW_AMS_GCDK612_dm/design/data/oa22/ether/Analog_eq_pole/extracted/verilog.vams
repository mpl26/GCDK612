// Verilog-AMS netlist generated by the AMS netlister, version IC6.1.3.500.15.
// Cadence Design Systems, Inc.

`include "disciplines.vams"

(* cds_ams_schematic *)
module Analog_eq_pole ( .gnd(vdd) );

inout   vdd;

gpdk090_nmos2v #(.ad(72.6f), .pd(1.01u), .as(72.6f), .m(1 * 1), .ps(1.01u),
 .w(1.1665e-05), .l(2.8e-07)) (*
integer library_binding = "gpdk090";

integer passed_mfactor = "m";
 *)
\+0  ( vdd, vdd, vdd, vdd );
gpdk090_nmos2v #(.ad(72.6f), .pd(1.01u), .as(72.6f), .m(1 * 1), .ps(1.01u),
 .w(1.1665e-05), .l(2.8e-07)) (*
integer library_binding = "gpdk090";

integer passed_mfactor = "m";
 *)
\+1  ( vdd, vdd, vdd, vdd );
gpdk090_nmos2v #(.ad(72.6f), .pd(1.01u), .as(72.6f), .m(1 * 1), .ps(1.01u),
 .w(1.1665e-05), .l(2.8e-07)) (*
integer library_binding = "gpdk090";

integer passed_mfactor = "m";
 *)
\+2  ( vdd, vdd, vdd, vdd );
gpdk090_nmos2v #(.ad(72.6f), .pd(1.01u), .as(72.6f), .m(1 * 1), .ps(1.01u),
 .w(1.1665e-05), .l(2.8e-07)) (*
integer library_binding = "gpdk090";

integer passed_mfactor = "m";
 *)
\+3  ( vdd, vdd, vdd, vdd );

gpdk090_pmos2v #(.ad(72.6f), .pd(1.01u), .as(72.6f), .m(1 * 1), .ps(1.01u),
 .w(1.165e-06), .l(2.8e-07)) (*
integer library_binding = "gpdk090";

integer passed_mfactor = "m";
 *)
\+4  ( vdd, vdd, vdd, vdd );
gpdk090_pmos2v #(.ad(72.6f), .pd(1.01u), .as(72.6f), .m(1 * 1), .ps(1.01u),
 .w(1.165e-06), .l(2.8e-07)) (*
integer library_binding = "gpdk090";

integer passed_mfactor = "m";
 *)
\+5  ( vdd, vdd, vdd, vdd );
gpdk090_pmos2v #(.ad(72.6f), .pd(1.01u), .as(72.6f), .m(1 * 1), .ps(1.01u),
 .w(1.165e-06), .l(2.8e-07)) (*
integer library_binding = "gpdk090";

integer passed_mfactor = "m";
 *)
\+6  ( vdd, vdd, vdd, vdd );
gpdk090_pmos2v #(.ad(72.6f), .pd(1.01u), .as(72.6f), .m(1 * 1), .ps(1.01u),
 .w(1.165e-06), .l(2.8e-07)) (*
integer library_binding = "gpdk090";

integer passed_mfactor = "m";
 *)
\+7  ( vdd, vdd, vdd, vdd );

gpdk090_pmoscap2v #(.m(1 * 1), .w(4.59e-06), .l(4.9e-06)) (*
integer
library_binding = "gpdk090";
integer passed_mfactor = "m";
 *)
\+15
 ( vdd, vdd, vdd, vdd );
gpdk090_pmoscap2v #(.m(1 * 1), .w(4.59e-06), .l(4.9e-06)) (*
integer
library_binding = "gpdk090";
integer passed_mfactor = "m";
 *)
\+14
 ( vdd, vdd, vdd, vdd );
gpdk090_pmoscap2v #(.m(1 * 1), .w(4.59e-06), .l(4.9e-06)) (*
integer
library_binding = "gpdk090";
integer passed_mfactor = "m";
 *)
\+13
 ( vdd, vdd, vdd, vdd );
gpdk090_pmoscap2v #(.m(1 * 1), .w(4.59e-06), .l(4.9e-06)) (*
integer
library_binding = "gpdk090";
integer passed_mfactor = "m";
 *)
\+12
 ( vdd, vdd, vdd, vdd );
gpdk090_pmoscap2v #(.m(1 * 1), .w(4.59e-06), .l(4.9e-06)) (*
integer
library_binding = "gpdk090";
integer passed_mfactor = "m";
 *)
\+11
 ( vdd, vdd, vdd, vdd );
gpdk090_pmoscap2v #(.m(1 * 1), .w(4.59e-06), .l(4.9e-06)) (*
integer
library_binding = "gpdk090";
integer passed_mfactor = "m";
 *)
\+10
 ( vdd, vdd, vdd, vdd );
gpdk090_pmoscap2v #(.m(1 * 1), .w(4.59e-06), .l(4.9e-06)) (*
integer
library_binding = "gpdk090";
integer passed_mfactor = "m";
 *)
\+9  (
vdd, vdd, vdd, vdd );
gpdk090_pmoscap2v #(.m(1 * 1), .w(4.59e-06), .l(4.9e-06)) (*
integer
library_binding = "gpdk090";
integer passed_mfactor = "m";
 *)
\+8  (
vdd, vdd, vdd, vdd );
gpdk090_pmoscap2v #(.m(1 * 1), .w(4.59e-06), .l(4.9e-06)) (*
integer
library_binding = "gpdk090";
integer passed_mfactor = "m";
 *)
\+16
 ( vdd, vdd, vdd, vdd );
gpdk090_pmoscap2v #(.m(1 * 1), .w(4.59e-06), .l(4.9e-06)) (*
integer
library_binding = "gpdk090";
integer passed_mfactor = "m";
 *)
\+35
 ( vdd, vdd, vdd, vdd );
gpdk090_pmoscap2v #(.m(1 * 1), .w(4.59e-06), .l(4.9e-06)) (*
integer
library_binding = "gpdk090";
integer passed_mfactor = "m";
 *)
\+34
 ( vdd, vdd, vdd, vdd );
gpdk090_pmoscap2v #(.m(1 * 1), .w(4.59e-06), .l(4.9e-06)) (*
integer
library_binding = "gpdk090";
integer passed_mfactor = "m";
 *)
\+33
 ( vdd, vdd, vdd, vdd );
gpdk090_pmoscap2v #(.m(1 * 1), .w(4.59e-06), .l(4.9e-06)) (*
integer
library_binding = "gpdk090";
integer passed_mfactor = "m";
 *)
\+32
 ( vdd, vdd, vdd, vdd );
gpdk090_pmoscap2v #(.m(1 * 1), .w(4.59e-06), .l(4.9e-06)) (*
integer
library_binding = "gpdk090";
integer passed_mfactor = "m";
 *)
\+31
 ( vdd, vdd, vdd, vdd );
gpdk090_pmoscap2v #(.m(1 * 1), .w(4.59e-06), .l(4.9e-06)) (*
integer
library_binding = "gpdk090";
integer passed_mfactor = "m";
 *)
\+30
 ( vdd, vdd, vdd, vdd );
gpdk090_pmoscap2v #(.m(1 * 1), .w(4.59e-06), .l(4.9e-06)) (*
integer
library_binding = "gpdk090";
integer passed_mfactor = "m";
 *)
\+29
 ( vdd, vdd, vdd, vdd );
gpdk090_pmoscap2v #(.m(1 * 1), .w(4.59e-06), .l(4.9e-06)) (*
integer
library_binding = "gpdk090";
integer passed_mfactor = "m";
 *)
\+28
 ( vdd, vdd, vdd, vdd );
gpdk090_pmoscap2v #(.m(1 * 1), .w(4.59e-06), .l(4.9e-06)) (*
integer
library_binding = "gpdk090";
integer passed_mfactor = "m";
 *)
\+27
 ( vdd, vdd, vdd, vdd );

gpdk090_pmoscap2v #(.m(1 * 1), .w(5.27e-06), .l(5.63e-06)) (*
integer
library_binding = "gpdk090";
integer passed_mfactor = "m";
 *)
\+19
 ( vdd, vdd, vdd, vdd );
gpdk090_pmoscap2v #(.m(1 * 1), .w(5.27e-06), .l(5.63e-06)) (*
integer
library_binding = "gpdk090";
integer passed_mfactor = "m";
 *)
\+18
 ( vdd, vdd, vdd, vdd );
gpdk090_pmoscap2v #(.m(1 * 1), .w(5.27e-06), .l(5.63e-06)) (*
integer
library_binding = "gpdk090";
integer passed_mfactor = "m";
 *)
\+17
 ( vdd, vdd, vdd, vdd );
gpdk090_pmoscap2v #(.m(1 * 1), .w(5.27e-06), .l(5.63e-06)) (*
integer
library_binding = "gpdk090";
integer passed_mfactor = "m";
 *)
\+26
 ( vdd, vdd, vdd, vdd );
gpdk090_pmoscap2v #(.m(1 * 1), .w(5.27e-06), .l(5.63e-06)) (*
integer
library_binding = "gpdk090";
integer passed_mfactor = "m";
 *)
\+25
 ( vdd, vdd, vdd, vdd );
gpdk090_pmoscap2v #(.m(1 * 1), .w(5.27e-06), .l(5.63e-06)) (*
integer
library_binding = "gpdk090";
integer passed_mfactor = "m";
 *)
\+24
 ( vdd, vdd, vdd, vdd );

gpdk090_pmoscap2v #(.m(1 * 1), .w(7.8e-07), .l(4.85e-07)) (*
integer
library_binding = "gpdk090";
integer passed_mfactor = "m";
 *)
\+21
 ( vdd, vdd, vdd, vdd );
gpdk090_pmoscap2v #(.m(1 * 1), .w(7.8e-07), .l(4.85e-07)) (*
integer
library_binding = "gpdk090";
integer passed_mfactor = "m";
 *)
\+22
 ( vdd, vdd, vdd, vdd );

gpdk090_pmoscap2v #(.m(1 * 1), .w(3.7e-06), .l(3.945e-06)) (*
integer
library_binding = "gpdk090";
integer passed_mfactor = "m";
 *)
\+20
 ( vdd, vdd, vdd, vdd );
gpdk090_pmoscap2v #(.m(1 * 1), .w(3.7e-06), .l(3.945e-06)) (*
integer
library_binding = "gpdk090";
integer passed_mfactor = "m";
 *)
\+23
 ( vdd, vdd, vdd, vdd );

endmodule
