// Verilog-AMS netlist generated by the AMS netlister, version  IC6.1.4.431 .
// Cadence Design Systems, Inc.

`include "disciplines.vams"

(* cds_ams_schematic *)
module and2_1x_hv ( Y,A,B );

output   Y;
input   A;
input   B;

wire (*
integer inh_conn_prop_name = "DVSS";
integer
inh_conn_def_value = "cds_globals.\\VSS! ";
 *)
\VSS! ;
wire (*
integer inh_conn_prop_name = "DVDD";
integer
inh_conn_def_value = "cds_globals.\\VDD! ";
 *)
\VDD! ;

gpdk090_pmos2v #(.ad(840f), .pd(4u), .as(840f), .m(1 * 1), .ps(4u), .w(1.4u),
 .l(280.0n)) (*
integer library_binding = "gpdk090";
integer
passed_mfactor = "m";
 *)
PM2 ( Y, net040, \VDD! , \VDD!  );
gpdk090_pmos2v #(.ad(840f), .pd(4u), .as(840f), .m(1 * 1), .ps(4u), .w(1.4u),
 .l(280.0n)) (*
integer library_binding = "gpdk090";
integer
passed_mfactor = "m";
 *)
PM1 ( net040, A, \VDD! , \VDD!  );
gpdk090_pmos2v #(.ad(840f), .pd(4u), .as(840f), .m(1 * 1), .ps(4u), .w(1.4u),
 .l(280.0n)) (*
integer library_binding = "gpdk090";
integer
passed_mfactor = "m";
 *)
PM0 ( net040, B, \VDD! , \VDD!  );

gpdk090_nmos2v #(.ad(472f), .pd(2.8u), .as(472f), .m(1 * 1), .ps(2.8u),
 .w(560n), .l(280.0n)) (*
integer library_binding = "gpdk090";

integer passed_mfactor = "m";
 *)
NM2 ( Y, net040, \VSS! , \VSS!  );
gpdk090_nmos2v #(.ad(672f), .pd(3.44u), .as(672f), .m(1 * 1), .ps(3.44u),
 .w(1.12u), .l(280.0n)) (*
integer library_binding = "gpdk090";

integer passed_mfactor = "m";
 *)
NM0 ( net28, B, \VSS! , \VSS!  );
gpdk090_nmos2v #(.ad(672f), .pd(3.44u), .as(672f), .m(1 * 1), .ps(3.44u),
 .w(1.12u), .l(280.0n)) (*
integer library_binding = "gpdk090";

integer passed_mfactor = "m";
 *)
NM1 ( net040, A, net28, \VSS!  );

endmodule
