// Verilog-AMS netlist generated by the AMS netlister, version  IC6.1.4.431 .
// Cadence Design Systems, Inc.

`include "disciplines.vams"

(* cds_ams_schematic *)
module clkbuf_1x_hv ( Y,A );

output   Y;
input   A;

wire (*
integer inh_conn_prop_name = "DVSS";
integer
inh_conn_def_value = "cds_globals.\\VSS! ";
 *)
\VSS! ;
wire (*
integer inh_conn_prop_name = "DVDD";
integer
inh_conn_def_value = "cds_globals.\\VDD! ";
 *)
\VDD! ;

gpdk090_pmos2v #(.ad(840f), .pd(4u), .as(840f), .m(1 * 1), .ps(4u), .w(1.4u),
 .l(280.0n)) (*
integer library_binding = "gpdk090";
integer
passed_mfactor = "m";
 *)
PM1 ( Y, net27, \VDD! , \VDD!  );
gpdk090_pmos2v #(.ad(525f), .pd(2.95u), .as(525f), .m(1 * 1), .ps(2.95u),
 .w(875n), .l(280.0n)) (*
integer library_binding = "gpdk090";

integer passed_mfactor = "m";
 *)
PM0 ( net27, A, \VDD! , \VDD!  );

gpdk090_nmos2v #(.ad(440f), .pd(2.8u), .as(440f), .m(1 * 1), .ps(2.8u),
 .w(400n), .l(280.0n)) (*
integer library_binding = "gpdk090";

integer passed_mfactor = "m";
 *)
NM0 ( net27, A, \VSS! , \VSS!  );
gpdk090_nmos2v #(.ad(472f), .pd(2.8u), .as(472f), .m(1 * 1), .ps(2.8u),
 .w(560n), .l(280.0n)) (*
integer library_binding = "gpdk090";

integer passed_mfactor = "m";
 *)
NM1 ( Y, net27, \VSS! , \VSS!  );

endmodule
