// Verilog-AMS netlist generated by the AMS netlister, version  IC6.1.4.431 .
// Cadence Design Systems, Inc.

`include "disciplines.vams"

(* cds_ams_schematic *)
module dff_1x_hv ( QN,CK,D,Q );

output   QN;
input   CK;
input   D;
output   Q;

wire (*
integer inh_conn_prop_name = "DVSS";
integer
inh_conn_def_value = "cds_globals.\\VSS! ";
 *)
\VSS! ;
wire (*
integer inh_conn_prop_name = "DVDD";
integer
inh_conn_def_value = "cds_globals.\\VDD! ";
 *)
\VDD! ;

gpdk090_pmos2v #(.ad(840f), .pd(4u), .as(840f), .m(1 * 1), .ps(4u), .w(1.4u),
 .l(280.0n)) (*
integer library_binding = "gpdk090";
integer
passed_mfactor = "m";
 *)
PM2 ( clk, clkb, \VDD! , \VDD!  );
gpdk090_pmos2v #(.ad(840f), .pd(4u), .as(840f), .m(1 * 1), .ps(4u), .w(1.4u),
 .l(280.0n)) (*
integer library_binding = "gpdk090";
integer
passed_mfactor = "m";
 *)
PM11 ( net69, clk, net0225, \VDD!  );
gpdk090_pmos2v #(.ad(840f), .pd(4u), .as(840f), .m(1 * 1), .ps(4u), .w(1.4u),
 .l(280.0n)) (*
integer library_binding = "gpdk090";
integer
passed_mfactor = "m";
 *)
PM12 ( net0225, net0258, \VDD! , \VDD!  );
gpdk090_pmos2v #(.ad(840f), .pd(4u), .as(840f), .m(1 * 1), .ps(4u), .w(1.4u),
 .l(280.0n)) (*
integer library_binding = "gpdk090";
integer
passed_mfactor = "m";
 *)
PM9 ( Q, net0258, \VDD! , \VDD!  );
gpdk090_pmos2v #(.ad(840f), .pd(4u), .as(840f), .m(1 * 1), .ps(4u), .w(1.4u),
 .l(280.0n)) (*
integer library_binding = "gpdk090";
integer
passed_mfactor = "m";
 *)
PM10 ( QN, Q, \VDD! , \VDD!  );
gpdk090_pmos2v #(.ad(840f), .pd(4u), .as(840f), .m(1 * 1), .ps(4u), .w(1.4u),
 .l(280.0n)) (*
integer library_binding = "gpdk090";
integer
passed_mfactor = "m";
 *)
PM8 ( net0258, net69, \VDD! , \VDD!  );
gpdk090_pmos2v #(.ad(840f), .pd(4u), .as(840f), .m(1 * 1), .ps(4u), .w(1.4u),
 .l(280.0n)) (*
integer library_binding = "gpdk090";
integer
passed_mfactor = "m";
 *)
PM7 ( net53, clkb, net60, \VDD!  );
gpdk090_pmos2v #(.ad(840f), .pd(4u), .as(840f), .m(1 * 1), .ps(4u), .w(1.4u),
 .l(280.0n)) (*
integer library_binding = "gpdk090";
integer
passed_mfactor = "m";
 *)
PM6 ( net60, net49, \VDD! , \VDD!  );
gpdk090_pmos2v #(.ad(840f), .pd(4u), .as(840f), .m(1 * 1), .ps(4u), .w(1.4u),
 .l(280.0n)) (*
integer library_binding = "gpdk090";
integer
passed_mfactor = "m";
 *)
PM5 ( net69, clkb, net49, \VDD!  );
gpdk090_pmos2v #(.ad(840f), .pd(4u), .as(840f), .m(1 * 1), .ps(4u), .w(1.4u),
 .l(280.0n)) (*
integer library_binding = "gpdk090";
integer
passed_mfactor = "m";
 *)
PM4 ( net49, net53, \VDD! , \VDD!  );
gpdk090_pmos2v #(.ad(840f), .pd(4u), .as(840f), .m(1 * 1), .ps(4u), .w(1.4u),
 .l(280.0n)) (*
integer library_binding = "gpdk090";
integer
passed_mfactor = "m";
 *)
PM3 ( net53, clk, net65, \VDD!  );
gpdk090_pmos2v #(.ad(840f), .pd(4u), .as(840f), .m(1 * 1), .ps(4u), .w(1.4u),
 .l(280.0n)) (*
integer library_binding = "gpdk090";
integer
passed_mfactor = "m";
 *)
PM1 ( clkb, CK, \VDD! , \VDD!  );
gpdk090_pmos2v #(.ad(840f), .pd(4u), .as(840f), .m(1 * 1), .ps(4u), .w(1.4u),
 .l(280.0n)) (*
integer library_binding = "gpdk090";
integer
passed_mfactor = "m";
 *)
PM0 ( net65, D, \VDD! , \VDD!  );

gpdk090_nmos2v #(.ad(472f), .pd(2.8u), .as(472f), .m(1 * 1), .ps(2.8u),
 .w(560n), .l(280.0n)) (*
integer library_binding = "gpdk090";

integer passed_mfactor = "m";
 *)
NM0 ( net65, D, \VSS! , \VSS!  );
gpdk090_nmos2v #(.ad(472f), .pd(2.8u), .as(472f), .m(1 * 1), .ps(2.8u),
 .w(560n), .l(280.0n)) (*
integer library_binding = "gpdk090";

integer passed_mfactor = "m";
 *)
NM4 ( net49, net53, \VSS! , \VSS!  );
gpdk090_nmos2v #(.ad(472f), .pd(2.8u), .as(472f), .m(1 * 1), .ps(2.8u),
 .w(560n), .l(280.0n)) (*
integer library_binding = "gpdk090";

integer passed_mfactor = "m";
 *)
NM12 ( net0225, net0258, \VSS! ,
\VSS!  );
gpdk090_nmos2v #(.ad(472f), .pd(2.8u), .as(472f), .m(1 * 1), .ps(2.8u),
 .w(560n), .l(280.0n)) (*
integer library_binding = "gpdk090";

integer passed_mfactor = "m";
 *)
NM11 ( net69, clkb, net0225, \VSS!  );
gpdk090_nmos2v #(.ad(472f), .pd(2.8u), .as(472f), .m(1 * 1), .ps(2.8u),
 .w(560n), .l(280.0n)) (*
integer library_binding = "gpdk090";

integer passed_mfactor = "m";
 *)
NM9 ( Q, net0258, \VSS! , \VSS!  );
gpdk090_nmos2v #(.ad(472f), .pd(2.8u), .as(472f), .m(1 * 1), .ps(2.8u),
 .w(560n), .l(280.0n)) (*
integer library_binding = "gpdk090";

integer passed_mfactor = "m";
 *)
NM8 ( net0258, net69, \VSS! , \VSS!  );
gpdk090_nmos2v #(.ad(472f), .pd(2.8u), .as(472f), .m(1 * 1), .ps(2.8u),
 .w(560n), .l(280.0n)) (*
integer library_binding = "gpdk090";

integer passed_mfactor = "m";
 *)
NM10 ( QN, Q, \VSS! , \VSS!  );
gpdk090_nmos2v #(.ad(472f), .pd(2.8u), .as(472f), .m(1 * 1), .ps(2.8u),
 .w(560n), .l(280.0n)) (*
integer library_binding = "gpdk090";

integer passed_mfactor = "m";
 *)
NM7 ( net53, clk, net60, \VSS!  );
gpdk090_nmos2v #(.ad(472f), .pd(2.8u), .as(472f), .m(1 * 1), .ps(2.8u),
 .w(560n), .l(280.0n)) (*
integer library_binding = "gpdk090";

integer passed_mfactor = "m";
 *)
NM6 ( net60, net49, \VSS! , \VSS!  );
gpdk090_nmos2v #(.ad(472f), .pd(2.8u), .as(472f), .m(1 * 1), .ps(2.8u),
 .w(560n), .l(280.0n)) (*
integer library_binding = "gpdk090";

integer passed_mfactor = "m";
 *)
NM5 ( net69, clk, net49, \VSS!  );
gpdk090_nmos2v #(.ad(472f), .pd(2.8u), .as(472f), .m(1 * 1), .ps(2.8u),
 .w(560n), .l(280.0n)) (*
integer library_binding = "gpdk090";

integer passed_mfactor = "m";
 *)
NM3 ( net53, clkb, net65, \VSS!  );
gpdk090_nmos2v #(.ad(472f), .pd(2.8u), .as(472f), .m(1 * 1), .ps(2.8u),
 .w(560n), .l(280.0n)) (*
integer library_binding = "gpdk090";

integer passed_mfactor = "m";
 *)
NM2 ( clk, clkb, \VSS! , \VSS!  );
gpdk090_nmos2v #(.ad(472f), .pd(2.8u), .as(472f), .m(1 * 1), .ps(2.8u),
 .w(560n), .l(280.0n)) (*
integer library_binding = "gpdk090";

integer passed_mfactor = "m";
 *)
NM1 ( clkb, CK, \VSS! , \VSS!  );

endmodule
