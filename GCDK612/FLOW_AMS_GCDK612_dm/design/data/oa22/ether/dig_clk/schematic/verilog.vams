// Verilog-AMS netlist generated by the AMS netlister, version 5.10.41.500.1.11.
// Cadence Design Systems, Inc.

`include "disciplines.vams"

module dig_clk ( RX10_RCLK2_5,MR_100MBS,CLKXTAL,RCLK2_5_GOOD,X_125,
X_160,RX100_RCLK25,RCLK25_GOOD,AN_ACTIVE_XTND,RESET,RPD_10_DISB,
RPD_100_DISB,RESETREG,RESETPLL,CLKPLL_IN,LINK10_DOWN,LINK100_DOWN,
MR_AN_ENAB,CLKPLL_SC,clk160_enable,clk160n_enable,clk12_5_enable,
clk10_enable,clk10n_enable,RCLK2_5_SC,RXC_SC,clk125_enable,clk125_disb,
CLKFAST_SC,clkfast_enable,clkfastd8_enable,clkfastd8_gate,TXC_O_SC,
TXC25_SC,txc25_enable,txc25n_enable,TXC25_ALIGN,txc2_5_enable,
txc2_5n_enable,CLK2_5_NO_FF,MR_PLL_LOCKED,XOFF_20,BASE10_DIS,
BASE100TX_DIS,BASE100TX_DIS_ER,scan_reset,SCAN_MODE,scan_setinv,
scan_resetinv,scan_in1,scan_out1,scan_in2,scan_out2,SCAN_ENABLE,
scan_in3,scan_out3,scan_in4,scan_out4 );

input   RX10_RCLK2_5;
input   MR_100MBS;
input   CLKXTAL;
input
 RCLK2_5_GOOD;
input   X_125;
input   X_160;
input   RX100_RCLK25;

input   RCLK25_GOOD;
input   AN_ACTIVE_XTND;
input   RESET;
input
 RPD_10_DISB;
input   RPD_100_DISB;
input   RESETREG;
input
 RESETPLL;
input   CLKPLL_IN;
input   LINK10_DOWN;
input
 LINK100_DOWN;
input   MR_AN_ENAB;
output   CLKPLL_SC;
output
 clk160_enable;
output   clk160n_enable;
output   clk12_5_enable;

output   clk10_enable;
output   clk10n_enable;
output   RCLK2_5_SC;

output   RXC_SC;
output   clk125_enable;
output   clk125_disb;

output   CLKFAST_SC;
output   clkfast_enable;
output
 clkfastd8_enable;
output   clkfastd8_gate;
output   TXC_O_SC;

output   TXC25_SC;
output   txc25_enable;
output   txc25n_enable;

output   TXC25_ALIGN;
output   txc2_5_enable;
output
 txc2_5n_enable;
output   CLK2_5_NO_FF;
output   MR_PLL_LOCKED;

output   XOFF_20;
output   BASE10_DIS;
output   BASE100TX_DIS;

output   BASE100TX_DIS_ER;
input   scan_reset;
input   SCAN_MODE;

input   scan_setinv;
input   scan_resetinv;
input   scan_in1;
output
 scan_out1;
input   scan_in2;
output   scan_out2;
input
 SCAN_ENABLE;
input   scan_in3;
output   scan_out3;
input   scan_in4;

output   scan_out4;

wire n_492;
wire n_6541;
wire n_6321;
wire n_2008;
wire n_14083;
wire n_2736;
wire Flag_in_to_rec;
wire n_294;
wire prev1xtal_10disb;
wire prev3_cont2_5;
wire n_13779;
wire prev2pll_10disb;
wire net57;
wire n_13931;
wire BASE100TX_DIS;
wire n_14283;
wire prev1_rx10_rclk2_5;
wire prev_x160_sel_pos;
wire net22;
wire n_297;
wire [1:0] sync_all_disb_plln;
wire n_457;
wire net77;
wire rclk2_5_good;
wire n_6485;
wire n_581;
wire n_232;
wire n_6592;
wire net116;
wire net49;
wire n_389;
wire net107;
wire prev3xtal_100disb;
wire n_458;
wire scan_setinv;
wire [6:0] time_reset_pc;
wire net109;
wire net141;
wire net147;
wire n_12;
wire n_6457;
wire net140;
wire count125_5_;
wire n_6864;
wire n_2011;
wire scan_out3;
wire count125_1_;
wire n_12886;
wire n_2016;
wire [1:0] pll160_locked_plln;
wire n_1399;
wire rclk2_5_good_edge;
wire net40;
wire n_6830;
wire n_6315;
wire n_2017;
wire scan_out1;
wire n_251;
wire txc_disb;
wire n_464;
wire net34;
wire n_1955;
wire net5;
wire n_6665;
wire [9:0] time_count;
wire prev1_clk25;
wire n_7;
wire n_181;
wire n_274;
wire net55;
wire n_291;
wire genplld5_enable;
wire net127;
wire n_1256;
wire net130;
wire n_6801;
wire n_899;
wire n_318;
wire nbus_1089_0_8265;
wire n_27416;
wire n_12991;
wire CLKPLL_SC;
wire n_13930;
wire [1:0] pll125_locked_pll;
wire clk160n_enable;
wire n_6349;
wire prev1_rpd100tx_disb;
wire n_1692;
wire pll160_locked_pos;
wire n_13068;
wire prev1pll_10disb;
wire n_2056;
wire n_13291;
wire cnt160_next_3f;
wire n_500;
wire net88;
wire net44;
wire net43;
wire net64;
wire n_2030;
wire n_381;
wire net20;
wire nbus_1100_9_;
wire n_499;
wire net131;
wire n_262;
wire net93;
wire prev3xtal_10disb;
wire RESETPLL;
wire n_12920;
wire n_431;
wire n_273;
wire n_299;
wire n_495;
wire txc25_disb;
wire net132;
wire net74;
wire res_rclk2_5_good_edge;
wire Flag10_to_100;
wire n_478;
wire n_269;
wire [1:0] meta_rclk2_5;
wire n_383;
wire net47;
wire net84;
wire tie_lo;
wire n_61;
wire n_2061;
wire n_2054;
wire n_6496;
wire n_2299;
wire cnt125_at_49;
wire n_512;
wire n_2018;
wire n_2146;
wire nbus_1100_2_;
wire n_13533;
wire n_331;
wire n_249;
wire n_149;
wire clk125_enable_int;
wire n_6868;
wire n_263;
wire sqw25n;
wire n_12981;
wire n_6529;
wire nbus_1100_8_;
wire n_2286;
wire nbus_1111_0_;
wire n_364;
wire prev_x125_sel_2_;
wire txc25ena_pos;
wire n_13026;
wire n_535;
wire n_13535;
wire RX10_RCLK2_5;
wire net7;
wire RESET;
wire X_160;
wire n_10;
wire n_13414;
wire prev2pll_100disb;
wire n_415;
wire net39;
wire n_19;
wire n_62;
wire n_450;
wire n_8;
wire n_130468256;
wire n_6341;
wire prev1_mr100;
wire n_532;
wire n_6738;
wire n_348;
wire prev1pll_100disb;
wire n_418;
wire n_2284;
wire n_564;
wire n_510;
wire net6;
wire net117;
wire n_6769;
wire n_1928;
wire n_6563;
wire MR_PLL_LOCKED;
wire net154;
wire n_367;
wire n_406;
wire n_422;
wire net143;
wire net70;
wire n_14146;
wire selorlocked125;
wire net81;
wire n_504;
wire net136;
wire net38;
wire n_6715;
wire n_13266;
wire net28;
wire n_1684;
wire n_462;
wire n_2029;
wire n_14031;
wire clk125_disb;
wire sqw25_125;
wire n_2301;
wire cnt125_at_1;
wire n_258;
wire net124;
wire n_426;
wire n_576;
wire n_13027;
wire net31;
wire n_534;
wire net123;
wire tie_hi;
wire n_130028259;
wire n_518;
wire n_6;
wire net75;
wire n_6652;
wire n_354;
wire n_9;
wire selorlocked160;
wire n_13548;
wire n_417;
wire n_433;
wire n_64;
wire net68;
wire prev_b100txdis_xtal_0_;
wire net119;
wire n_517;
wire n_26515;
wire net54;
wire X_125;
wire n_574;
wire clk12_5_ctrl;
wire prev1_cont2_5;
wire prev2xtal_100disb;
wire prev1_rpd10_disb;
wire n_13250;
wire net89;
wire res_rclk25_edge;
wire count125_2_;
wire n_440;
wire n_6646;
wire prev2_rx10_rclk2_5;
wire n_2024;
wire net35;
wire n_575;
wire n_6535;
wire n_12956;
wire n_385;
wire n_14337;
wire nbus_1100_6_;
wire n_710;
wire n_13050;
wire n_227;
wire Flag_rec_to_in;
wire n_1696;
wire n_6575;
wire n_1396;
wire net149;
wire net14;
wire cnt160_at_1f_pos;
wire net144;
wire n_39;
wire n_13029;
wire n_6323;
wire n_13966;
wire n_6621;
wire [1:0] pll125_status;
wire net25;
wire n_501;
wire net61;
wire xoff_20_pc_0_;
wire n_2009;
wire n_246;
wire n_536;
wire n_6505;
wire n_6383;
wire n_288;
wire n_276;
wire n_334;
wire n_519;
wire net90;
wire net139;
wire n_425;
wire net125;
wire n_403;
wire scan_resetinv;
wire n_13526;
wire n_6523;
wire n_6393;
wire [1:0] meta_rpd_10_disb;
wire n_305;
wire n_361;
wire n_6347;
wire n_571;
wire n_188;
wire prev3_rpd100tx_disb;
wire count125_4_;
wire n_427;
wire n_12910;
wire net146;
wire n_578;
wire nbus_1115_3_;
wire n_12980;
wire n_284;
wire net97;
wire n_6493;
wire n_283;
wire scan_out4;
wire net12;
wire net80;
wire net95;
wire count125_3_;
wire time_reset_xc_0_;
wire n_6649;
wire n_2006;
wire mr_txc2_5_pd_pll;
wire prev2_rpd10_disb;
wire n_6717;
wire n_13538;
wire n_129138266;
wire n_237;
wire net129;
wire n_2223;
wire n_13639;
wire net9;
wire net19;
wire net102;
wire Flag_rclk2_5_int_to_ext;
wire n_13358;
wire n_238;
wire [1:0] nbus_1109;
wire n_265;
wire n_12985;
wire n_6581;
wire net100;
wire n_432;
wire x125_sel_sync1;
wire n_6659;
wire net16;
wire n_6706;
wire n_981;
wire n_550;
wire net134;
wire n_13534;
wire net30;
wire n_6624;
wire n_436;
wire n_14294;
wire n_2305;
wire n_2309;
wire LINK100_DOWN;
wire nbus_1100_3_;
wire n_6781;
wire n_572;
wire net153;
wire n_6709;
wire n_1909;
wire n_502;
wire n_520;
wire n_300;
wire n_398;
wire [1:0] nbus_1106;
wire n_395;
wire n_261;
wire nbus_1100_4_;
wire cnt160_at_0_pos;
wire x125_sel;
wire net152;
wire cnt125_at_4;
wire prev_x160_sel_7_pll;
wire net46;
wire n_12957;
wire net8;
wire clkfastd8_gate;
wire n_346;
wire net106;
wire n_2028;
wire MR_AN_ENAB;
wire n_13537;
wire n_6842;
wire n_1151;
wire RCLK2_5_GOOD;
wire n_6532;
wire rxc_sel;
wire CLKFAST_SC;
wire n_546;
wire n_6882;
wire net103;
wire n_6880;
wire SCAN_MODE;
wire TXC25_SC;
wire n_1446;
wire n_1688;
wire xoff_20;
wire n_13839;
wire n_6384;
wire net122;
wire LINK10_DOWN;
wire n_401;
wire n_1711;
wire rclk25_sync1;
wire [1:0] sync_all_disb_pll;
wire net13;
wire n_1939;
wire n_6671;
wire n_6860;
wire n_13929;
wire n_1905;
wire n_277;
wire n_2346;
wire RESETREG;
wire n_6454;
wire net58;
wire n_330;
wire n_5;
wire n_2210;
wire RCLK2_5_SC;
wire n_6511;
wire res_x125_edge;
wire n_6844;
wire n_2010;
wire n_292;
wire n_6385;
wire n_6679;
wire n_2027;
wire n_6589;
wire n_2;
wire n_14379;
wire BASE100TX_DIS_ER;
wire clk10n_enable;
wire n_14285;
wire net86;
wire n_14039;
wire n_275;
wire cont2_5_edge;
wire net33;
wire n_13532;
wire n_6373;
wire net137;
wire n_1512;
wire n_6526;
wire net148;
wire n_2023;
wire cont2_5_sel;
wire n_463;
wire n_14131;
wire n_302;
wire net59;
wire net121;
wire clk160_enable;
wire n_304;
wire [1:0] pll125_locked_plln;
wire n_14069;
wire n_2013;
wire n_2057;
wire n_99;
wire cnt125_at_24;
wire n_13539;
wire fastcount_7;
wire net101;
wire n_2143;
wire sync2_rclk2_5_good_pll;
wire net32;
wire slvtxc2_5_pd;
wire prev2_clk25;
wire n_13545;
wire n_479;
wire clk10_enable;
wire cnt160_at_3e;
wire prev3_rpd10_disb;
wire n_4397;
wire n_98;
wire n_465;
wire n_6617;
wire n_449;
wire n_522;
wire n_13530;
wire net126;
wire n_6843;
wire txc25_enable;
wire n_78310;
wire net105;
wire n_430;
wire net67;
wire n_392;
wire n_434;
wire n_2113;
wire n_6847;
wire n_6569;
wire n_6371;
wire sqw2_5_125;
wire [1:0] pll160_status;
wire n_407;
wire n_13547;
wire n_13030;
wire net10;
wire nbus_1115_0_;
wire n_351;
wire n_6854;
wire n_78342;
wire net96;
wire x125_sel_sync3;
wire n_487;
wire net85;
wire n_6856;
wire n_382;
wire n_482;
wire BASE10_DIS;
wire prev2xtal_10disb;
wire txc2_5_enable;
wire net50;
wire n_3;
wire n_129698261;
wire net145;
wire net29;
wire n_1257;
wire n_2144;
wire net53;
wire n_333;
wire scan_in1;
wire [1:0] an_link_down_plln;
wire n_13622;
wire n_2031;
wire n_474;
wire n_13098;
wire n_12834;
wire count125_6_;
wire net91;
wire n_2311;
wire n_324;
wire n_1997;
wire n_13025;
wire prev_x160_sel_6_;
wire n_135;
wire net51;
wire n_374;
wire clk125_enable;
wire n_2292;
wire n_270;
wire n_413;
wire n_13540;
wire count125_0_;
wire n_6875;
wire n_11;
wire clkfastd8_enable;
wire cont2_5_disb;
wire n_13003;
wire n_397;
wire net78;
wire n_2021;
wire n_2294;
wire n_349;
wire n_13230;
wire n_130248254;
wire n_530;
wire n_526;
wire n_544;
wire n_6377;
wire n_416;
wire n_393;
wire cnt125_at_8;
wire nbus_1115_4_;
wire n_130678255;
wire net37;
wire n_515;
wire net4;
wire n_437;
wire n_14343;
wire n_281;
wire cnt125_at_9;
wire net76;
wire x125_sel_sync2;
wire n_6343;
wire n_2012;
wire rclk25_disb;
wire n_13529;
wire n_278;
wire n_219;
wire cnt125_at_9_pos;
wire clk160_enable_int;
wire txc_sel;
wire net150;
wire n_6459;
wire n_1201;
wire net71;
wire net108;
wire n_1926;
wire n_6668;
wire n_14387;
wire net42;
wire n_2290;
wire n_327;
wire n_2026;
wire n_6870;
wire nbus_1114_1_;
wire n_424;
wire n_2145;
wire CLK2_5_NO_FF;
wire net133;
wire net23;
wire n_6329;
wire n_6764;
wire CLKXTAL;
wire n_271;
wire RXC_SC;
wire net113;
wire n_272;
wire RX100_RCLK25;
wire scan_reset;
wire AN_ACTIVE_XTND;
wire n_6335;
wire net92;
wire RCLK25_GOOD;
wire n_2015;
wire n_13785;
wire n_6365;
wire rclk2_5_good_pll;
wire scan_in2;
wire net138;
wire rxc_disb;
wire n_13;
wire n_368;
wire n_12941;
wire n_6834;
wire n_6615;
wire n_6677;
wire n_134;
wire rclk25_sel;
wire MR_100MBS;
wire n_6359;
wire net99;
wire n_14445;
wire net104;
wire n_375;
wire n_13541;
wire cnt160_at_8_pos;
wire n_405;
wire txc2_5_disb;
wire [1:0] pll160_locked_pll;
wire n_384;
wire n_6712;
wire n_1907;
wire net11;
wire n_2132;
wire net115;
wire n_6865;
wire n_435;
wire n_229;
wire n_268;
wire n_13049;
wire n_2055;
wire net17;
wire n_438;
wire n_452;
wire net135;
wire n_63;
wire n_380;
wire n_182;
wire net111;
wire n_6631;
wire n_6379;
wire net87;
wire n_13544;
wire n_2020;
wire n_390;
wire n_371;
wire n_557;
wire n_466;
wire clkfast_enable;
wire n_2298;
wire prev_b10dis_xtal_0_;
wire n_321;
wire n_391;
wire prev1xtal_100disb;
wire n_394;
wire n_408;
wire n_38;
wire n_6361;
wire n_6367;
wire net98;
wire net83;
wire scan_in4;
wire prev2_rpd100tx_disb;
wire n_1694;
wire n_6309;
wire n_6643;
wire n_339;
wire n_12973;
wire n_6680;
wire net27;
wire n_2014;
wire n_412;
wire n_2154;
wire net128;
wire n_2007;
wire rclk2_5_disb;
wire n_6332;
wire n_1129;
wire net26;
wire n_6735;
wire n_130008257;
wire cnt125_at_3;
wire n_218;
wire n_12968;
wire n_6353;
wire net72;
wire time_reset;
wire net41;
wire time_reset_xc_1_;
wire n_399;
wire clk160_disb;
wire CLKPLL_IN;
wire XOFF_20;
wire net73;
wire n_402;
wire n_560;
wire n_129688264;
wire n_485;
wire net110;
wire n_342;
wire n_13933;
wire net45;
wire Flag_rclk2_5_ext_to_int;
wire n_2022;
wire n_2352;
wire n_13052;
wire n_13039;
wire prev_rclk25_good;
wire n_580;
wire n_316;
wire net112;
wire n_41;
wire n_423;
wire n_183;
wire n_116;
wire prev2_5_mr100;
wire sqw25_sync1;
wire net21;
wire n_2025;
wire prev3_rx10_rclk2_5;
wire net52;
wire SCAN_ENABLE;
wire txc2_5n_enable;
wire n_362;
wire twenty_us_expired;
wire x125_edge;
wire net69;
wire net118;
wire n_6718;
wire n_2019;
wire n_1976;
wire n_6761;
wire nbus_1100_0_;
wire net65;
wire RPD_100_DISB;
wire clk12_5_enable;
wire net15;
wire n_527;
wire n_15822;
wire n_13174;
wire n_2307;
wire net36;
wire n_541;
wire net114;
wire n_414;
wire rclk25_good_edge;
wire prev2_mr100;
wire n_6355;
wire n_6833;
wire net24;
wire cnt160_at_3f_pos;
wire scan_in3;
wire cnt125_at_6;
wire n_6836;
wire n_314;
wire n_18;
wire [2:0] fastcount;
wire [5:0] count160;
wire net142;
wire n_2059;
wire n_157;
wire net18;
wire net56;
wire n_3409;
wire nbus_1104_0_;
wire net1;
wire n_561;
wire net60;
wire n_2060;
wire n_6866;
wire n_410;
wire slvtxc25_pd;
wire n_12888;
wire nbus_1089_0_;
wire n_13051;
wire net66;
wire n_404;
wire n_420;
wire scan_out2;
wire prev_b10dis_xtal_1_;
wire n_129828262;
wire RPD_10_DISB;
wire n_14265;
wire TXC_O_SC;
wire n_555;
wire net94;
wire n_312;
wire n_419;
wire TXC25_ALIGN;
wire net63;
wire n_60;
wire n_129988258;
wire n_6337;
wire txc25n_enable;
wire sqw25p;
wire n_14816;
wire n_2283;
wire net79;
wire net82;
wire nbus_1107_0_;
wire clk160_disb_pll;
wire [1:0] twenty_us_exp_xtal;
wire n_13243;
wire n_14463;
wire n_130978267;
wire n_2058;
wire n_6818;
wire n_130288263;
wire prev2_cont2_5;
wire n_206;
wire net151;
wire n_19560;
wire net48;
wire Flag100_to_10;
wire nbus_1110_1_;
wire net62;
wire fastcount_5;
wire n_12970;
wire nbus_1100_7_;
wire n_264;
wire sync1_rclk2_5_good_pll;

dig_clk_pll_sel (*
integer library_binding = "ether";
 *)

i_dig_clk_pll_sel ( .scan_setinv( n_1907 ), .scan_resetinv(
scan_resetinv ), .x160_sel( net_5618 ), .X_160( X_160 ), .scan_out2(
scan_out4 ), .CLKPLL_SC( CLKPLL_SC ), .SCAN_MODE( n_1446 ), .SCAN_ENABLE(
n_1257 ), .RPD_10_DISB( RPD_10_DISB ), .pll125_locked(
pll125_status[1] ), .prev_x160_sel( { n_12945,
prev_x160_sel_6_,prev_x160_sel_5_,prev_x160_sel_4_,prev_x160_sel_3_,
prev_x160_sel_2_,prev_x160_sel_1_,prev_x160_sel_0_ } ), .scan_in2(
net145 ), .all_disb( nbus_1089_0_ ), .RPD_100_DISB( RPD_100_DISB ), .scan_in1(
net124 ), .RESETPLL( RESETPLL ), .prev_x125_sel( { n_13227,
prev_x125_sel_6_,prev_x125_sel_5_,prev_x125_sel_4_,prev_x125_sel_3_,
prev_x125_sel_2_,prev_x125_sel_1_,prev_x125_sel_0_ } ), .X_125( X_125 ),
.RESETREG( RESETREG ), .scan_out1( scan_out3 ), .x125_sel( x125_sel ),
.pll160_locked( pll160_status[1] ) );

TIELO (*
integer library_binding = "gsclib090";
 *)
i_TIELO ( .Y(
tie_lo ) );

TIEHI (*
integer library_binding = "gsclib090";
 *)
i_TIEHI ( .Y(
tie_hi ) );

BUFX4 (*
integer library_binding = "gsclib090";
 *)
i_13066 ( .Y(
n_14816 ), .A( n_4397 ) );

BUFX6 (*
integer library_binding = "gsclib090";
 *)
i_367 ( .Y( n_281 ),
.A( RX100_RCLK25 ) );

MXI2X6 (*
integer library_binding = "gsclib090";
 *)
i_344 ( .Y( n_463 ),
.S0( rclk25_sel ), .B( n_206 ), .A( n_899 ) );

SDFFNSRX2 (*
integer library_binding = "gsclib090";
 *)

cnt125_at_8_reg ( .CKN( CLKPLL_IN ), .QN( net119 ), .D( n_14285 ), .SI(
prev2_rx10_rclk2_5 ), .RN( n_13544 ), .SN( tie_hi ), .SE( n_1696 ), .Q(
cnt125_at_8 ) );

SDFFNSRXL (*
integer library_binding = "gsclib090";
 *)
count160_reg_0
 ( .CKN( CLKPLL_IN ), .QN( nbus_1111_0_ ), .D( n_2146 ), .SI(
cnt125_at_49 ), .RN( tie_hi ), .SN( n_2311 ), .SE( n_1688 ), .Q(
count160[0] ) );

SDFFRX4 (*
integer library_binding = "gsclib090";
 *)
cont2_5_disb_reg
 ( .QN( net62 ), .D( n_6485 ), .SI( net63 ), .RN( net8 ), .CK(
CLKPLL_IN ), .SE( n_1696 ), .Q( cont2_5_disb ) );

SDFFRXL (*
integer library_binding = "gsclib090";
 *)

cnt160_at_0_pos_reg ( .QN( cnt160_at_0_pos ), .D( n_6818 ), .SI(
rclk25_good_edge ), .RN( n_13535 ), .CK( CLKPLL_IN ), .SE( n_2286 ), .Q(
net46 ) );

SDFFSX2 (*
integer library_binding = "gsclib090";
 *)
txc_disb_reg ( .QN(
n_232 ), .D( n_6615 ), .SI( net43 ), .SN( net15 ), .CK( CLKPLL_IN ), .SE(
n_2283 ), .Q( txc_disb ) );
SDFFSX2 (*
integer library_binding = "gsclib090";
 *)
cont2_5_sel_reg
 ( .QN( n_237 ), .D( n_6457 ), .SI( net66 ), .SN( net4 ), .CK(
CLKPLL_IN ), .SE( n_1696 ), .Q( cont2_5_sel ) );
SDFFSX2 (*
integer library_binding = "gsclib090";
 *)

prev2xtal_10disb_reg ( .QN( net140 ), .D( prev1xtal_10disb ), .SI(
net141 ), .SN( n_6880 ), .CK( CLKXTAL ), .SE( n_1696 ), .Q(
prev2xtal_10disb ) );

DFFSX4 (*
integer library_binding = "gsclib090";
 *)

x125_sel_sync1_reg ( .QN( net_5694 ), .D( x125_sel ), .SN( n_13931 ),
.CK( n_14816 ), .Q( x125_sel_sync1 ) );
DFFSX4 (*
integer library_binding = "gsclib090";
 *)
sqw25_125_reg ( .QN(
net_5689 ), .D( tie_lo ), .SN( n_6882 ), .CK( sqw25n ), .Q( sqw25_125 ) );

DFFSXL (*
integer library_binding = "gsclib090";
 *)

x125_sel_sync2_reg ( .QN( n_182 ), .D( x125_sel_sync1 ), .SN( n_13930 ),
.CK( n_14816 ), .Q( x125_sel_sync2 ) );

DFFSX1 (*
integer library_binding = "gsclib090";
 *)

x125_sel_sync3_reg ( .QN( x125_sel_sync3 ), .D( x125_sel_sync2 ), .SN(
n_13931 ), .CK( n_14816 ), .Q( net_5703 ) );

DFFRXL (*
integer library_binding = "gsclib090";
 *)
x125_edge_reg ( .QN(
n_13039 ), .D( n_6643 ), .RN( n_13931 ), .CK( n_14816 ), .Q( x125_edge ) );

DFFRX1 (*
integer library_binding = "gsclib090";
 *)

meta_rclk2_5_reg_1 ( .QN( meta_rclk2_5[1] ), .D( meta_rclk2_5[0] ), .RN(
n_13930 ), .CK( n_4397 ), .Q( net_5712 ) );

DFFSX2 (*
integer library_binding = "gsclib090";
 *)
rxc_sel_reg ( .QN(
net_5719 ), .D( n_6665 ), .SN( n_13930 ), .CK( n_14816 ), .Q( rxc_sel ) );

SDFFNSRX4 (*
integer library_binding = "gsclib090";
 *)

clk160_disb_reg ( .CKN( CLKPLL_IN ), .QN( n_14039 ), .D( n_393 ), .SI(
n_2143 ), .RN( tie_hi ), .SN( net10 ), .SE( n_2309 ), .Q( clk160_disb ) );
SDFFNSRX4 (*
integer library_binding = "gsclib090";
 *)

clk125_disb_reg ( .CKN( CLKPLL_IN ), .QN( n_13174 ), .D( n_418 ), .SI(
net97 ), .RN( tie_hi ), .SN( net12 ), .SE( n_2294 ), .Q( net96 ) );
SDFFNSRX4 (*
integer library_binding = "gsclib090";
 *)
sqw25p_reg ( .CKN(
CLKPLL_IN ), .QN( n_6882 ), .D( TXC25_ALIGN ), .SI( net101 ), .RN(
n_13548 ), .SN( tie_hi ), .SE( n_2294 ), .Q( sqw25p ) );
SDFFNSRX4 (*
integer library_binding = "gsclib090";
 *)

CLK2_5_NO_FF_reg ( .CKN( CLKPLL_IN ), .QN( scan_out2 ), .D(
count160[5] ), .SI( n_2144 ), .RN( tie_hi ), .SN( net4 ), .SE( n_2294 ),
.Q( CLK2_5_NO_FF ) );
SDFFNSRX4 (*
integer library_binding = "gsclib090";
 *)
sqw2_5_125_reg
 ( .CKN( CLKPLL_IN ), .QN( net105 ), .D( n_6493 ), .SI( n_2145 ), .RN(
net8 ), .SN( tie_hi ), .SE( n_2294 ), .Q( sqw2_5_125 ) );
SDFFNSRX4 (*
integer library_binding = "gsclib090";
 *)

prev2_rx10_rclk2_5_reg ( .CKN( CLKPLL_IN ), .QN( n_219 ), .D(
prev1_rx10_rclk2_5 ), .SI( n_1939 ), .RN( n_13544 ), .SN( tie_hi ), .SE(
n_2309 ), .Q( prev2_rx10_rclk2_5 ) );

SDFFSXL (*
integer library_binding = "gsclib090";
 *)

clk160_disb_pll_reg ( .QN( net31 ), .D( clk160_disb ), .SI( net32 ), .SN(
net10 ), .CK( CLKPLL_IN ), .SE( n_2301 ), .Q( clk160_disb_pll ) );

SDFFSX1 (*
integer library_binding = "gsclib090";
 *)
slvtxc2_5_pd_reg
 ( .QN( net30 ), .D( n_6709 ), .SI( net31 ), .SN( net10 ), .CK(
CLKPLL_IN ), .SE( n_1256 ), .Q( slvtxc2_5_pd ) );
SDFFSX1 (*
integer library_binding = "gsclib090";
 *)
txc_sel_reg ( .QN(
net42 ), .D( n_6621 ), .SI( txc_disb ), .SN( net15 ), .CK( CLKPLL_IN ),
.SE( n_2286 ), .Q( txc_sel ) );
SDFFSX1 (*
integer library_binding = "gsclib090";
 *)

sync_all_disb_pll_reg_1 ( .QN( n_13026 ), .D( sync_all_disb_pll[0] ),
.SI( net45 ), .SN( net13 ), .CK( CLKPLL_IN ), .SE( n_2286 ), .Q(
sync_all_disb_pll[1] ) );
SDFFSX1 (*
integer library_binding = "gsclib090";
 *)

sync_all_disb_pll_reg_0 ( .QN( net45 ), .D( nbus_1089_0_ ), .SI( net46 ),
.SN( net12 ), .CK( CLKPLL_IN ), .SE( n_2736 ), .Q(
sync_all_disb_pll[0] ) );
SDFFSX1 (*
integer library_binding = "gsclib090";
 *)
sqw25n_reg ( .QN(
net54 ), .D( n_12991 ), .SI( net55 ), .SN( net5 ), .CK( CLKPLL_IN ), .SE(
n_2736 ), .Q( sqw25n ) );
SDFFSX1 (*
integer library_binding = "gsclib090";
 *)
xoff_20_reg ( .QN(
net126 ), .D( n_14337 ), .SI( net127 ), .SN( net123 ), .CK( CLKXTAL ),
.SE( n_1688 ), .Q( xoff_20 ) );
SDFFSX1 (*
integer library_binding = "gsclib090";
 *)
xoff_20_pc_reg_1
 ( .QN( net71 ), .D( n_6377 ), .SI( net72 ), .SN( n_2311 ), .CK(
CLKPLL_IN ), .SE( n_2299 ), .Q( XOFF_20 ) );
SDFFSX1 (*
integer library_binding = "gsclib090";
 *)
xoff_20_pc_reg_0
 ( .QN( net72 ), .D( n_6371 ), .SI( net73 ), .SN( n_2311 ), .CK(
CLKPLL_IN ), .SE( n_2301 ), .Q( xoff_20_pc_0_ ) );
SDFFSX1 (*
integer library_binding = "gsclib090";
 *)

time_reset_pc_reg_6 ( .QN( net73 ), .D( n_6365 ), .SI( net74 ), .SN(
n_2311 ), .CK( CLKPLL_IN ), .SE( n_2301 ), .Q( time_reset_pc[6] ) );
SDFFSX1 (*
integer library_binding = "gsclib090";
 *)

time_reset_pc_reg_5 ( .QN( net74 ), .D( n_6359 ), .SI( net75 ), .SN(
n_2311 ), .CK( CLKPLL_IN ), .SE( n_2301 ), .Q( time_reset_pc[5] ) );
SDFFSX1 (*
integer library_binding = "gsclib090";
 *)

time_reset_pc_reg_4 ( .QN( net75 ), .D( n_6353 ), .SI( net76 ), .SN(
net4 ), .CK( CLKPLL_IN ), .SE( n_1256 ), .Q( time_reset_pc[4] ) );
SDFFSX1 (*
integer library_binding = "gsclib090";
 *)

time_reset_pc_reg_3 ( .QN( net76 ), .D( n_6347 ), .SI( net77 ), .SN(
n_2311 ), .CK( CLKPLL_IN ), .SE( n_2301 ), .Q( time_reset_pc[3] ) );
SDFFSX1 (*
integer library_binding = "gsclib090";
 *)

time_reset_pc_reg_2 ( .QN( net77 ), .D( n_6341 ), .SI( net78 ), .SN(
n_2311 ), .CK( CLKPLL_IN ), .SE( n_2301 ), .Q( time_reset_pc[2] ) );
SDFFSX1 (*
integer library_binding = "gsclib090";
 *)

time_reset_pc_reg_1 ( .QN( net78 ), .D( n_6335 ), .SI( net79 ), .SN(
net7 ), .CK( CLKPLL_IN ), .SE( n_2301 ), .Q( time_reset_pc[1] ) );
SDFFSX1 (*
integer library_binding = "gsclib090";
 *)

time_reset_pc_reg_0 ( .QN( net79 ), .D( n_6329 ), .SI( genplld5_enable ),
.SN( net6 ), .CK( CLKPLL_IN ), .SE( n_1256 ), .Q( time_reset_pc[0] ) );
SDFFSX1 (*
integer library_binding = "gsclib090";
 *)

prev3xtal_10disb_reg ( .QN( n_227 ), .D( prev2xtal_10disb ), .SI(
prev3xtal_100disb ), .SN( net122 ), .CK( CLKXTAL ), .SE( n_1256 ), .Q(
prev3xtal_10disb ) );
SDFFSX1 (*
integer library_binding = "gsclib090";
 *)

prev1xtal_10disb_reg ( .QN( net141 ), .D( RPD_10_DISB ), .SI(
prev2xtal_100disb ), .SN( net122 ), .CK( CLKXTAL ), .SE( n_1256 ), .Q(
prev1xtal_10disb ) );
SDFFSX1 (*
integer library_binding = "gsclib090";
 *)

prev_b10dis_xtal_reg_2 ( .QN( n_6870 ), .D( prev_b10dis_xtal_1_ ), .SI(
net143 ), .SN( n_6880 ), .CK( CLKXTAL ), .SE( n_1688 ), .Q( n_14294 ) );
SDFFSX1 (*
integer library_binding = "gsclib090";
 *)

prev_b10dis_xtal_reg_1 ( .QN( net143 ), .D( prev_b10dis_xtal_0_ ), .SI(
net144 ), .SN( n_6880 ), .CK( CLKXTAL ), .SE( n_2301 ), .Q(
prev_b10dis_xtal_1_ ) );
SDFFSX1 (*
integer library_binding = "gsclib090";
 *)

prev_b10dis_xtal_reg_0 ( .QN( net144 ), .D( n_419 ), .SI( scan_in3 ),
.SN( n_6880 ), .CK( CLKXTAL ), .SE( n_2301 ), .Q( prev_b10dis_xtal_0_ ) );
SDFFSX1 (*
integer library_binding = "gsclib090";
 *)
prev2_mr100_reg
 ( .QN( net80 ), .D( prev1_mr100 ), .SI( net81 ), .SN( net7 ), .CK(
CLKPLL_IN ), .SE( n_1688 ), .Q( prev2_mr100 ) );
SDFFSX1 (*
integer library_binding = "gsclib090";
 *)
prev1_mr100_reg
 ( .QN( net81 ), .D( n_390 ), .SI( net82 ), .SN( net7 ), .CK(
CLKPLL_IN ), .SE( n_1256 ), .Q( prev1_mr100 ) );

DFFRX2 (*
integer library_binding = "gsclib090";
 *)
rxc_disb_reg ( .QN(
n_6833 ), .D( n_6735 ), .RN( n_13930 ), .CK( n_14816 ), .Q( rxc_disb ) );
DFFRX2 (*
integer library_binding = "gsclib090";
 *)
res_x125_edge_reg
 ( .QN( net_5948 ), .D( n_6677 ), .RN( n_13930 ), .CK( n_14816 ), .Q(
res_x125_edge ) );
DFFRX2 (*
integer library_binding = "gsclib090";
 *)
Flag100_to_10_reg
 ( .QN( n_181 ), .D( n_6671 ), .RN( n_13930 ), .CK( n_14816 ), .Q(
Flag100_to_10 ) );
DFFRX2 (*
integer library_binding = "gsclib090";
 *)
Flag10_to_100_reg
 ( .QN( net_5938 ), .D( n_6659 ), .RN( n_13930 ), .CK( n_14816 ), .Q(
Flag10_to_100 ) );
DFFRX2 (*
integer library_binding = "gsclib090";
 *)

meta_rclk2_5_reg_0 ( .QN( net_5933 ), .D( n_6843 ), .RN( n_13931 ), .CK(
n_14816 ), .Q( meta_rclk2_5[0] ) );

SDFFRX2 (*
integer library_binding = "gsclib090";
 *)
clk12_5_ctrl_reg
 ( .QN( clk12_5_ctrl ), .D( n_385 ), .SI( net20 ), .RN( n_13538 ), .CK(
CLKPLL_IN ), .SE( n_1257 ), .Q( net19 ) );
SDFFRX2 (*
integer library_binding = "gsclib090";
 *)

selorlocked125_reg ( .QN( net23 ), .D( n_6834 ), .SI( net24 ), .RN(
n_13539 ), .CK( CLKPLL_IN ), .SE( n_1257 ), .Q( selorlocked125 ) );
SDFFRX2 (*
integer library_binding = "gsclib090";
 *)
rclk25_disb_reg
 ( .QN( net40 ), .D( n_6631 ), .SI( net41 ), .RN( n_13529 ), .CK(
CLKPLL_IN ), .SE( n_2283 ), .Q( rclk25_disb ) );
SDFFRX2 (*
integer library_binding = "gsclib090";
 *)

res_rclk25_edge_reg ( .QN( net48 ), .D( n_6581 ), .SI( net49 ), .RN(
n_13532 ), .CK( CLKPLL_IN ), .SE( n_2294 ), .Q( res_rclk25_edge ) );
SDFFRX2 (*
integer library_binding = "gsclib090";
 *)

Flag_in_to_rec_reg ( .QN( net49 ), .D( n_6575 ), .SI( net50 ), .RN(
n_13532 ), .CK( CLKPLL_IN ), .SE( n_2294 ), .Q( Flag_in_to_rec ) );
SDFFRX2 (*
integer library_binding = "gsclib090";
 *)
rclk25_sel_reg
 ( .QN( net50 ), .D( n_6569 ), .SI( net51 ), .RN( n_13532 ), .CK(
CLKPLL_IN ), .SE( n_2294 ), .Q( rclk25_sel ) );
SDFFRX2 (*
integer library_binding = "gsclib090";
 *)

Flag_rec_to_in_reg ( .QN( net51 ), .D( n_6563 ), .SI( net52 ), .RN(
n_13535 ), .CK( CLKPLL_IN ), .SE( n_2294 ), .Q( Flag_rec_to_in ) );
SDFFRX2 (*
integer library_binding = "gsclib090";
 *)
rclk25_sync1_reg
 ( .QN( net52 ), .D( n_1909 ), .SI( net53 ), .RN( n_13535 ), .CK(
CLKPLL_IN ), .SE( n_2294 ), .Q( rclk25_sync1 ) );
SDFFRX2 (*
integer library_binding = "gsclib090";
 *)

Flag_rclk2_5_ext_to_int_reg ( .QN( net60 ), .D( n_6505 ), .SI(
prev2_cont2_5 ), .RN( n_13547 ), .CK( CLKPLL_IN ), .SE( n_2294 ), .Q(
Flag_rclk2_5_ext_to_int ) );

SDFFNSRX1 (*
integer library_binding = "gsclib090";
 *)

clk160n_enable_reg ( .CKN( CLKPLL_IN ), .QN( net84 ), .D(
clk160_enable_int ), .SI( n_2006 ), .RN( n_13538 ), .SN( tie_hi ), .SE(
n_1257 ), .Q( clk160n_enable ) );
SDFFNSRX1 (*
integer library_binding = "gsclib090";
 *)
txc25_disb_reg
 ( .CKN( CLKPLL_IN ), .QN( net85 ), .D( n_6769 ), .SI( n_2007 ), .RN(
n_13538 ), .SN( tie_hi ), .SE( n_1257 ), .Q( txc25_disb ) );
SDFFNSRX1 (*
integer library_binding = "gsclib090";
 *)

slvtxc25_pd_reg ( .CKN( CLKPLL_IN ), .QN( net86 ), .D( n_6761 ), .SI(
net87 ), .RN( n_13539 ), .SN( tie_hi ), .SE( n_2307 ), .Q( slvtxc25_pd ) );
SDFFNSRX1 (*
integer library_binding = "gsclib090";
 *)

an_link_down_plln_reg_1 ( .CKN( CLKPLL_IN ), .QN( an_link_down_plln[1] ),
.D( an_link_down_plln[0] ), .SI( n_2008 ), .RN( n_13537 ), .SN( tie_hi ),
.SE( n_2292 ), .Q( net87 ) );
SDFFNSRX1 (*
integer library_binding = "gsclib090";
 *)

an_link_down_plln_reg_0 ( .CKN( CLKPLL_IN ), .QN( net88 ), .D(
nbus_1104_0_ ), .SI( n_2009 ), .RN( n_13537 ), .SN( tie_hi ), .SE(
n_2286 ), .Q( an_link_down_plln[0] ) );
SDFFNSRX1 (*
integer library_binding = "gsclib090";
 *)

cnt125_at_4_reg ( .CKN( CLKPLL_IN ), .QN( net89 ), .D( n_6836 ), .SI(
n_2010 ), .RN( n_13538 ), .SN( tie_hi ), .SE( n_2286 ), .Q(
cnt125_at_4 ) );
SDFFNSRX1 (*
integer library_binding = "gsclib090";
 *)

prev2_5_mr100_reg ( .CKN( CLKPLL_IN ), .QN( net90 ), .D( prev2_mr100 ),
.SI( n_1928 ), .RN( tie_hi ), .SN( net11 ), .SE( n_1257 ), .Q(
prev2_5_mr100 ) );
SDFFNSRX1 (*
integer library_binding = "gsclib090";
 *)

pll160_locked_plln_reg_1 ( .CKN( CLKPLL_IN ), .QN( net91 ), .D(
nbus_1109[1] ), .SI( net92 ), .RN( n_13540 ), .SN( tie_hi ), .SE(
n_2307 ), .Q( pll160_locked_plln[1] ) );
SDFFNSRX1 (*
integer library_binding = "gsclib090";
 *)

pll160_locked_plln_reg_0 ( .CKN( CLKPLL_IN ), .QN(
pll160_locked_plln[0] ), .D( nbus_1109[0] ), .SI( net93 ), .RN(
n_13540 ), .SN( tie_hi ), .SE( n_2299 ), .Q( net92 ) );
SDFFNSRX1 (*
integer library_binding = "gsclib090";
 *)

prev2pll_10disb_reg ( .CKN( CLKPLL_IN ), .QN( prev2pll_10disb ), .D(
prev1pll_10disb ), .SI( n_2011 ), .RN( tie_hi ), .SN( net14 ), .SE(
n_2307 ), .Q( net93 ) );
SDFFNSRX1 (*
integer library_binding = "gsclib090";
 *)

prev1pll_10disb_reg ( .CKN( CLKPLL_IN ), .QN( net94 ), .D( RPD_10_DISB ),
.SI( n_2012 ), .RN( tie_hi ), .SN( net14 ), .SE( n_2299 ), .Q(
prev1pll_10disb ) );
SDFFNSRX1 (*
integer library_binding = "gsclib090";
 *)

cnt125_at_9_reg ( .CKN( CLKPLL_IN ), .QN( net95 ), .D( n_6842 ), .SI(
net96 ), .RN( n_13529 ), .SN( tie_hi ), .SE( n_2284 ), .Q( cnt125_at_9 ) );
SDFFNSRX1 (*
integer library_binding = "gsclib090";
 *)

prev2pll_100disb_reg ( .CKN( CLKPLL_IN ), .QN( prev2pll_100disb ), .D(
prev1pll_100disb ), .SI( n_2013 ), .RN( tie_hi ), .SN( net12 ), .SE(
n_2284 ), .Q( net97 ) );
SDFFNSRX1 (*
integer library_binding = "gsclib090";
 *)

prev1pll_100disb_reg ( .CKN( CLKPLL_IN ), .QN( net98 ), .D(
RPD_100_DISB ), .SI( n_2015 ), .RN( tie_hi ), .SN( net11 ), .SE(
n_2292 ), .Q( prev1pll_100disb ) );
SDFFNSRX1 (*
integer library_binding = "gsclib090";
 *)

pll125_locked_plln_reg_1 ( .CKN( CLKPLL_IN ), .QN( net99 ), .D(
nbus_1106[1] ), .SI( net100 ), .RN( n_13537 ), .SN( tie_hi ), .SE(
n_2286 ), .Q( pll125_locked_plln[1] ) );
SDFFNSRX1 (*
integer library_binding = "gsclib090";
 *)

pll125_locked_plln_reg_0 ( .CKN( CLKPLL_IN ), .QN(
pll125_locked_plln[0] ), .D( nbus_1106[0] ), .SI( sqw25p ), .RN(
n_13537 ), .SN( tie_hi ), .SE( n_2286 ), .Q( net100 ) );
SDFFNSRX1 (*
integer library_binding = "gsclib090";
 *)

cnt125_at_3_reg ( .CKN( CLKPLL_IN ), .QN( cnt125_at_3 ), .D( n_13250 ),
.SI( n_2016 ), .RN( n_13548 ), .SN( tie_hi ), .SE( n_2286 ), .Q(
net101 ) );
SDFFNSRX1 (*
integer library_binding = "gsclib090";
 *)

cnt125_at_6_reg ( .CKN( CLKPLL_IN ), .QN( net102 ), .D( n_13779 ), .SI(
n_2017 ), .RN( n_13548 ), .SN( tie_hi ), .SE( n_2284 ), .Q(
cnt125_at_6 ) );
SDFFNSRX1 (*
integer library_binding = "gsclib090";
 *)

cnt125_at_1_reg ( .CKN( CLKPLL_IN ), .QN( net103 ), .D( n_13526 ), .SI(
n_2018 ), .RN( n_13548 ), .SN( tie_hi ), .SE( n_2286 ), .Q(
cnt125_at_1 ) );
SDFFNSRX1 (*
integer library_binding = "gsclib090";
 *)

rclk2_5_good_reg ( .CKN( CLKPLL_IN ), .QN( net104 ), .D( RCLK2_5_GOOD ),
.SI( n_1926 ), .RN( n_13547 ), .SN( tie_hi ), .SE( n_2292 ), .Q(
rclk2_5_good ) );
SDFFNSRX1 (*
integer library_binding = "gsclib090";
 *)

cnt125_at_24_reg ( .CKN( CLKPLL_IN ), .QN( net106 ), .D( n_13291 ), .SI(
n_2019 ), .RN( net8 ), .SN( tie_hi ), .SE( n_2298 ), .Q( cnt125_at_24 ) );
SDFFNSRX1 (*
integer library_binding = "gsclib090";
 *)

cnt160_at_3e_reg ( .CKN( CLKPLL_IN ), .QN( net107 ), .D( n_14343 ), .SI(
n_2020 ), .RN( net8 ), .SN( tie_hi ), .SE( n_2283 ), .Q( cnt160_at_3e ) );
SDFFNSRX1 (*
integer library_binding = "gsclib090";
 *)
count160_reg_5
 ( .CKN( CLKPLL_IN ), .QN( net108 ), .D( n_407 ), .SI( n_2021 ), .RN(
tie_hi ), .SN( net4 ), .SE( n_1688 ), .Q( count160[5] ) );
SDFFNSRX1 (*
integer library_binding = "gsclib090";
 *)
count160_reg_4
 ( .CKN( CLKPLL_IN ), .QN( net109 ), .D( n_406 ), .SI( count160[3] ),
.RN( tie_hi ), .SN( net4 ), .SE( n_1688 ), .Q( count160[4] ) );
SDFFNSRX1 (*
integer library_binding = "gsclib090";
 *)
count160_reg_3
 ( .CKN( CLKPLL_IN ), .QN( n_116 ), .D( n_405 ), .SI( n_2022 ), .RN(
tie_hi ), .SN( n_2311 ), .SE( n_1694 ), .Q( count160[3] ) );
SDFFNSRX1 (*
integer library_binding = "gsclib090";
 *)
count160_reg_2
 ( .CKN( CLKPLL_IN ), .QN( net110 ), .D( n_404 ), .SI( n_2023 ), .RN(
tie_hi ), .SN( n_2311 ), .SE( n_1694 ), .Q( count160[2] ) );
SDFFNSRX1 (*
integer library_binding = "gsclib090";
 *)
count160_reg_1
 ( .CKN( CLKPLL_IN ), .QN( net111 ), .D( n_403 ), .SI( count160[0] ),
.RN( tie_hi ), .SN( n_2311 ), .SE( n_1694 ), .Q( count160[1] ) );
SDFFNSRX1 (*
integer library_binding = "gsclib090";
 *)

cnt125_at_49_reg ( .CKN( CLKPLL_IN ), .QN( n_157 ), .D( n_13839 ), .SI(
n_2024 ), .RN( n_13541 ), .SN( tie_hi ), .SE( n_2283 ), .Q(
cnt125_at_49 ) );
SDFFNSRX1 (*
integer library_binding = "gsclib090";
 *)

pll125_status_reg_1 ( .CKN( CLKXTAL ), .QN( net145 ), .D( nbus_1110_1_ ),
.SI( n_2054 ), .RN( n_13931 ), .SN( tie_hi ), .SE( n_1694 ), .Q(
pll125_status[1] ) );
SDFFNSRX1 (*
integer library_binding = "gsclib090";
 *)

pll125_status_reg_0 ( .CKN( CLKXTAL ), .QN( net146 ), .D( n_397 ), .SI(
net147 ), .RN( n_13929 ), .SN( tie_hi ), .SE( n_1688 ), .Q(
pll125_status[0] ) );
SDFFNSRX1 (*
integer library_binding = "gsclib090";
 *)

prev3_rpd100tx_disb_reg ( .CKN( CLKXTAL ), .QN( prev3_rpd100tx_disb ),
.D( prev2_rpd100tx_disb ), .SI( n_2055 ), .RN( n_13929 ), .SN( tie_hi ),
.SE( n_1694 ), .Q( net147 ) );
SDFFNSRX1 (*
integer library_binding = "gsclib090";
 *)

prev2_rpd100tx_disb_reg ( .CKN( CLKXTAL ), .QN( net148 ), .D(
prev1_rpd100tx_disb ), .SI( n_2056 ), .RN( n_13929 ), .SN( tie_hi ), .SE(
n_1688 ), .Q( prev2_rpd100tx_disb ) );
SDFFNSRX1 (*
integer library_binding = "gsclib090";
 *)

prev1_rpd100tx_disb_reg ( .CKN( CLKXTAL ), .QN( net149 ), .D(
RPD_100_DISB ), .SI( n_2057 ), .RN( n_13930 ), .SN( tie_hi ), .SE(
n_1688 ), .Q( prev1_rpd100tx_disb ) );
SDFFNSRX1 (*
integer library_binding = "gsclib090";
 *)

sync_all_disb_plln_reg_1 ( .CKN( CLKPLL_IN ), .QN( n_12920 ), .D(
sync_all_disb_plln[0] ), .SI( n_2025 ), .RN( tie_hi ), .SN( net4 ), .SE(
n_1694 ), .Q( sync_all_disb_plln[1] ) );
SDFFNSRX1 (*
integer library_binding = "gsclib090";
 *)

sync_all_disb_plln_reg_0 ( .CKN( CLKPLL_IN ), .QN( net112 ), .D(
nbus_1089_0_ ), .SI( n_135 ), .RN( tie_hi ), .SN( net4 ), .SE( n_1694 ),
.Q( sync_all_disb_plln[0] ) );
SDFFNSRX1 (*
integer library_binding = "gsclib090";
 *)

pll160_status_reg_0 ( .CKN( CLKXTAL ), .QN( net151 ), .D( n_413 ), .SI(
net152 ), .RN( n_13930 ), .SN( tie_hi ), .SE( n_2283 ), .Q(
pll160_status[0] ) );
SDFFNSRX1 (*
integer library_binding = "gsclib090";
 *)

pll160_status_reg_1 ( .CKN( CLKXTAL ), .QN( net150 ), .D( nbus_1114_1_ ),
.SI( n_2058 ), .RN( n_13930 ), .SN( tie_hi ), .SE( n_1688 ), .Q(
pll160_status[1] ) );
SDFFNSRX1 (*
integer library_binding = "gsclib090";
 *)
count125_reg_6
 ( .CKN( CLKPLL_IN ), .QN( n_135 ), .D( n_6321 ), .SI( n_2026 ), .RN(
n_13545 ), .SN( tie_hi ), .SE( n_2307 ), .Q( count125_6_ ) );
SDFFNSRX1 (*
integer library_binding = "gsclib090";
 *)
count125_reg_5
 ( .CKN( CLKPLL_IN ), .QN( net113 ), .D( n_6315 ), .SI( n_2027 ), .RN(
n_13545 ), .SN( tie_hi ), .SE( n_2307 ), .Q( count125_5_ ) );
SDFFNSRX1 (*
integer library_binding = "gsclib090";
 *)
count125_reg_4
 ( .CKN( CLKPLL_IN ), .QN( net114 ), .D( n_6309 ), .SI( n_2028 ), .RN(
n_13547 ), .SN( tie_hi ), .SE( n_2307 ), .Q( count125_4_ ) );
SDFFNSRX1 (*
integer library_binding = "gsclib090";
 *)
count125_reg_3
 ( .CKN( CLKPLL_IN ), .QN( net115 ), .D( nbus_1115_3_ ), .SI( n_2029 ),
.RN( n_13545 ), .SN( tie_hi ), .SE( n_2307 ), .Q( count125_3_ ) );
SDFFNSRX1 (*
integer library_binding = "gsclib090";
 *)
count125_reg_2
 ( .CKN( CLKPLL_IN ), .QN( net116 ), .D( n_415 ), .SI( n_2030 ), .RN(
n_13545 ), .SN( tie_hi ), .SE( n_2307 ), .Q( count125_2_ ) );
SDFFNSRX1 (*
integer library_binding = "gsclib090";
 *)
count125_reg_1
 ( .CKN( CLKPLL_IN ), .QN( net117 ), .D( n_414 ), .SI( n_2031 ), .RN(
n_13545 ), .SN( tie_hi ), .SE( n_1694 ), .Q( count125_1_ ) );
SDFFNSRX1 (*
integer library_binding = "gsclib090";
 *)
count125_reg_0
 ( .CKN( CLKPLL_IN ), .QN( net118 ), .D( nbus_1115_0_ ), .SI( n_1955 ),
.RN( n_13544 ), .SN( tie_hi ), .SE( n_1694 ), .Q( count125_0_ ) );
SDFFNSRX1 (*
integer library_binding = "gsclib090";
 *)

prev3_rpd10_disb_reg ( .CKN( CLKXTAL ), .QN( prev3_rpd10_disb ), .D(
prev2_rpd10_disb ), .SI( n_2059 ), .RN( tie_hi ), .SN( n_6880 ), .SE(
n_2307 ), .Q( net152 ) );
SDFFNSRX1 (*
integer library_binding = "gsclib090";
 *)

prev2_rpd10_disb_reg ( .CKN( CLKXTAL ), .QN( net153 ), .D(
prev1_rpd10_disb ), .SI( n_2060 ), .RN( tie_hi ), .SN( n_6880 ), .SE(
n_2299 ), .Q( prev2_rpd10_disb ) );
SDFFNSRX1 (*
integer library_binding = "gsclib090";
 *)

prev1_rpd10_disb_reg ( .CKN( CLKXTAL ), .QN( net154 ), .D( RPD_10_DISB ),
.SI( n_2061 ), .RN( tie_hi ), .SN( n_6880 ), .SE( n_2307 ), .Q(
prev1_rpd10_disb ) );

SDFFRX1 (*
integer library_binding = "gsclib090";
 *)
txc25ena_pos_reg
 ( .QN( txc25ena_pos ), .D( n_13230 ), .SI( net17 ), .RN( n_13538 ), .CK(
CLKPLL_IN ), .SE( n_1257 ), .Q( net16 ) );
SDFFRX1 (*
integer library_binding = "gsclib090";
 *)

cnt125_at_9_pos_reg ( .QN( cnt125_at_9_pos ), .D( n_6842 ), .SI( net18 ),
.RN( n_13538 ), .CK( CLKPLL_IN ), .SE( n_1257 ), .Q( net17 ) );
SDFFRX1 (*
integer library_binding = "gsclib090";
 *)

clk10n_enable_reg ( .QN( scan_out1 ), .D( n_13358 ), .SI( net16 ), .RN(
n_13539 ), .CK( CLKPLL_IN ), .SE( n_2305 ), .Q( clk10n_enable ) );
SDFFRX1 (*
integer library_binding = "gsclib090";
 *)
fastcount_7_reg
 ( .QN( fastcount_7 ), .D( n_13414 ), .SI( net19 ), .RN( n_13538 ), .CK(
CLKPLL_IN ), .SE( n_2305 ), .Q( net18 ) );
SDFFRX1 (*
integer library_binding = "gsclib090";
 *)

clk125_enable_reg ( .QN( net20 ), .D( clk125_enable_int ), .SI( net21 ),
.RN( n_13537 ), .CK( CLKPLL_IN ), .SE( n_2309 ), .Q( clk125_enable ) );
SDFFRX1 (*
integer library_binding = "gsclib090";
 *)

cnt160_at_8_pos_reg ( .QN( cnt160_at_8_pos ), .D( n_13639 ), .SI(
net22 ), .RN( n_13537 ), .CK( CLKPLL_IN ), .SE( n_2290 ), .Q( net21 ) );
SDFFRX1 (*
integer library_binding = "gsclib090";
 *)

clk160_enable_reg ( .QN( net22 ), .D( clk160_enable_int ), .SI( net23 ),
.RN( n_13538 ), .CK( CLKPLL_IN ), .SE( n_2290 ), .Q( clk160_enable ) );
SDFFRX1 (*
integer library_binding = "gsclib090";
 *)
fastcount_5_reg
 ( .QN( fastcount_5 ), .D( n_13966 ), .SI( net25 ), .RN( n_13540 ), .CK(
CLKPLL_IN ), .SE( n_1257 ), .Q( net24 ) );
SDFFRX1 (*
integer library_binding = "gsclib090";
 *)
fastcount_reg_2
 ( .QN( net25 ), .D( n_395 ), .SI( fastcount[1] ), .RN( n_13540 ), .CK(
CLKPLL_IN ), .SE( n_2292 ), .Q( fastcount[2] ) );
SDFFRX1 (*
integer library_binding = "gsclib090";
 *)
fastcount_reg_1
 ( .QN( n_98 ), .D( n_394 ), .SI( fastcount[0] ), .RN( n_13540 ), .CK(
CLKPLL_IN ), .SE( n_2290 ), .Q( fastcount[1] ) );
SDFFRX1 (*
integer library_binding = "gsclib090";
 *)
fastcount_reg_0
 ( .QN( nbus_1107_0_ ), .D( nbus_1107_0_ ), .SI( net26 ), .RN( n_13540 ),
.CK( CLKPLL_IN ), .SE( n_2309 ), .Q( fastcount[0] ) );
SDFFRX1 (*
integer library_binding = "gsclib090";
 *)

clk125_enable_int_reg ( .QN( net26 ), .D( n_13174 ), .SI( net27 ), .RN(
net9 ), .CK( CLKPLL_IN ), .SE( n_2309 ), .Q( clk125_enable_int ) );
SDFFRX1 (*
integer library_binding = "gsclib090";
 *)

clk160_enable_int_reg ( .QN( net27 ), .D( n_14039 ), .SI( net28 ), .RN(
net9 ), .CK( CLKPLL_IN ), .SE( n_2305 ), .Q( clk160_enable_int ) );
SDFFRX1 (*
integer library_binding = "gsclib090";
 *)

cnt160_at_3f_pos_reg ( .QN( cnt160_at_3f_pos ), .D( n_14069 ), .SI(
net29 ), .RN( n_13540 ), .CK( CLKPLL_IN ), .SE( n_2298 ), .Q( net28 ) );
SDFFRX1 (*
integer library_binding = "gsclib090";
 *)
txc2_5_disb_reg
 ( .QN( net29 ), .D( n_6715 ), .SI( net30 ), .RN( n_13540 ), .CK(
CLKPLL_IN ), .SE( n_2309 ), .Q( txc2_5_disb ) );
SDFFRX1 (*
integer library_binding = "gsclib090";
 *)

selorlocked160_reg ( .QN( net32 ), .D( n_6830 ), .SI( net33 ), .RN(
n_13539 ), .CK( CLKPLL_IN ), .SE( n_2305 ), .Q( selorlocked160 ) );
SDFFRX1 (*
integer library_binding = "gsclib090";
 *)
clk10_enable_reg
 ( .QN( net33 ), .D( n_14146 ), .SI( net34 ), .RN( n_13539 ), .CK(
CLKPLL_IN ), .SE( n_2305 ), .Q( clk10_enable ) );
SDFFRX1 (*
integer library_binding = "gsclib090";
 *)

pll160_locked_pos_reg ( .QN( pll160_locked_pos ), .D(
pll160_locked_pll[1] ), .SI( net35 ), .RN( n_13530 ), .CK( CLKPLL_IN ),
.SE( n_2305 ), .Q( net34 ) );
SDFFRX1 (*
integer library_binding = "gsclib090";
 *)

meta_rpd_10_disb_reg_1 ( .QN( net35 ), .D( meta_rpd_10_disb[0] ), .SI(
net36 ), .RN( n_13530 ), .CK( CLKPLL_IN ), .SE( n_2305 ), .Q(
meta_rpd_10_disb[1] ) );
SDFFRX1 (*
integer library_binding = "gsclib090";
 *)

meta_rpd_10_disb_reg_0 ( .QN( net36 ), .D( RPD_10_DISB ), .SI( net37 ),
.RN( n_13530 ), .CK( CLKPLL_IN ), .SE( n_2305 ), .Q(
meta_rpd_10_disb[0] ) );
SDFFRX1 (*
integer library_binding = "gsclib090";
 *)

prev_x160_sel_pos_reg ( .QN( prev_x160_sel_pos ), .D( n_19560 ), .SI(
net38 ), .RN( n_13530 ), .CK( CLKPLL_IN ), .SE( n_2309 ), .Q( net37 ) );
SDFFRX1 (*
integer library_binding = "gsclib090";
 *)

mr_txc2_5_pd_pll_reg ( .QN( net38 ), .D( n_408 ), .SI( net39 ), .RN(
n_13532 ), .CK( CLKPLL_IN ), .SE( n_2298 ), .Q( mr_txc2_5_pd_pll ) );
SDFFRX1 (*
integer library_binding = "gsclib090";
 *)
rclk2_5_disb_reg
 ( .QN( net39 ), .D( n_6649 ), .SI( net40 ), .RN( n_13530 ), .CK(
CLKPLL_IN ), .SE( n_2298 ), .Q( rclk2_5_disb ) );
SDFFRX1 (*
integer library_binding = "gsclib090";
 *)

cnt160_at_1f_pos_reg ( .QN( cnt160_at_1f_pos ), .D( n_14265 ), .SI(
net42 ), .RN( n_13529 ), .CK( CLKPLL_IN ), .SE( n_2290 ), .Q( net41 ) );
SDFFRX1 (*
integer library_binding = "gsclib090";
 *)
prev2_clk25_reg
 ( .QN( prev2_clk25 ), .D( prev1_clk25 ), .SI( net44 ), .RN( n_13529 ),
.CK( CLKPLL_IN ), .SE( n_2290 ), .Q( net43 ) );
SDFFRX1 (*
integer library_binding = "gsclib090";
 *)
prev1_clk25_reg
 ( .QN( net44 ), .D( n_710 ), .SI( n_13026 ), .RN( n_13529 ), .CK(
CLKPLL_IN ), .SE( n_2292 ), .Q( prev1_clk25 ) );
SDFFRX1 (*
integer library_binding = "gsclib090";
 *)

rclk25_good_edge_reg ( .QN( n_12985 ), .D( n_6589 ), .SI( net47 ), .RN(
n_13535 ), .CK( CLKPLL_IN ), .SE( n_2283 ), .Q( rclk25_good_edge ) );
SDFFRX1 (*
integer library_binding = "gsclib090";
 *)

prev_rclk25_good_reg ( .QN( net47 ), .D( RCLK25_GOOD ), .SI( net48 ),
.RN( n_13532 ), .CK( CLKPLL_IN ), .SE( n_2290 ), .Q( prev_rclk25_good ) );
SDFFRX1 (*
integer library_binding = "gsclib090";
 *)
sqw25_sync1_reg
 ( .QN( net53 ), .D( n_710 ), .SI( net54 ), .RN( n_13532 ), .CK(
CLKPLL_IN ), .SE( n_2290 ), .Q( sqw25_sync1 ) );
SDFFRX1 (*
integer library_binding = "gsclib090";
 *)

rclk2_5_good_pll_reg ( .QN( net55 ), .D( n_6541 ), .SI( net56 ), .RN(
n_13548 ), .CK( CLKPLL_IN ), .SE( n_2292 ), .Q( rclk2_5_good_pll ) );
SDFFRX1 (*
integer library_binding = "gsclib090";
 *)
cont2_5_edge_reg
 ( .QN( net56 ), .D( n_6535 ), .SI( net57 ), .RN( n_13548 ), .CK(
CLKPLL_IN ), .SE( n_2292 ), .Q( cont2_5_edge ) );
SDFFRX1 (*
integer library_binding = "gsclib090";
 *)

Flag_rclk2_5_int_to_ext_reg ( .QN( net57 ), .D( n_6529 ), .SI(
rclk2_5_good_edge ), .RN( n_13548 ), .CK( CLKPLL_IN ), .SE( n_2290 ),
.Q( Flag_rclk2_5_int_to_ext ) );
SDFFRX1 (*
integer library_binding = "gsclib090";
 *)

rclk2_5_good_edge_reg ( .QN( n_12834 ), .D( n_6523 ), .SI( net58 ), .RN(
n_13547 ), .CK( CLKPLL_IN ), .SE( n_2283 ), .Q( rclk2_5_good_edge ) );
SDFFRX1 (*
integer library_binding = "gsclib090";
 *)

sync2_rclk2_5_good_pll_reg ( .QN( sync2_rclk2_5_good_pll ), .D(
sync1_rclk2_5_good_pll ), .SI( sync1_rclk2_5_good_pll ), .RN( n_13547 ),
.CK( CLKPLL_IN ), .SE( n_2290 ), .Q( net58 ) );
SDFFRX1 (*
integer library_binding = "gsclib090";
 *)

sync1_rclk2_5_good_pll_reg ( .QN( n_62 ), .D( rclk2_5_good ), .SI(
net59 ), .RN( n_13547 ), .CK( CLKPLL_IN ), .SE( n_2292 ), .Q(
sync1_rclk2_5_good_pll ) );
SDFFRX1 (*
integer library_binding = "gsclib090";
 *)

res_rclk2_5_good_edge_reg ( .QN( net59 ), .D( n_6511 ), .SI( net60 ),
.RN( n_13547 ), .CK( CLKPLL_IN ), .SE( n_2292 ), .Q(
res_rclk2_5_good_edge ) );
SDFFRX1 (*
integer library_binding = "gsclib090";
 *)

prev2_cont2_5_reg ( .QN( n_218 ), .D( prev1_cont2_5 ), .SI( net61 ), .RN(
n_13547 ), .CK( CLKPLL_IN ), .SE( n_2292 ), .Q( prev2_cont2_5 ) );
SDFFRX1 (*
integer library_binding = "gsclib090";
 *)

prev1_cont2_5_reg ( .QN( net61 ), .D( n_501 ), .SI( net62 ), .RN(
n_13541 ), .CK( CLKPLL_IN ), .SE( n_2290 ), .Q( prev1_cont2_5 ) );
SDFFRX1 (*
integer library_binding = "gsclib090";
 *)

cnt160_next_3f_reg ( .QN( cnt160_next_3f ), .D( cnt160_at_3e ), .SI(
net64 ), .RN( net8 ), .CK( CLKPLL_IN ), .SE( n_1684 ), .Q( net63 ) );
SDFFRX1 (*
integer library_binding = "gsclib090";
 *)

prev_x160_sel_7_pll_reg ( .QN( prev_x160_sel_7_pll ), .D( n_19560 ), .SI(
net65 ), .RN( n_13541 ), .CK( CLKPLL_IN ), .SE( n_1692 ), .Q( net64 ) );
SDFFRX1 (*
integer library_binding = "gsclib090";
 *)

prev3_cont2_5_reg ( .QN( net65 ), .D( prev2_cont2_5 ), .SI( n_237 ), .RN(
n_13541 ), .CK( CLKPLL_IN ), .SE( n_1684 ), .Q( prev3_cont2_5 ) );
SDFFRX1 (*
integer library_binding = "gsclib090";
 *)

pll160_locked_pll_reg_1 ( .QN( net66 ), .D( pll160_locked_pll[0] ), .SI(
net67 ), .RN( net8 ), .CK( CLKPLL_IN ), .SE( n_1696 ), .Q(
pll160_locked_pll[1] ) );
SDFFRX1 (*
integer library_binding = "gsclib090";
 *)

pll160_locked_pll_reg_0 ( .QN( net67 ), .D( pll160_status[1] ), .SI(
net68 ), .RN( net8 ), .CK( CLKPLL_IN ), .SE( n_1684 ), .Q(
pll160_locked_pll[0] ) );
SDFFRX1 (*
integer library_binding = "gsclib090";
 *)

pll125_locked_pll_reg_1 ( .QN( net68 ), .D( pll125_locked_pll[0] ), .SI(
net69 ), .RN( net8 ), .CK( CLKPLL_IN ), .SE( n_1696 ), .Q(
pll125_locked_pll[1] ) );
SDFFRX1 (*
integer library_binding = "gsclib090";
 *)

pll125_locked_pll_reg_0 ( .QN( net69 ), .D( pll125_status[1] ), .SI(
net70 ), .RN( n_13544 ), .CK( CLKPLL_IN ), .SE( n_1692 ), .Q(
pll125_locked_pll[0] ) );
SDFFRX1 (*
integer library_binding = "gsclib090";
 *)

prev_b100txdis_xtal_reg_2 ( .QN( n_6868 ), .D( BASE100TX_DIS_ER ), .SI(
net125 ), .RN( n_13929 ), .CK( CLKXTAL ), .SE( n_1696 ), .Q( n_14283 ) );
SDFFRX1 (*
integer library_binding = "gsclib090";
 *)

prev_b100txdis_xtal_reg_1 ( .QN( net124 ), .D( prev_b100txdis_xtal_0_ ),
.SI( n_14283 ), .RN( n_13929 ), .CK( CLKXTAL ), .SE( n_1692 ), .Q(
BASE100TX_DIS_ER ) );
SDFFRX1 (*
integer library_binding = "gsclib090";
 *)

prev_b100txdis_xtal_reg_0 ( .QN( net125 ), .D( n_391 ), .SI( net126 ),
.RN( n_13929 ), .CK( CLKXTAL ), .SE( n_1692 ), .Q(
prev_b100txdis_xtal_0_ ) );
SDFFRX1 (*
integer library_binding = "gsclib090";
 *)
time_count_reg_9
 ( .QN( net127 ), .D( nbus_1100_9_ ), .SI( net128 ), .RN( n_13929 ), .CK(
CLKXTAL ), .SE( n_1696 ), .Q( time_count[9] ) );
SDFFRX1 (*
integer library_binding = "gsclib090";
 *)
time_count_reg_8
 ( .QN( net128 ), .D( nbus_1100_8_ ), .SI( net129 ), .RN( n_13929 ), .CK(
CLKXTAL ), .SE( n_1692 ), .Q( time_count[8] ) );
SDFFRX1 (*
integer library_binding = "gsclib090";
 *)
time_count_reg_7
 ( .QN( net129 ), .D( nbus_1100_7_ ), .SI( net130 ), .RN( n_13931 ), .CK(
CLKXTAL ), .SE( n_1684 ), .Q( time_count[7] ) );
SDFFRX1 (*
integer library_binding = "gsclib090";
 *)
time_count_reg_6
 ( .QN( net130 ), .D( nbus_1100_6_ ), .SI( net131 ), .RN( n_13933 ), .CK(
CLKXTAL ), .SE( n_1684 ), .Q( time_count[6] ) );
SDFFRX1 (*
integer library_binding = "gsclib090";
 *)
time_count_reg_5
 ( .QN( net131 ), .D( n_384 ), .SI( net132 ), .RN( n_13933 ), .CK(
CLKXTAL ), .SE( n_1692 ), .Q( time_count[5] ) );
SDFFRX1 (*
integer library_binding = "gsclib090";
 *)
time_count_reg_4
 ( .QN( net132 ), .D( nbus_1100_4_ ), .SI( net133 ), .RN( n_13933 ), .CK(
CLKXTAL ), .SE( n_1692 ), .Q( time_count[4] ) );
SDFFRX1 (*
integer library_binding = "gsclib090";
 *)
time_count_reg_3
 ( .QN( net133 ), .D( nbus_1100_3_ ), .SI( net134 ), .RN( net121 ), .CK(
CLKXTAL ), .SE( n_1694 ), .Q( time_count[3] ) );
SDFFRX1 (*
integer library_binding = "gsclib090";
 *)
time_count_reg_2
 ( .QN( net134 ), .D( nbus_1100_2_ ), .SI( net135 ), .RN( net121 ), .CK(
CLKXTAL ), .SE( n_1684 ), .Q( time_count[2] ) );
SDFFRX1 (*
integer library_binding = "gsclib090";
 *)
time_count_reg_1
 ( .QN( net135 ), .D( n_383 ), .SI( net136 ), .RN( n_13933 ), .CK(
CLKXTAL ), .SE( n_1696 ), .Q( time_count[1] ) );
SDFFRX1 (*
integer library_binding = "gsclib090";
 *)
time_count_reg_0
 ( .QN( net136 ), .D( nbus_1100_0_ ), .SI( time_reset_xc_1_ ), .RN(
n_13933 ), .CK( CLKXTAL ), .SE( n_1696 ), .Q( time_count[0] ) );
SDFFRX1 (*
integer library_binding = "gsclib090";
 *)

time_reset_xc_reg_1 ( .QN( n_6844 ), .D( time_reset_xc_0_ ), .SI(
net137 ), .RN( n_13933 ), .CK( CLKXTAL ), .SE( n_1692 ), .Q(
time_reset_xc_1_ ) );
SDFFRX1 (*
integer library_binding = "gsclib090";
 *)

time_reset_xc_reg_0 ( .QN( net137 ), .D( n_389 ), .SI( net138 ), .RN(
n_13933 ), .CK( CLKXTAL ), .SE( n_2309 ), .Q( time_reset_xc_0_ ) );
SDFFRX1 (*
integer library_binding = "gsclib090";
 *)
time_reset_reg
 ( .QN( net138 ), .D( n_6393 ), .SI( net139 ), .RN( n_13933 ), .CK(
CLKXTAL ), .SE( n_2298 ), .Q( time_reset ) );
SDFFRX1 (*
integer library_binding = "gsclib090";
 *)

twenty_us_exp_xtal_reg_1 ( .QN( twenty_us_exp_xtal[1] ), .D(
twenty_us_exp_xtal[0] ), .SI( twenty_us_exp_xtal[0] ), .RN( n_13933 ),
.CK( CLKXTAL ), .SE( n_2309 ), .Q( net139 ) );
SDFFRX1 (*
integer library_binding = "gsclib090";
 *)

twenty_us_exp_xtal_reg_0 ( .QN( n_6801 ), .D( twenty_us_expired ), .SI(
prev3xtal_10disb ), .RN( n_13933 ), .CK( CLKXTAL ), .SE( n_2298 ), .Q(
twenty_us_exp_xtal[0] ) );
SDFFRX1 (*
integer library_binding = "gsclib090";
 *)

twenty_us_expired_reg ( .QN( net70 ), .D( n_6383 ), .SI( net71 ), .RN(
net8 ), .CK( CLKPLL_IN ), .SE( n_2305 ), .Q( twenty_us_expired ) );
SDFFRX1 (*
integer library_binding = "gsclib090";
 *)

genplld5_enable_reg ( .QN( n_6384 ), .D( n_398 ), .SI( net80 ), .RN(
n_13545 ), .CK( CLKPLL_IN ), .SE( n_2305 ), .Q( genplld5_enable ) );
SDFFRX1 (*
integer library_binding = "gsclib090";
 *)

prev3xtal_100disb_reg ( .QN( n_229 ), .D( prev2xtal_100disb ), .SI(
net140 ), .RN( net121 ), .CK( CLKXTAL ), .SE( n_1684 ), .Q(
prev3xtal_100disb ) );
SDFFRX1 (*
integer library_binding = "gsclib090";
 *)

prev2xtal_100disb_reg ( .QN( n_251 ), .D( prev1xtal_100disb ), .SI(
net142 ), .RN( n_13931 ), .CK( CLKXTAL ), .SE( n_1692 ), .Q(
prev2xtal_100disb ) );
SDFFRX1 (*
integer library_binding = "gsclib090";
 *)

prev1xtal_100disb_reg ( .QN( net142 ), .D( RPD_100_DISB ), .SI(
n_14294 ), .RN( n_13931 ), .CK( CLKXTAL ), .SE( n_1692 ), .Q(
prev1xtal_100disb ) );
SDFFRX1 (*
integer library_binding = "gsclib090";
 *)

prev3_rx10_rclk2_5_reg ( .QN( prev3_rx10_rclk2_5 ), .D(
prev2_rx10_rclk2_5 ), .SI( net83 ), .RN( n_13545 ), .CK( CLKPLL_IN ),
.SE( n_2298 ), .Q( net82 ) );
SDFFRX1 (*
integer library_binding = "gsclib090";
 *)

prev1_rx10_rclk2_5_reg ( .QN( net83 ), .D( n_258 ), .SI( scan_in1 ), .RN(
n_13544 ), .CK( CLKPLL_IN ), .SE( n_2309 ), .Q( prev1_rx10_rclk2_5 ) );

AO22X4 (*
integer library_binding = "gsclib090";
 *)
i_98 ( .A0(
x125_edge ), .A1( n_182 ), .B0( Flag100_to_10 ), .Y( n_6671 ), .B1(
n_292 ) );

OAI2BB1X2 (*
integer library_binding = "gsclib090";
 *)
i_93 ( .A0N(
Flag_rec_to_in ), .A1N( n_274 ), .B0( n_265 ), .Y( n_6563 ) );

NAND3X2 (*
integer library_binding = "gsclib090";
 *)
i_84 ( .C(
Flag_in_to_rec ), .Y( n_238 ), .B( n_246 ), .A( n_1129 ) );

OAI211X2 (*
integer library_binding = "gsclib090";
 *)
i_82 ( .C0(
n_6833 ), .A0( n_449 ), .A1( rxc_sel ), .B0( n_9 ), .Y( RXC_SC ) );
OAI211X2 (*
integer library_binding = "gsclib090";
 *)
i_95 ( .C0(
n_6856 ), .A0( n_283 ), .A1( n_157 ), .B0( cont2_5_disb ), .Y( n_5 ) );

MX2XL (*
integer library_binding = "gsclib090";
 *)
uu1 ( .Y( net1 ),
.S0( n_1396 ), .B( scan_reset ), .A( RESETPLL ) );
MX2XL (*
integer library_binding = "gsclib090";
 *)
uu4 ( .Y( net4 ),
.S0( n_1399 ), .B( n_1907 ), .A( n_13541 ) );
MX2XL (*
integer library_binding = "gsclib090";
 *)
uu5 ( .Y( net5 ),
.S0( n_1396 ), .B( scan_setinv ), .A( n_13548 ) );
MX2XL (*
integer library_binding = "gsclib090";
 *)
uu6 ( .Y( net6 ),
.S0( n_1446 ), .B( n_1907 ), .A( n_13545 ) );
MX2XL (*
integer library_binding = "gsclib090";
 *)
uu7 ( .Y( net7 ),
.S0( n_1446 ), .B( n_1907 ), .A( n_13544 ) );
MX2XL (*
integer library_binding = "gsclib090";
 *)
uu8 ( .Y( net8 ),
.S0( n_1446 ), .B( scan_resetinv ), .A( net4 ) );
MX2XL (*
integer library_binding = "gsclib090";
 *)
uu9 ( .Y( net9 ),
.S0( n_1446 ), .B( scan_resetinv ), .A( net4 ) );
MX2XL (*
integer library_binding = "gsclib090";
 *)
uu10 ( .Y( net10 ),
.S0( n_1396 ), .B( n_1907 ), .A( n_13539 ) );
MX2XL (*
integer library_binding = "gsclib090";
 *)
uu11 ( .Y( net11 ),
.S0( n_1396 ), .B( n_1907 ), .A( n_13537 ) );
MX2XL (*
integer library_binding = "gsclib090";
 *)
uu12 ( .Y( net12 ),
.S0( n_1396 ), .B( n_1907 ), .A( n_13535 ) );
MX2XL (*
integer library_binding = "gsclib090";
 *)
uu13 ( .Y( net13 ),
.S0( n_1446 ), .B( n_1907 ), .A( n_13532 ) );
MX2XL (*
integer library_binding = "gsclib090";
 *)
uu14 ( .Y( net14 ),
.S0( n_1399 ), .B( scan_setinv ), .A( n_13530 ) );
MX2XL (*
integer library_binding = "gsclib090";
 *)
uu15 ( .Y( net15 ),
.S0( n_1399 ), .B( scan_setinv ), .A( n_13529 ) );
MX2XL (*
integer library_binding = "gsclib090";
 *)
uu17 ( .Y( net121 ),
.S0( n_1399 ), .B( scan_resetinv ), .A( n_6880 ) );
MX2XL (*
integer library_binding = "gsclib090";
 *)
uu18 ( .Y( net122 ),
.S0( n_1399 ), .B( scan_setinv ), .A( n_13931 ) );
MX2XL (*
integer library_binding = "gsclib090";
 *)
uu19 ( .Y( net123 ),
.S0( n_1399 ), .B( scan_setinv ), .A( n_13929 ) );

BUFX12 (*
integer library_binding = "gsclib090";
 *)
i_12566 ( .Y(
BASE100TX_DIS ), .A( n_14283 ) );
BUFX12 (*
integer library_binding = "gsclib090";
 *)
i_12572 ( .Y(
BASE10_DIS ), .A( n_14294 ) );

INVX8 (*
integer library_binding = "gsclib090";
 *)
i_47 ( .Y( n_3409 ),
.A( n_13 ) );

NAND2X4 (*
integer library_binding = "gsclib090";
 *)
i_36 ( .Y( n_64 ),
.B( n_78342 ), .A( n_60 ) );

INVX4 (*
integer library_binding = "gsclib090";
 *)
i_76 ( .Y( n_60 ),
.A( n_63 ) );

INVX6 (*
integer library_binding = "gsclib090";
 *)
i_74 ( .Y( n_3 ),
.A( n_64 ) );

OAI2BB1X4 (*
integer library_binding = "gsclib090";
 *)
i_48 ( .A0N(
n_10 ), .A1N( n_2346 ), .B0( n_11 ), .Y( n_354 ) );

AND2X2 (*
integer library_binding = "gsclib090";
 *)
i_39 ( .Y( n_10 ),
.B( rclk25_sync1 ), .A( n_78310 ) );

AND2X8 (*
integer library_binding = "gsclib090";
 *)
i_38 ( .Y( n_11 ),
.B( n_6 ), .A( n_371 ) );

AND2XL (*
integer library_binding = "gsclib090";
 *)
i_188 ( .Y( n_381 ),
.B( prev2_5_mr100 ), .A( n_183 ) );

OAI2BB1XL (*
integer library_binding = "gsclib090";
 *)
i_37 ( .A0N(
n_6854 ), .A1N( rclk2_5_good_pll ), .B0( Flag_rclk2_5_int_to_ext ), .Y(
n_367 ) );
OAI2BB1XL (*
integer library_binding = "gsclib090";
 *)
i_169 ( .A0N(
n_10 ), .A1N( n_6454 ), .B0( n_11 ), .Y( n_134 ) );

OAI211XL (*
integer library_binding = "gsclib090";
 *)
i_11 ( .C0(
n_362 ), .A0( n_129698261 ), .A1( n_129828262 ), .B0( n_474 ), .Y(
n_361 ) );
OAI211XL (*
integer library_binding = "gsclib090";
 *)
i_88 ( .C0(
n_2210 ), .A0( n_246 ), .A1( n_129988258 ), .B0( n_149 ), .Y( n_6575 ) );

XNOR2X1 (*
integer library_binding = "gsclib090";
 *)
i_44 ( .Y( n_263 ),
.B( sync2_rclk2_5_good_pll ), .A( n_62 ) );
XNOR2X1 (*
integer library_binding = "gsclib090";
 *)
i_45 ( .Y( n_264 ),
.B( RCLK25_GOOD ), .A( prev_rclk25_good ) );
XNOR2X1 (*
integer library_binding = "gsclib090";
 *)
i_46 ( .Y(
n_26515 ), .B( n_182 ), .A( x125_sel_sync3 ) );
XNOR2X1 (*
integer library_binding = "gsclib090";
 *)
i_63 ( .Y( n_273 ),
.B( n_580 ), .A( time_count[7] ) );
XNOR2X1 (*
integer library_binding = "gsclib090";
 *)
i_64 ( .Y(
n_27416 ), .B( n_578 ), .A( time_count[6] ) );
XNOR2X1 (*
integer library_binding = "gsclib090";
 *)
i_66 ( .Y( n_275 ),
.B( time_count[4] ), .A( n_576 ) );
XNOR2X1 (*
integer library_binding = "gsclib090";
 *)
i_67 ( .Y( n_276 ),
.B( n_575 ), .A( time_count[3] ) );
XNOR2X1 (*
integer library_binding = "gsclib090";
 *)
i_68 ( .Y( n_277 ),
.B( time_count[2] ), .A( n_574 ) );

MXI2X4 (*
integer library_binding = "gsclib090";
 *)
i_41 ( .Y( n_261 ),
.S0( cont2_5_sel ), .B( sqw2_5_125 ), .A( CLK2_5_NO_FF ) );

XOR2X1 (*
integer library_binding = "gsclib090";
 *)
i_55 ( .Y( n_407 ),
.B( count160[5] ), .A( n_541 ) );
XOR2X1 (*
integer library_binding = "gsclib090";
 *)
i_21 ( .Y( n_395 ),
.B( fastcount[2] ), .A( n_550 ) );
XOR2X1 (*
integer library_binding = "gsclib090";
 *)
i_49 ( .Y( n_268 ),
.B( count125_3_ ), .A( n_520 ) );

NAND4X4 (*
integer library_binding = "gsclib090";
 *)
i_11235 ( .D(
n_14379 ), .C( n_6866 ), .Y( n_425 ), .B( n_426 ), .A( n_6865 ) );

AO22X1 (*
integer library_binding = "gsclib090";
 *)
i_139 ( .A0(
nbus_1115_4_ ), .A1( count125_5_ ), .B0( n_517 ), .Y( n_416 ), .B1(
count125_4_ ) );
AO22X1 (*
integer library_binding = "gsclib090";
 *)
i_211834 ( .A0(
nbus_1115_0_ ), .A1( count125_1_ ), .B0( n_522 ), .Y( n_414 ), .B1(
count125_0_ ) );
AO22X1 (*
integer library_binding = "gsclib090";
 *)
i_122 ( .A0(
nbus_1100_0_ ), .A1( time_count[5] ), .B0( n_288 ), .Y( n_384 ), .B1(
n_6844 ) );
AO22X1 (*
integer library_binding = "gsclib090";
 *)
i_126 ( .A0(
nbus_1100_0_ ), .A1( time_count[1] ), .B0( time_count[0] ), .Y( n_383 ),
.B1( n_581 ) );

AOI21X4 (*
integer library_binding = "gsclib090";
 *)
i_11082 ( .A0(
n_13049 ), .A1( Flag100_to_10 ), .B0( n_434 ), .Y( n_433 ) );

AOI21XL (*
integer library_binding = "gsclib090";
 *)
i_11443 ( .A0(
n_361 ), .A1( n_478 ), .B0( n_436 ), .Y( n_435 ) );

NOR2BX4 (*
integer library_binding = "gsclib090";
 *)
i_179 ( .AN(
n_13622 ), .Y( n_450 ), .B( rclk2_5_good_pll ) );

NAND2BXL (*
integer library_binding = "gsclib090";
 *)
i_10738 ( .AN(
n_1201 ), .Y( n_452 ), .B( n_463 ) );
NAND2BXL (*
integer library_binding = "gsclib090";
 *)
i_10894 ( .AN(
n_13051 ), .Y( n_434 ), .B( n_130468256 ) );
NAND2BXL (*
integer library_binding = "gsclib090";
 *)
i_94 ( .AN(
rxc_sel ), .Y( n_292 ), .B( n_13049 ) );
NAND2BXL (*
integer library_binding = "gsclib090";
 *)
i_6489 ( .AN(
rclk25_disb ), .Y( n_6706 ), .B( n_463 ) );

OR2X1 (*
integer library_binding = "gsclib090";
 *)
i_10360 ( .Y(
n_12991 ), .B( cnt125_at_1 ), .A( cnt125_at_6 ) );
OR2X1 (*
integer library_binding = "gsclib090";
 *)
i_10646 ( .Y(
n_424 ), .B( n_12957 ), .A( n_12941 ) );
OR2X1 (*
integer library_binding = "gsclib090";
 *)
i_10836 ( .Y(
n_422 ), .B( n_12980 ), .A( n_12981 ) );
OR2X1 (*
integer library_binding = "gsclib090";
 *)
i_10833 ( .Y(
n_410 ), .B( n_499 ), .A( n_12980 ) );
OR2X1 (*
integer library_binding = "gsclib090";
 *)
i_28 ( .Y( n_300 ),
.B( pll160_locked_plln[1] ), .A( pll125_locked_plln[1] ) );
OR2X1 (*
integer library_binding = "gsclib090";
 *)
i_0 ( .Y( n_6 ), .B(
n_130028259 ), .A( n_78310 ) );

MXI2X1 (*
integer library_binding = "gsclib090";
 *)
i_338 ( .Y( n_466 ),
.S0( txc_sel ), .B( n_899 ), .A( n_501 ) );
MXI2X1 (*
integer library_binding = "gsclib090";
 *)
i_10813 ( .Y(
n_457 ), .S0( prev2_mr100 ), .B( selorlocked125 ), .A( selorlocked160 ) );
MXI2X1 (*
integer library_binding = "gsclib090";
 *)
i_42 ( .Y( n_262 ),
.S0( prev2_mr100 ), .B( LINK100_DOWN ), .A( LINK10_DOWN ) );
MXI2X1 (*
integer library_binding = "gsclib090";
 *)
i_50 ( .Y( n_6631 ),
.S0( n_3409 ), .B( n_38 ), .A( n_39 ) );
MXI2X1 (*
integer library_binding = "gsclib090";
 *)
i_70 ( .Y( n_6569 ),
.S0( n_3409 ), .B( n_18 ), .A( n_41 ) );

NOR4XL (*
integer library_binding = "gsclib090";
 *)
i_10168 ( .D(
txc2_5_disb ), .C( cnt160_at_3f_pos ), .Y( txc2_5_enable ), .B(
slvtxc2_5_pd ), .A( clk160_disb ) );

NOR3BX4 (*
integer library_binding = "gsclib090";
 *)
i_10291 ( .AN(
n_13227 ), .C( n_487 ), .Y( n_13030 ), .B( n_99 ) );

NOR3BX2 (*
integer library_binding = "gsclib090";
 *)
i_11278 ( .AN(
n_465 ), .C( Flag100_to_10 ), .Y( n_14031 ), .B( n_434 ) );

AOI211X1 (*
integer library_binding = "gsclib090";
 *)
i_11344 ( .C0(
n_129828262 ), .A0( n_129688264 ), .A1( n_129698261 ), .B0(
Flag_rclk2_5_int_to_ext ), .Y( n_14131 ) );
AOI211X1 (*
integer library_binding = "gsclib090";
 *)
i_43 ( .C0(
n_251 ), .A0( prev2xtal_10disb ), .A1( n_227 ), .B0( n_440 ), .Y(
n_374 ) );

NOR2X2 (*
integer library_binding = "gsclib090";
 *)
i_10262 ( .Y(
n_13049 ), .B( meta_rclk2_5[1] ), .A( n_249 ) );
NOR2X2 (*
integer library_binding = "gsclib090";
 *)
i_013134 ( .Y(
n_63 ), .B( n_246 ), .A( n_129988258 ) );

NAND2X2 (*
integer library_binding = "gsclib090";
 *)
i_10349 ( .Y(
n_129988258 ), .B( sqw25_sync1 ), .A( sqw25_125 ) );
NAND2X2 (*
integer library_binding = "gsclib090";
 *)
i_10330 ( .Y(
n_418 ), .B( prev2pll_100disb ), .A( n_6834 ) );

NAND4BXL (*
integer library_binding = "gsclib090";
 *)
i_10393 ( .D(
n_219 ), .AN( cont2_5_edge ), .C( n_2 ), .Y( n_129688264 ), .B(
prev3_rx10_rclk2_5 ) );

AND4X1 (*
integer library_binding = "gsclib090";
 *)
i_10424 ( .D(
n_348 ), .C( n_492 ), .Y( n_12941 ), .B( prev3_cont2_5 ), .A( n_218 ) );
AND4X1 (*
integer library_binding = "gsclib090";
 *)
i_10298 ( .D(
prev2_clk25 ), .C( prev1_clk25 ), .Y( n_13029 ), .B( txc_sel ), .A(
n_492 ) );

NAND4XL (*
integer library_binding = "gsclib090";
 *)
i_10389 ( .D(
n_219 ), .C( n_2 ), .Y( n_129698261 ), .B( prev3_rx10_rclk2_5 ), .A(
cont2_5_edge ) );
NAND4XL (*
integer library_binding = "gsclib090";
 *)
i_86 ( .D( n_246 ),
.C( n_13003 ), .Y( n_2210 ), .B( Flag_in_to_rec ), .A( n_1129 ) );

NAND4BX1 (*
integer library_binding = "gsclib090";
 *)
i_10304 ( .D(
n_2 ), .AN( txc_sel ), .C( prev2_mr100 ), .Y( n_130288263 ), .B(
pll125_locked_pll[1] ) );
NAND4BX1 (*
integer library_binding = "gsclib090";
 *)
i_257413 ( .D(
time_count[3] ), .AN( n_575 ), .C( time_count[5] ), .Y( n_578 ), .B(
time_count[4] ) );
NAND4BX1 (*
integer library_binding = "gsclib090";
 *)
i_7 ( .D(
n_14083 ), .AN( n_1512 ), .C( n_1711 ), .Y( n_385 ), .B( n_2113 ) );

NOR2X4 (*
integer library_binding = "gsclib090";
 *)
i_10400 ( .Y(
n_13622 ), .B( cont2_5_disb ), .A( n_261 ) );

NAND3BX1 (*
integer library_binding = "gsclib090";
 *)
i_17592 ( .AN(
count125_1_ ), .C( count125_2_ ), .Y( n_13785 ), .B( n_546 ) );
NAND3BX1 (*
integer library_binding = "gsclib090";
 *)
i_10452 ( .AN(
n_229 ), .C( n_227 ), .Y( n_129138266 ), .B( xoff_20 ) );
NAND3BX1 (*
integer library_binding = "gsclib090";
 *)
i_10238 ( .AN(
mr_txc2_5_pd_pll ), .C( slvtxc2_5_pd ), .Y( n_130678255 ), .B( n_479 ) );

AO21X1 (*
integer library_binding = "gsclib090";
 *)
i_17969 ( .A0(
twenty_us_expired ), .A1( n_13533 ), .B0( n_6385 ), .Y( n_6383 ) );
AO21X1 (*
integer library_binding = "gsclib090";
 *)
i_17962 ( .A0(
n_13533 ), .A1( XOFF_20 ), .B0( n_6379 ), .Y( n_6377 ) );
AO21X1 (*
integer library_binding = "gsclib090";
 *)
i_17955 ( .A0(
n_13534 ), .A1( xoff_20_pc_0_ ), .B0( n_6373 ), .Y( n_6371 ) );
AO21X1 (*
integer library_binding = "gsclib090";
 *)
i_17948 ( .A0(
n_13534 ), .A1( time_reset_pc[6] ), .B0( n_6367 ), .Y( n_6365 ) );
AO21X1 (*
integer library_binding = "gsclib090";
 *)
i_17941 ( .A0(
n_13534 ), .A1( time_reset_pc[5] ), .B0( n_6361 ), .Y( n_6359 ) );
AO21X1 (*
integer library_binding = "gsclib090";
 *)
i_17934 ( .A0(
n_13534 ), .A1( time_reset_pc[4] ), .B0( n_6355 ), .Y( n_6353 ) );
AO21X1 (*
integer library_binding = "gsclib090";
 *)
i_17927 ( .A0(
n_13534 ), .A1( time_reset_pc[3] ), .B0( n_6349 ), .Y( n_6347 ) );
AO21X1 (*
integer library_binding = "gsclib090";
 *)
i_17920 ( .A0(
n_13534 ), .A1( time_reset_pc[2] ), .B0( n_6343 ), .Y( n_6341 ) );
AO21X1 (*
integer library_binding = "gsclib090";
 *)
i_17911 ( .A0(
n_13534 ), .A1( time_reset_pc[1] ), .B0( n_6337 ), .Y( n_6335 ) );
AO21X1 (*
integer library_binding = "gsclib090";
 *)
i_54 ( .A0(
count160[4] ), .A1( n_14387 ), .B0( n_541 ), .Y( n_406 ) );
AO21X1 (*
integer library_binding = "gsclib090";
 *)
i_51 ( .A0(
count160[1] ), .A1( count160[0] ), .B0( n_526 ), .Y( n_403 ) );
AO21X1 (*
integer library_binding = "gsclib090";
 *)
i_203547 ( .A0(
fastcount[1] ), .A1( fastcount[0] ), .B0( n_550 ), .Y( n_394 ) );
AO21X1 (*
integer library_binding = "gsclib090";
 *)
i_10905 ( .A0(
n_399 ), .A1( n_181 ), .B0( n_434 ), .Y( n_392 ) );
AO21X1 (*
integer library_binding = "gsclib090";
 *)
i_57 ( .A0(
n_6870 ), .A1( pll160_status[1] ), .B0( n_334 ), .Y( n_269 ) );
AO21X1 (*
integer library_binding = "gsclib090";
 *)
i_59 ( .A0(
n_6868 ), .A1( pll125_status[1] ), .B0( n_316 ), .Y( n_270 ) );
AO21X1 (*
integer library_binding = "gsclib090";
 *)
i_132 ( .A0(
n_333 ), .A1( n_129138266 ), .B0( pll160_status[1] ), .Y( n_331 ) );

AOI2BB1X1 (*
integer library_binding = "gsclib090";
 *)
i_17982 ( .A0N(
time_reset ), .A1N( n_12888 ), .B0( n_13243 ), .Y( n_6393 ) );

NAND2XL (*
integer library_binding = "gsclib090";
 *)
i_18129 ( .Y(
n_6496 ), .B( sqw2_5_125 ), .A( n_423 ) );
NAND2XL (*
integer library_binding = "gsclib090";
 *)
i_10275 ( .Y(
n_130468256 ), .B( n_182 ), .A( x125_edge ) );
NAND2XL (*
integer library_binding = "gsclib090";
 *)
i_83 ( .Y( n_246 ),
.B( RCLK25_GOOD ), .A( rclk25_good_edge ) );

MX2X1 (*
integer library_binding = "gsclib090";
 *)
i_18143 ( .Y(
n_6505 ), .S0( n_14463 ), .B( n_417 ), .A( Flag_rclk2_5_ext_to_int ) );

AO21XL (*
integer library_binding = "gsclib090";
 *)
i_18173 ( .A0(
n_422 ), .A1( n_436 ), .B0( n_6532 ), .Y( n_6529 ) );

MX3XL (*
integer library_binding = "gsclib090";
 *)
i_18187 ( .C(
rclk2_5_good_pll ), .Y( n_6541 ), .S0( rclk2_5_good_edge ), .B(
sync2_rclk2_5_good_pll ), .S1( n_435 ), .A( Flag_rclk2_5_int_to_ext ) );

NOR2BX1 (*
integer library_binding = "gsclib090";
 *)
i_911649 ( .AN(
pll125_status[1] ), .Y( nbus_1106[0] ), .B( sync_all_disb_plln[1] ) );
NOR2BX1 (*
integer library_binding = "gsclib090";
 *)
i_911651 ( .AN(
pll160_status[1] ), .Y( nbus_1109[0] ), .B( sync_all_disb_plln[1] ) );
NOR2BX1 (*
integer library_binding = "gsclib090";
 *)
i_18175 ( .AN(
Flag_rclk2_5_int_to_ext ), .Y( n_6532 ), .B( n_436 ) );
NOR2BX1 (*
integer library_binding = "gsclib090";
 *)
i_17970 ( .AN(
n_12886 ), .Y( n_6385 ), .B( n_6384 ) );
NOR2BX1 (*
integer library_binding = "gsclib090";
 *)
i_17963 ( .AN(
xoff_20_pc_0_ ), .Y( n_6379 ), .B( n_6384 ) );
NOR2BX1 (*
integer library_binding = "gsclib090";
 *)
i_17956 ( .AN(
xoff_20 ), .Y( n_6373 ), .B( n_13533 ) );
NOR2BX1 (*
integer library_binding = "gsclib090";
 *)
i_17949 ( .AN(
time_reset_pc[5] ), .Y( n_6367 ), .B( n_13533 ) );
NOR2BX1 (*
integer library_binding = "gsclib090";
 *)
i_17942 ( .AN(
time_reset_pc[4] ), .Y( n_6361 ), .B( n_6384 ) );
NOR2BX1 (*
integer library_binding = "gsclib090";
 *)
i_17935 ( .AN(
time_reset_pc[3] ), .Y( n_6355 ), .B( n_6384 ) );
NOR2BX1 (*
integer library_binding = "gsclib090";
 *)
i_17928 ( .AN(
time_reset_pc[2] ), .Y( n_6349 ), .B( n_6384 ) );
NOR2BX1 (*
integer library_binding = "gsclib090";
 *)
i_17921 ( .AN(
time_reset_pc[1] ), .Y( n_6343 ), .B( n_13533 ) );
NOR2BX1 (*
integer library_binding = "gsclib090";
 *)
i_10608 ( .AN(
n_6844 ), .Y( n_14337 ), .B( n_12910 ) );
NOR2BX1 (*
integer library_binding = "gsclib090";
 *)
i_17912 ( .AN(
time_reset_pc[0] ), .Y( n_6337 ), .B( n_13533 ) );
NOR2BX1 (*
integer library_binding = "gsclib090";
 *)
i_10622 ( .AN(
MR_AN_ENAB ), .Y( nbus_1104_0_ ), .B( n_262 ) );
NOR2BX1 (*
integer library_binding = "gsclib090";
 *)
i_10371 ( .AN(
Flag_rclk2_5_int_to_ext ), .Y( n_12981 ), .B( rclk2_5_good_pll ) );
NOR2BX1 (*
integer library_binding = "gsclib090";
 *)
i_10343 ( .AN(
Flag_in_to_rec ), .Y( n_13003 ), .B( n_14445 ) );
NOR2BX1 (*
integer library_binding = "gsclib090";
 *)
i_10267 ( .AN(
Flag10_to_100 ), .Y( n_13050 ), .B( rxc_sel ) );
NOR2BX1 (*
integer library_binding = "gsclib090";
 *)
i_196 ( .AN(
n_6844 ), .Y( n_581 ), .B( time_count[1] ) );
NOR2BX1 (*
integer library_binding = "gsclib090";
 *)
i_206 ( .AN(
AN_ACTIVE_XTND ), .Y( n_564 ), .B( sync_all_disb_pll[1] ) );
NOR2BX1 (*
integer library_binding = "gsclib090";
 *)
i_300 ( .AN(
pll160_locked_pll[1] ), .Y( n_492 ), .B( prev2_mr100 ) );
NOR2BX1 (*
integer library_binding = "gsclib090";
 *)
i_313 ( .AN(
n_246 ), .Y( n_482 ), .B( Flag_in_to_rec ) );
NOR2BX1 (*
integer library_binding = "gsclib090";
 *)
i_11003 ( .AN(
n_130978267 ), .Y( n_437 ), .B( n_13098 ) );
NOR2BX1 (*
integer library_binding = "gsclib090";
 *)
i_11116 ( .AN(
x125_edge ), .Y( n_431 ), .B( res_x125_edge ) );
NOR2BX1 (*
integer library_binding = "gsclib090";
 *)
i_11121 ( .AN(
rclk2_5_good_edge ), .Y( n_430 ), .B( res_rclk2_5_good_edge ) );
NOR2BX1 (*
integer library_binding = "gsclib090";
 *)
i_11472 ( .AN(
n_157 ), .Y( n_423 ), .B( cnt125_at_24 ) );
NOR2BX1 (*
integer library_binding = "gsclib090";
 *)
i_11545 ( .AN(
rclk25_good_edge ), .Y( n_420 ), .B( res_rclk25_edge ) );
NOR2BX1 (*
integer library_binding = "gsclib090";
 *)
i_69 ( .AN(
n_417 ), .Y( n_278 ), .B( Flag_rclk2_5_int_to_ext ) );
NOR2BX1 (*
integer library_binding = "gsclib090";
 *)
i_110 ( .AN(
n_401 ), .Y( n_318 ), .B( Flag_in_to_rec ) );

CLKMX2X6 (*
integer library_binding = "gsclib090";
 *)
i_18239 ( .Y(
n_6581 ), .S0( n_3409 ), .B( res_rclk25_edge ), .A( n_412 ) );

NOR4X1 (*
integer library_binding = "gsclib090";
 *)
i_17 ( .D(
n_13266 ), .C( count125_4_ ), .Y( n_13839 ), .B( count125_5_ ), .A(
n_135 ) );
NOR4X1 (*
integer library_binding = "gsclib090";
 *)
i_10251 ( .D(
pll160_locked_pos ), .C( prev_x160_sel_pos ), .Y( n_14146 ), .B(
cnt160_at_0_pos ), .A( meta_rpd_10_disb[1] ) );
NOR4X1 (*
integer library_binding = "gsclib090";
 *)
i_10190 ( .D(
cnt160_at_8_pos ), .C( pll160_locked_pos ), .Y( n_13358 ), .B(
prev_x160_sel_pos ), .A( meta_rpd_10_disb[1] ) );
NOR4X1 (*
integer library_binding = "gsclib090";
 *)
i_10308 ( .D(
txc_sel ), .C( prev_x160_sel_7_pll ), .Y( n_13027 ), .B( n_232 ), .A(
n_485 ) );
NOR4X1 (*
integer library_binding = "gsclib090";
 *)
i_10192 ( .D(
slvtxc25_pd ), .C( prev2pll_100disb ), .Y( n_13098 ), .B( cnt125_at_4 ),
.A( cnt125_at_9 ) );
NOR4X1 (*
integer library_binding = "gsclib090";
 *)
i_10167 ( .D(
clk160_disb ), .C( slvtxc2_5_pd ), .Y( txc2_5n_enable ), .B(
txc2_5_disb ), .A( cnt160_at_1f_pos ) );
NOR4X1 (*
integer library_binding = "gsclib090";
 *)
i_274 ( .D(
n_19560 ), .C( prev_x160_sel_4_ ), .Y( n_515 ), .B( prev_x160_sel_5_ ),
.A( prev_x160_sel_6_ ) );

OAI21X1 (*
integer library_binding = "gsclib090";
 *)
i_18286 ( .A0(
n_232 ), .A1( n_425 ), .B0( n_6617 ), .Y( n_6615 ) );

OAI21X2 (*
integer library_binding = "gsclib090";
 *)
i_18287 ( .A0(
n_495 ), .A1( sync_all_disb_pll[1] ), .B0( n_425 ), .Y( n_6617 ) );

NOR4BX1 (*
integer library_binding = "gsclib090";
 *)
i_16617 ( .D(
count125_1_ ), .AN( count125_0_ ), .C( count125_3_ ), .Y( n_13526 ), .B(
count125_2_ ) );
NOR4BX1 (*
integer library_binding = "gsclib090";
 *)
i_17983 ( .D(
count125_1_ ), .AN( count125_3_ ), .C( count125_2_ ), .Y( n_14285 ), .B(
count125_0_ ) );

OAI31XL (*
integer library_binding = "gsclib090";
 *)
i_18322 ( .A0(
n_431 ), .A1( n_26515 ), .B0( n_6646 ), .Y( n_6643 ), .A2( x125_edge ) );
OAI31XL (*
integer library_binding = "gsclib090";
 *)
i_18249 ( .A0(
n_264 ), .A1( n_420 ), .B0( n_6592 ), .Y( n_6589 ), .A2(
rclk25_good_edge ) );
OAI31XL (*
integer library_binding = "gsclib090";
 *)
i_18166 ( .A0(
n_263 ), .A1( n_430 ), .B0( n_6526 ), .Y( n_6523 ), .A2(
rclk2_5_good_edge ) );
OAI31XL (*
integer library_binding = "gsclib090";
 *)
i_111833 ( .A0(
n_519 ), .A1( cnt125_at_8 ), .B0( n_339 ), .Y( n_415 ), .A2(
count125_2_ ) );
OAI31XL (*
integer library_binding = "gsclib090";
 *)
i_61 ( .A0(
n_534 ), .A1( time_count[9] ), .B0( n_299 ), .Y( n_271 ), .A2( n_572 ) );
OAI31XL (*
integer library_binding = "gsclib090";
 *)
i_62 ( .A0(
n_532 ), .A1( time_count[8] ), .B0( n_297 ), .Y( n_272 ), .A2( n_578 ) );

CLKMX2X2 (*
integer library_binding = "gsclib090";
 *)
i_18342 ( .Y(
n_6659 ), .S0( n_14031 ), .B( n_399 ), .A( Flag10_to_100 ) );
CLKMX2X2 (*
integer library_binding = "gsclib090";
 *)
i_18180 ( .Y(
n_6535 ), .S0( n_14131 ), .B( n_12968 ), .A( cont2_5_edge ) );
CLKMX2X2 (*
integer library_binding = "gsclib090";
 *)
i_18150 ( .Y(
n_6511 ), .S0( n_435 ), .B( res_rclk2_5_good_edge ), .A( n_410 ) );
CLKMX2X2 (*
integer library_binding = "gsclib090";
 *)
i_17886 ( .Y(
n_6315 ), .S0( cnt125_at_8 ), .B( n_416 ), .A( count125_5_ ) );
CLKMX2X2 (*
integer library_binding = "gsclib090";
 *)
i_17879 ( .Y(
n_6309 ), .S0( cnt125_at_8 ), .B( nbus_1115_4_ ), .A( count125_4_ ) );

AOI211XL (*
integer library_binding = "gsclib090";
 *)
i_282 ( .C0(
rclk2_5_disb ), .A0( n_981 ), .A1( rclk2_5_good_pll ), .B0( n_294 ), .Y(
n_284 ) );

OAI211X1 (*
integer library_binding = "gsclib090";
 *)
i_18364 ( .C0(
x125_edge ), .A0( n_182 ), .A1( n_181 ), .B0( n_427 ), .Y( n_6679 ) );
OAI211X1 (*
integer library_binding = "gsclib090";
 *)
i_129 ( .C0(
n_6781 ), .A0( time_count[3] ), .A1( time_count[2] ), .B0(
time_count[4] ), .Y( n_327 ) );

AND2X1 (*
integer library_binding = "gsclib090";
 *)
i_125 ( .Y(
nbus_1100_2_ ), .B( n_6844 ), .A( n_277 ) );
AND2X1 (*
integer library_binding = "gsclib090";
 *)
i_124 ( .Y(
nbus_1100_3_ ), .B( n_15822 ), .A( n_276 ) );
AND2X1 (*
integer library_binding = "gsclib090";
 *)
i_123 ( .Y(
nbus_1100_4_ ), .B( n_6844 ), .A( n_275 ) );
AND2X1 (*
integer library_binding = "gsclib090";
 *)
i_121 ( .Y(
nbus_1100_6_ ), .B( n_15822 ), .A( n_27416 ) );
AND2X1 (*
integer library_binding = "gsclib090";
 *)
i_120 ( .Y(
nbus_1100_7_ ), .B( n_15822 ), .A( n_273 ) );
AND2X1 (*
integer library_binding = "gsclib090";
 *)
i_119 ( .Y(
nbus_1100_8_ ), .B( n_6844 ), .A( n_272 ) );
AND2X1 (*
integer library_binding = "gsclib090";
 *)
i_118 ( .Y(
nbus_1100_9_ ), .B( n_6844 ), .A( n_271 ) );
AND2X1 (*
integer library_binding = "gsclib090";
 *)
i_17914 ( .Y(
n_13639 ), .B( count160[3] ), .A( n_527 ) );
AND2X1 (*
integer library_binding = "gsclib090";
 *)
i_4212202 ( .Y(
nbus_1110_1_ ), .B( pll125_status[0] ), .A( n_270 ) );
AND2X1 (*
integer library_binding = "gsclib090";
 *)
i_4212196 ( .Y(
nbus_1114_1_ ), .B( pll160_status[0] ), .A( n_269 ) );
AND2X1 (*
integer library_binding = "gsclib090";
 *)
i_10387 ( .Y(
n_12970 ), .B( Flag_rclk2_5_ext_to_int ), .A( rclk2_5_good_pll ) );
AND2X1 (*
integer library_binding = "gsclib090";
 *)
i_10264 ( .Y(
n_13051 ), .B( Flag100_to_10 ), .A( rxc_sel ) );

OAI2BB1X1 (*
integer library_binding = "gsclib090";
 *)
i_18409 ( .A0N(
mr_txc2_5_pd_pll ), .A1N( n_432 ), .B0( n_6712 ), .Y( n_6709 ) );
OAI2BB1X1 (*
integer library_binding = "gsclib090";
 *)
i_18349 ( .A0N(
n_402 ), .A1N( n_427 ), .B0( n_6668 ), .Y( n_6665 ) );
OAI2BB1X1 (*
integer library_binding = "gsclib090";
 *)
i_150 ( .A0N(
n_130248254 ), .A1N( n_6864 ), .B0( sync_all_disb_pll[1] ), .Y( n_426 ) );
OAI2BB1X1 (*
integer library_binding = "gsclib090";
 *)
i_10487 ( .A0N(
n_515 ), .A1N( n_512 ), .B0( nbus_1089_0_8265 ), .Y( n_419 ) );
OAI2BB1X1 (*
integer library_binding = "gsclib090";
 *)
i_10891 ( .A0N(
n_181 ), .A1N( n_6847 ), .B0( n_130468256 ), .Y( n_402 ) );
OAI2BB1X1 (*
integer library_binding = "gsclib090";
 *)
i_72 ( .A0N(
pll125_locked_plln[1] ), .A1N( n_19560 ), .B0( an_link_down_plln[1] ),
.Y( n_1512 ) );
OAI2BB1X1 (*
integer library_binding = "gsclib090";
 *)
i_100 ( .A0N(
n_392 ), .A1N( n_427 ), .B0( n_6738 ), .Y( n_6735 ) );

NAND4X1 (*
integer library_binding = "gsclib090";
 *)
i_18417 ( .D(
n_458 ), .C( n_432 ), .Y( n_6717 ), .B( mr_txc2_5_pd_pll ), .A( n_479 ) );
NAND4X1 (*
integer library_binding = "gsclib090";
 *)
i_17894 ( .D(
cnt125_at_8 ), .C( count125_4_ ), .Y( n_6323 ), .B( n_135 ), .A(
count125_5_ ) );
NAND4X1 (*
integer library_binding = "gsclib090";
 *)
i_147406 ( .D(
time_count[2] ), .C( time_count[1] ), .Y( n_571 ), .B( time_count[4] ),
.A( time_count[3] ) );
NAND4X1 (*
integer library_binding = "gsclib090";
 *)
i_12 ( .D(
time_count[5] ), .C( time_count[6] ), .Y( n_534 ), .B( time_count[7] ),
.A( time_count[8] ) );
NAND4X1 (*
integer library_binding = "gsclib090";
 *)
i_34 ( .D(
count160[1] ), .C( count160[3] ), .Y( n_530 ), .B( count160[4] ), .A(
count160[2] ) );
NAND4X1 (*
integer library_binding = "gsclib090";
 *)
i_97 ( .D( n_557 ),
.C( n_560 ), .Y( n_305 ), .B( n_561 ), .A( n_555 ) );

NAND2BX1 (*
integer library_binding = "gsclib090";
 *)
i_18418 ( .AN(
n_432 ), .Y( n_6718 ), .B( txc2_5_disb ) );
NAND2BX1 (*
integer library_binding = "gsclib090";
 *)
i_18411 ( .AN(
n_432 ), .Y( n_6712 ), .B( slvtxc2_5_pd ) );
NAND2BX1 (*
integer library_binding = "gsclib090";
 *)
i_11479 ( .AN(
sync_all_disb_pll[1] ), .Y( n_14379 ), .B( n_495 ) );
NAND2BX1 (*
integer library_binding = "gsclib090";
 *)
i_20 ( .AN(
n_578 ), .Y( n_580 ), .B( time_count[6] ) );
NAND2BX1 (*
integer library_binding = "gsclib090";
 *)
i_14 ( .AN(
n_575 ), .Y( n_576 ), .B( time_count[3] ) );
NAND2BX1 (*
integer library_binding = "gsclib090";
 *)
i_13 ( .AN(
n_571 ), .Y( n_572 ), .B( time_count[0] ) );
NAND2BX1 (*
integer library_binding = "gsclib090";
 *)
i_26 ( .AN(
n_13029 ), .Y( n_495 ), .B( n_130288263 ) );
NAND2BX1 (*
integer library_binding = "gsclib090";
 *)
i_10356 ( .AN(
cnt125_at_8 ), .Y( TXC25_ALIGN ), .B( cnt125_at_3 ) );
NAND2BX1 (*
integer library_binding = "gsclib090";
 *)
i_10845 ( .AN(
n_13003 ), .Y( n_438 ), .B( n_246 ) );
NAND2BX1 (*
integer library_binding = "gsclib090";
 *)
i_11305 ( .AN(
n_13068 ), .Y( n_432 ), .B( n_130678255 ) );
NAND2BX1 (*
integer library_binding = "gsclib090";
 *)
i_10874 ( .AN(
n_12970 ), .Y( n_417 ), .B( n_129828262 ) );
NAND2BX1 (*
integer library_binding = "gsclib090";
 *)
i_555778 ( .AN(
time_count[9] ), .Y( n_12910 ), .B( n_327 ) );
NAND2BX1 (*
integer library_binding = "gsclib090";
 *)
i_10257 ( .AN(
prev2pll_100disb ), .Y( n_408 ), .B( prev2pll_10disb ) );
NAND2BX1 (*
integer library_binding = "gsclib090";
 *)
i_52 ( .AN(
n_527 ), .Y( n_404 ), .B( n_321 ) );
NAND2BX1 (*
integer library_binding = "gsclib090";
 *)
i_10877 ( .AN(
n_78310 ), .Y( n_401 ), .B( n_130028259 ) );
NAND2BX1 (*
integer library_binding = "gsclib090";
 *)
i_10886 ( .AN(
n_13050 ), .Y( n_399 ), .B( n_6847 ) );
NAND2BX1 (*
integer library_binding = "gsclib090";
 *)
i_10497 ( .AN(
MR_100MBS ), .Y( n_390 ), .B( RPD_100_DISB ) );
NAND2BX1 (*
integer library_binding = "gsclib090";
 *)
i_10460 ( .AN(
time_reset ), .Y( n_389 ), .B( nbus_1089_0_8265 ) );
NAND2BX1 (*
integer library_binding = "gsclib090";
 *)
i_172 ( .AN(
n_251 ), .Y( n_375 ), .B( n_229 ) );
NAND2BX1 (*
integer library_binding = "gsclib090";
 *)
i_96 ( .AN(
n_424 ), .Y( n_6485 ), .B( n_5 ) );

AND3X1 (*
integer library_binding = "gsclib090";
 *)
i_17790 ( .C(
fastcount[2] ), .Y( n_13414 ), .B( fastcount[1] ), .A( fastcount[0] ) );
AND3X1 (*
integer library_binding = "gsclib090";
 *)
i_16619 ( .C(
n_546 ), .Y( n_13779 ), .B( count125_2_ ), .A( count125_1_ ) );
AND3X1 (*
integer library_binding = "gsclib090";
 *)
i_17909 ( .C(
n_98 ), .Y( n_13966 ), .B( fastcount[2] ), .A( fastcount[0] ) );
AND3X1 (*
integer library_binding = "gsclib090";
 *)
i_10231 ( .C(
n_479 ), .Y( n_13068 ), .B( mr_txc2_5_pd_pll ), .A( n_458 ) );

OAI21XL (*
integer library_binding = "gsclib090";
 *)
i_18481 ( .A0(
n_437 ), .A1( prev2pll_100disb ), .B0( n_6764 ), .Y( n_6761 ) );
OAI21XL (*
integer library_binding = "gsclib090";
 *)
i_18329 ( .A0(
n_382 ), .A1( n_435 ), .B0( n_6652 ), .Y( n_6649 ) );
OAI21XL (*
integer library_binding = "gsclib090";
 *)
i_18293 ( .A0(
n_14379 ), .A1( n_130288263 ), .B0( n_6624 ), .Y( n_6621 ) );
OAI21XL (*
integer library_binding = "gsclib090";
 *)
i_18127 ( .A0(
n_423 ), .A1( n_157 ), .B0( n_6496 ), .Y( n_6493 ) );
OAI21XL (*
integer library_binding = "gsclib090";
 *)
i_18077 ( .A0(
n_424 ), .A1( n_237 ), .B0( n_6459 ), .Y( n_6457 ) );
OAI21XL (*
integer library_binding = "gsclib090";
 *)
i_10572 ( .A0(
n_374 ), .A1( n_229 ), .B0( n_375 ), .Y( n_13243 ) );
OAI21XL (*
integer library_binding = "gsclib090";
 *)
i_17903 ( .A0(
n_6844 ), .A1( n_13533 ), .B0( n_6332 ), .Y( n_6329 ) );
OAI21XL (*
integer library_binding = "gsclib090";
 *)
i_17893 ( .A0(
n_135 ), .A1( cnt125_at_8 ), .B0( n_6323 ), .Y( n_6321 ) );
OAI21XL (*
integer library_binding = "gsclib090";
 *)
i_11061 ( .A0(
n_367 ), .A1( n_12980 ), .B0( n_368 ), .Y( n_436 ) );
OAI21XL (*
integer library_binding = "gsclib090";
 *)
i_10850 ( .A0(
n_6860 ), .A1( Flag_in_to_rec ), .B0( n_246 ), .Y( n_412 ) );
OAI21XL (*
integer library_binding = "gsclib090";
 *)
i_53 ( .A0(
n_116 ), .A1( n_527 ), .B0( n_14387 ), .Y( n_405 ) );
OAI21XL (*
integer library_binding = "gsclib090";
 *)
i_4312203 ( .A0(
n_314 ), .A1( pll125_status[1] ), .B0( n_312 ), .Y( n_397 ) );
OAI21XL (*
integer library_binding = "gsclib090";
 *)
i_65 ( .A0(
n_572 ), .A1( time_count[5] ), .B0( n_291 ), .Y( n_288 ) );
OAI21XL (*
integer library_binding = "gsclib090";
 *)
i_87 ( .A0(
n_532 ), .A1( n_578 ), .B0( time_count[8] ), .Y( n_297 ) );
OAI21XL (*
integer library_binding = "gsclib090";
 *)
i_89 ( .A0(
n_572 ), .A1( n_534 ), .B0( time_count[9] ), .Y( n_299 ) );
OAI21XL (*
integer library_binding = "gsclib090";
 *)
i_60 ( .A0(
pll125_status[0] ), .A1( xoff_20 ), .B0( n_229 ), .Y( n_314 ) );
OAI21XL (*
integer library_binding = "gsclib090";
 *)
i_113 ( .A0(
count160[1] ), .A1( count160[0] ), .B0( count160[2] ), .Y( n_321 ) );
OAI21XL (*
integer library_binding = "gsclib090";
 *)
i_143 ( .A0(
nbus_1115_0_ ), .A1( n_522 ), .B0( count125_2_ ), .Y( n_339 ) );
OAI21XL (*
integer library_binding = "gsclib090";
 *)
i_75 ( .A0(
Flag_in_to_rec ), .A1( n_78310 ), .B0( n_246 ), .Y( n_41 ) );
OAI21XL (*
integer library_binding = "gsclib090";
 *)
i_80 ( .A0(
pll125_locked_plln[1] ), .A1( pll160_locked_plln[1] ), .B0( n_535 ), .Y(
n_2113 ) );

NAND2X1 (*
integer library_binding = "gsclib090";
 *)
i_18483 ( .Y(
n_6764 ), .B( slvtxc25_pd ), .A( n_437 ) );
NAND2X1 (*
integer library_binding = "gsclib090";
 *)
i_18416 ( .Y(
n_6715 ), .B( n_6717 ), .A( n_6718 ) );
NAND2X1 (*
integer library_binding = "gsclib090";
 *)
i_18363 ( .Y(
n_6677 ), .B( n_6680 ), .A( n_6679 ) );
NAND2X1 (*
integer library_binding = "gsclib090";
 *)
i_18331 ( .Y(
n_6652 ), .B( rclk2_5_disb ), .A( n_435 ) );
NAND2X1 (*
integer library_binding = "gsclib090";
 *)
i_18324 ( .Y(
n_6646 ), .B( x125_edge ), .A( n_431 ) );
NAND2X1 (*
integer library_binding = "gsclib090";
 *)
i_18295 ( .Y(
n_6624 ), .B( txc_sel ), .A( n_14379 ) );
NAND2X1 (*
integer library_binding = "gsclib090";
 *)
i_18251 ( .Y(
n_6592 ), .B( rclk25_good_edge ), .A( n_420 ) );
NAND2X1 (*
integer library_binding = "gsclib090";
 *)
i_18168 ( .Y(
n_6526 ), .B( rclk2_5_good_edge ), .A( n_430 ) );
NAND2X1 (*
integer library_binding = "gsclib090";
 *)
i_17913 ( .Y(
n_14387 ), .B( n_116 ), .A( n_527 ) );
NAND2X1 (*
integer library_binding = "gsclib090";
 *)
i_18078 ( .Y(
n_6459 ), .B( n_424 ), .A( n_12957 ) );
NAND2X1 (*
integer library_binding = "gsclib090";
 *)
i_17905 ( .Y(
n_6332 ), .B( n_6384 ), .A( time_reset_pc[0] ) );
NAND2X1 (*
integer library_binding = "gsclib090";
 *)
i_10248 ( .Y(
n_14083 ), .B( pll160_locked_plln[1] ), .A( n_19560 ) );
NAND2X1 (*
integer library_binding = "gsclib090";
 *)
i_10494 ( .Y(
nbus_1089_0_8265 ), .B( RPD_100_DISB ), .A( RPD_10_DISB ) );
NAND2X1 (*
integer library_binding = "gsclib090";
 *)
i_10369 ( .Y(
n_129828262 ), .B( sync2_rclk2_5_good_pll ), .A( rclk2_5_good_edge ) );
NAND2X1 (*
integer library_binding = "gsclib090";
 *)
i_10346 ( .Y(
n_130028259 ), .B( Flag_rec_to_in ), .A( n_14445 ) );
NAND2X1 (*
integer library_binding = "gsclib090";
 *)
i_17394 ( .Y(
n_574 ), .B( time_count[0] ), .A( time_count[1] ) );
NAND2X1 (*
integer library_binding = "gsclib090";
 *)
i_238 ( .Y(
n_544 ), .B( count160[0] ), .A( count160[5] ) );
NAND2X1 (*
integer library_binding = "gsclib090";
 *)
i_012824 ( .Y(
n_532 ), .B( time_count[6] ), .A( time_count[7] ) );
NAND2X1 (*
integer library_binding = "gsclib090";
 *)
i_9 ( .Y( n_519 ),
.B( count125_1_ ), .A( count125_0_ ) );
NAND2X1 (*
integer library_binding = "gsclib090";
 *)
i_190 ( .Y(
n_518 ), .B( count125_5_ ), .A( nbus_1115_4_ ) );
NAND2X1 (*
integer library_binding = "gsclib090";
 *)
i_288 ( .Y(
n_504 ), .B( prev2_mr100 ), .A( n_218 ) );
NAND2X1 (*
integer library_binding = "gsclib090";
 *)
i_289 ( .Y(
n_502 ), .B( prev3_cont2_5 ), .A( pll125_locked_pll[1] ) );
NAND2X1 (*
integer library_binding = "gsclib090";
 *)
i_307 ( .Y(
n_485 ), .B( pll160_locked_pll[1] ), .A( n_13025 ) );
NAND2X1 (*
integer library_binding = "gsclib090";
 *)
i_10819 ( .Y(
TXC_O_SC ), .B( n_232 ), .A( n_466 ) );
NAND2X1 (*
integer library_binding = "gsclib090";
 *)
i_10601 ( .Y(
n_12888 ), .B( twenty_us_exp_xtal[1] ), .A( n_6801 ) );
NAND2X1 (*
integer library_binding = "gsclib090";
 *)
i_11397 ( .Y(
n_427 ), .B( n_433 ), .A( n_349 ) );
NAND2X1 (*
integer library_binding = "gsclib090";
 *)
i_4312197 ( .Y(
n_413 ), .B( n_330 ), .A( n_331 ) );
NAND2X1 (*
integer library_binding = "gsclib090";
 *)
i_10472 ( .Y(
n_398 ), .B( n_13266 ), .A( n_13785 ) );
NAND2X1 (*
integer library_binding = "gsclib090";
 *)
i_10243 ( .Y(
n_393 ), .B( n_6830 ), .A( prev2pll_10disb ) );
NAND2X1 (*
integer library_binding = "gsclib090";
 *)
i_10438 ( .Y(
n_391 ), .B( nbus_1089_0_8265 ), .A( n_305 ) );
NAND2X1 (*
integer library_binding = "gsclib090";
 *)
i_81 ( .Y( n_291 ),
.B( n_571 ), .A( time_count[5] ) );
NAND2X1 (*
integer library_binding = "gsclib090";
 *)
i_134 ( .Y(
n_333 ), .B( n_227 ), .A( pll160_status[0] ) );
NAND2X1 (*
integer library_binding = "gsclib090";
 *)
i_152 ( .Y(
n_349 ), .B( n_465 ), .A( n_181 ) );
NAND2X1 (*
integer library_binding = "gsclib090";
 *)
i_153 ( .Y(
n_351 ), .B( Flag10_to_100 ), .A( n_6847 ) );
NAND2X1 (*
integer library_binding = "gsclib090";
 *)
i_161 ( .Y(
n_362 ), .B( n_129828262 ), .A( n_12970 ) );
NAND2X1 (*
integer library_binding = "gsclib090";
 *)
i_166 ( .Y(
n_368 ), .B( n_2 ), .A( n_12980 ) );
NAND2X1 (*
integer library_binding = "gsclib090";
 *)
i_27 ( .Y( n_7 ),
.B( n_246 ), .A( Flag_in_to_rec ) );
NAND2X1 (*
integer library_binding = "gsclib090";
 *)
i_10218 ( .Y(
n_2014 ), .B( pll125_locked_plln[1] ), .A( n_535 ) );
NAND2X1 (*
integer library_binding = "gsclib090";
 *)
i_58 ( .Y(
n_1711 ), .B( n_564 ), .A( n_300 ) );
NAND2X1 (*
integer library_binding = "gsclib090";
 *)
i_320 ( .Y( n_9 ),
.B( rxc_sel ), .A( n_452 ) );
NAND2X1 (*
integer library_binding = "gsclib090";
 *)
i_85 ( .Y( n_149 ),
.B( Flag_in_to_rec ), .A( n_238 ) );
NAND2X1 (*
integer library_binding = "gsclib090";
 *)
i_91 ( .Y( n_274 ),
.B( n_8 ), .A( n_134 ) );

NOR3X1 (*
integer library_binding = "gsclib090";
 *)
i_17158 ( .C(
count125_3_ ), .Y( n_13250 ), .B( n_519 ), .A( count125_2_ ) );
NOR3X1 (*
integer library_binding = "gsclib090";
 *)
i_10407 ( .C(
n_502 ), .Y( n_12957 ), .B( n_504 ), .A( n_348 ) );
NOR3X1 (*
integer library_binding = "gsclib090";
 *)
i_10464 ( .C(
time_reset_pc[1] ), .Y( n_12886 ), .B( time_reset_pc[6] ), .A( XOFF_20 ) );
NOR3X1 (*
integer library_binding = "gsclib090";
 *)
i_10317 ( .C(
prev3_cont2_5 ), .Y( n_13025 ), .B( n_218 ), .A( prev2_mr100 ) );
NOR3X1 (*
integer library_binding = "gsclib090";
 *)
i_213 ( .C(
prev_x125_sel_4_ ), .Y( n_560 ), .B( prev_x125_sel_5_ ), .A(
prev_x125_sel_6_ ) );
NOR3X1 (*
integer library_binding = "gsclib090";
 *)
i_216 ( .C(
prev_x125_sel_3_ ), .Y( n_557 ), .B( prev_x125_sel_1_ ), .A(
prev_x125_sel_2_ ) );
NOR3X1 (*
integer library_binding = "gsclib090";
 *)
i_218 ( .C(
prev3_rpd100tx_disb ), .Y( n_555 ), .B( prev_x125_sel_0_ ), .A(
AN_ACTIVE_XTND ) );
NOR3X1 (*
integer library_binding = "gsclib090";
 *)
i_15 ( .C(
count160[1] ), .Y( n_527 ), .B( count160[2] ), .A( count160[0] ) );
NOR3X1 (*
integer library_binding = "gsclib090";
 *)
i_277 ( .C(
prev3_rpd10_disb ), .Y( n_510 ), .B( prev_x160_sel_1_ ), .A(
prev_x160_sel_0_ ) );

OA21XL (*
integer library_binding = "gsclib090";
 *)
i_18491 ( .A0(
n_13098 ), .A1( txc25_disb ), .B0( n_130978267 ), .Y( n_6769 ) );
OA21XL (*
integer library_binding = "gsclib090";
 *)
i_10174 ( .A0(
cnt125_at_6 ), .A1( cnt125_at_1 ), .B0( n_13230 ), .Y( txc25n_enable ) );
OA21XL (*
integer library_binding = "gsclib090";
 *)
i_2 ( .A0(
n_129828262 ), .A1( n_219 ), .B0( n_364 ), .Y( n_474 ) );
OA21XL (*
integer library_binding = "gsclib090";
 *)
i_10158 ( .A0(
n_381 ), .A1( n_380 ), .B0( CLKPLL_IN ), .Y( CLKFAST_SC ) );

NOR3BXL (*
integer library_binding = "gsclib090";
 *)
i_31 ( .AN(
n_13174 ), .C( txc25_disb ), .Y( n_13230 ), .B( slvtxc25_pd ) );
NOR3BXL (*
integer library_binding = "gsclib090";
 *)
i_134164 ( .AN(
count160[0] ), .C( count160[5] ), .Y( n_14265 ), .B( n_530 ) );
NOR3BXL (*
integer library_binding = "gsclib090";
 *)
i_144298 ( .AN(
count160[5] ), .C( count160[0] ), .Y( n_14343 ), .B( n_530 ) );
NOR3BXL (*
integer library_binding = "gsclib090";
 *)
i_10412 ( .AN(
cont2_5_disb ), .C( cnt160_next_3f ), .Y( n_12956 ), .B(
prev_x160_sel_7_pll ) );
NOR3BXL (*
integer library_binding = "gsclib090";
 *)
i_11524 ( .AN(
n_361 ), .C( Flag_rclk2_5_int_to_ext ), .Y( n_14463 ), .B( n_422 ) );
NOR3BXL (*
integer library_binding = "gsclib090";
 *)
i_278 ( .AN(
n_510 ), .C( prev_x160_sel_2_ ), .Y( n_512 ), .B( prev_x160_sel_3_ ) );
NOR3BXL (*
integer library_binding = "gsclib090";
 *)
i_108 ( .AN(
n_229 ), .C( pll125_status[1] ), .Y( n_316 ), .B( xoff_20 ) );
NOR3BXL (*
integer library_binding = "gsclib090";
 *)
i_135 ( .AN(
n_227 ), .C( pll160_status[1] ), .Y( n_334 ), .B( xoff_20 ) );

INVX3 (*
integer library_binding = "gsclib090";
 *)
i_19037 ( .Y(
n_6865 ), .A( n_13030 ) );
INVX3 (*
integer library_binding = "gsclib090";
 *)
i_19026 ( .Y(
n_6854 ), .A( n_12973 ) );
INVX3 (*
integer library_binding = "gsclib090";
 *)
i_19013 ( .Y(
n_6834 ), .A( n_2014 ) );
INVX3 (*
integer library_binding = "gsclib090";
 *)
i_10 ( .Y( n_38 ),
.A( n_1201 ) );
INVX3 (*
integer library_binding = "gsclib090";
 *)
i_73 ( .Y( n_19 ),
.A( n_7 ) );
INVX3 (*
integer library_binding = "gsclib090";
 *)
i_40 ( .Y( n_18 ),
.A( n_14445 ) );

INVX2 (*
integer library_binding = "gsclib090";
 *)
i_19041 ( .Y(
n_6880 ), .A( RESET ) );
INVX2 (*
integer library_binding = "gsclib090";
 *)
i_19040 ( .Y(
n_6875 ), .A( net1 ) );
INVX2 (*
integer library_binding = "gsclib090";
 *)
i_19039 ( .Y(
clkfast_enable ), .A( n_457 ) );
INVX2 (*
integer library_binding = "gsclib090";
 *)
i_19038 ( .Y(
n_6866 ), .A( n_13027 ) );
INVX2 (*
integer library_binding = "gsclib090";
 *)
i_19036 ( .Y(
n_6864 ), .A( n_13025 ) );
INVX2 (*
integer library_binding = "gsclib090";
 *)
i_19032 ( .Y(
n_6860 ), .A( n_78310 ) );
INVX2 (*
integer library_binding = "gsclib090";
 *)
i_19028 ( .Y(
n_6856 ), .A( n_12956 ) );
INVX2 (*
integer library_binding = "gsclib090";
 *)
i_19022 ( .Y(
n_12968 ), .A( n_129688264 ) );
INVX2 (*
integer library_binding = "gsclib090";
 *)
i_19021 ( .Y(
nbus_1089_0_ ), .A( nbus_1089_0_8265 ) );
INVX2 (*
integer library_binding = "gsclib090";
 *)
i_19019 ( .Y(
n_6847 ), .A( n_13052 ) );
INVX2 (*
integer library_binding = "gsclib090";
 *)
i_19016 ( .Y(
n_6843 ), .A( n_284 ) );
INVX2 (*
integer library_binding = "gsclib090";
 *)
i_19015 ( .Y(
n_6842 ), .A( n_13266 ) );
INVX2 (*
integer library_binding = "gsclib090";
 *)
i_19014 ( .Y(
n_6836 ), .A( n_13785 ) );
INVX2 (*
integer library_binding = "gsclib090";
 *)
i_19012 ( .Y(
n_6830 ), .A( n_14083 ) );
INVX2 (*
integer library_binding = "gsclib090";
 *)
i_19011 ( .Y(
n_6818 ), .A( n_14387 ) );
INVX2 (*
integer library_binding = "gsclib090";
 *)
i_19010 ( .Y(
n_6781 ), .A( n_534 ) );
INVX2 (*
integer library_binding = "gsclib090";
 *)
i_236 ( .Y( n_183 ),
.A( n_188 ) );
INVX2 (*
integer library_binding = "gsclib090";
 *)
i_90 ( .Y( n_283 ),
.A( n_535 ) );

NAND4BX4 (*
integer library_binding = "gsclib090";
 *)
i_19 ( .D(
sqw25_sync1 ), .AN( n_78310 ), .C( Flag_rec_to_in ), .Y( n_371 ), .B(
sqw25_125 ) );

NAND3X1 (*
integer library_binding = "gsclib090";
 *)
i_24 ( .C(
prev2_mr100 ), .Y( n_99 ), .B( prev2_clk25 ), .A( prev1_clk25 ) );
NAND3X1 (*
integer library_binding = "gsclib090";
 *)
i_18446 ( .C(
rxc_disb ), .Y( n_6738 ), .B( n_324 ), .A( n_342 ) );
NAND3X1 (*
integer library_binding = "gsclib090";
 *)
i_18365 ( .C(
res_x125_edge ), .Y( n_6680 ), .B( n_324 ), .A( n_342 ) );
NAND3X1 (*
integer library_binding = "gsclib090";
 *)
i_18351 ( .C(
n_342 ), .Y( n_6668 ), .B( n_324 ), .A( rxc_sel ) );
NAND3X1 (*
integer library_binding = "gsclib090";
 *)
i_16813 ( .C(
count125_0_ ), .Y( n_13266 ), .B( count125_3_ ), .A( n_536 ) );
NAND3X1 (*
integer library_binding = "gsclib090";
 *)
i_10321 ( .C(
prev2_mr100 ), .Y( n_130248254 ), .B( prev1_clk25 ), .A( prev2_clk25 ) );
NAND3X1 (*
integer library_binding = "gsclib090";
 *)
i_10195 ( .C(
slvtxc25_pd ), .Y( n_130978267 ), .B( prev2pll_100disb ), .A( n_462 ) );
NAND3X1 (*
integer library_binding = "gsclib090";
 *)
i_3 ( .C(
time_count[2] ), .Y( n_575 ), .B( time_count[0] ), .A( time_count[1] ) );
NAND3X1 (*
integer library_binding = "gsclib090";
 *)
i_23 ( .C(
count125_1_ ), .Y( n_520 ), .B( count125_0_ ), .A( count125_2_ ) );
NAND3X1 (*
integer library_binding = "gsclib090";
 *)
i_305 ( .C(
txc_sel ), .Y( n_487 ), .B( pll125_locked_pll[1] ), .A( txc_disb ) );
NAND3X1 (*
integer library_binding = "gsclib090";
 *)
i_104 ( .C(
n_6868 ), .Y( n_312 ), .B( pll125_status[1] ), .A( pll125_status[0] ) );
NAND3X1 (*
integer library_binding = "gsclib090";
 *)
i_131 ( .C(
n_6870 ), .Y( n_330 ), .B( pll160_status[1] ), .A( pll160_status[0] ) );
NAND3X1 (*
integer library_binding = "gsclib090";
 *)
i_163 ( .C(
n_129828262 ), .Y( n_364 ), .B( n_2 ), .A( Flag_rclk2_5_ext_to_int ) );
NAND3X1 (*
integer library_binding = "gsclib090";
 *)
i_92 ( .C( n_134 ),
.Y( n_265 ), .B( n_8 ), .A( n_401 ) );

AOI211X2 (*
integer library_binding = "gsclib090";
 *)
i_257 ( .C0(
rclk2_5_disb ), .A0( n_981 ), .A1( rclk2_5_good_pll ), .B0( n_450 ), .Y(
n_249 ) );
AOI211X2 (*
integer library_binding = "gsclib090";
 *)
i_10750 ( .C0(
n_346 ), .A0( RX10_RCLK2_5 ), .A1( rclk2_5_good_pll ), .B0(
rclk2_5_disb ), .Y( n_449 ) );

OAI31X2 (*
integer library_binding = "gsclib090";
 *)
i_427 ( .A0(
n_249 ), .A1( meta_rclk2_5[1] ), .B0( n_351 ), .Y( n_465 ), .A2(
n_6847 ) );

NOR2XL (*
integer library_binding = "gsclib090";
 *)
i_458 ( .Y( n_500 ),
.B( n_304 ), .A( cont2_5_disb ) );
NOR2XL (*
integer library_binding = "gsclib090";
 *)
i_25 ( .Y( n_2 ),
.B( n_218 ), .A( prev3_cont2_5 ) );
NOR2XL (*
integer library_binding = "gsclib090";
 *)
i_1 ( .Y( n_78310 ),
.B( n_12985 ), .A( RCLK25_GOOD ) );
NOR2XL (*
integer library_binding = "gsclib090";
 *)
i_10179 ( .Y(
txc25_enable ), .B( txc25ena_pos ), .A( n_6384 ) );
NOR2XL (*
integer library_binding = "gsclib090";
 *)
i_211 ( .Y( n_561 ),
.B( n_535 ), .A( nbus_1104_0_ ) );
NOR2XL (*
integer library_binding = "gsclib090";
 *)
i_5 ( .Y( n_526 ),
.B( count160[0] ), .A( count160[1] ) );

NOR2BXL (*
integer library_binding = "gsclib090";
 *)
i_290 ( .AN(
n_302 ), .Y( n_294 ), .B( rclk2_5_good_pll ) );
NOR2BXL (*
integer library_binding = "gsclib090";
 *)
i_429 ( .AN(
n_500 ), .Y( n_464 ), .B( rclk2_5_good_pll ) );
NOR2BXL (*
integer library_binding = "gsclib090";
 *)
i_10381 ( .AN(
prev3_rx10_rclk2_5 ), .Y( n_12973 ), .B( n_219 ) );

NOR2X1 (*
integer library_binding = "gsclib090";
 *)
i_295 ( .Y( n_302 ),
.B( cont2_5_disb ), .A( n_304 ) );
NOR2X1 (*
integer library_binding = "gsclib090";
 *)
i_143662 ( .Y(
n_13291 ), .B( n_13785 ), .A( n_518 ) );
NOR2X1 (*
integer library_binding = "gsclib090";
 *)
i_127 ( .Y(
nbus_1100_0_ ), .B( time_count[0] ), .A( time_reset_xc_1_ ) );
NOR2X1 (*
integer library_binding = "gsclib090";
 *)
i_811648 ( .Y(
nbus_1106[1] ), .B( sync_all_disb_plln[1] ), .A( pll125_locked_plln[0] ) );
NOR2X1 (*
integer library_binding = "gsclib090";
 *)
i_811650 ( .Y(
nbus_1109[1] ), .B( sync_all_disb_plln[1] ), .A( pll160_locked_plln[0] ) );
NOR2X1 (*
integer library_binding = "gsclib090";
 *)
i_145377 ( .Y(
n_14069 ), .B( n_530 ), .A( n_544 ) );
NOR2X1 (*
integer library_binding = "gsclib090";
 *)
i_311835 ( .Y(
nbus_1115_0_ ), .B( count125_0_ ), .A( cnt125_at_8 ) );
NOR2X1 (*
integer library_binding = "gsclib090";
 *)
i_011832 ( .Y(
nbus_1115_3_ ), .B( cnt125_at_8 ), .A( n_268 ) );
NOR2X1 (*
integer library_binding = "gsclib090";
 *)
i_140 ( .Y(
nbus_1115_4_ ), .B( count125_6_ ), .A( count125_4_ ) );
NOR2X1 (*
integer library_binding = "gsclib090";
 *)
i_10263 ( .Y(
n_13052 ), .B( n_182 ), .A( n_13039 ) );
NOR2X1 (*
integer library_binding = "gsclib090";
 *)
i_10374 ( .Y(
n_12980 ), .B( sync2_rclk2_5_good_pll ), .A( n_12834 ) );
NOR2X1 (*
integer library_binding = "gsclib090";
 *)
i_10176 ( .Y(
clkfastd8_gate ), .B( n_457 ), .A( fastcount_5 ) );
NOR2X1 (*
integer library_binding = "gsclib090";
 *)
i_10173 ( .Y(
clk12_5_enable ), .B( clk12_5_ctrl ), .A( cnt125_at_9_pos ) );
NOR2X1 (*
integer library_binding = "gsclib090";
 *)
i_10166 ( .Y(
clkfastd8_enable ), .B( n_457 ), .A( fastcount_7 ) );
NOR2X1 (*
integer library_binding = "gsclib090";
 *)
i_18 ( .Y( n_550 ),
.B( fastcount[1] ), .A( fastcount[0] ) );
NOR2X1 (*
integer library_binding = "gsclib090";
 *)
i_233 ( .Y( n_546 ),
.B( count125_3_ ), .A( count125_0_ ) );
NOR2X1 (*
integer library_binding = "gsclib090";
 *)
i_16 ( .Y( n_541 ),
.B( n_14387 ), .A( count160[4] ) );
NOR2X1 (*
integer library_binding = "gsclib090";
 *)
i_35 ( .Y( n_536 ),
.B( count125_1_ ), .A( count125_2_ ) );
NOR2X1 (*
integer library_binding = "gsclib090";
 *)
i_263 ( .Y( n_522 ),
.B( count125_1_ ), .A( cnt125_at_8 ) );
NOR2X1 (*
integer library_binding = "gsclib090";
 *)
i_267 ( .Y( n_517 ),
.B( count125_6_ ), .A( count125_5_ ) );
NOR2X1 (*
integer library_binding = "gsclib090";
 *)
i_293 ( .Y( n_499 ),
.B( n_129828262 ), .A( Flag_rclk2_5_int_to_ext ) );
NOR2X1 (*
integer library_binding = "gsclib090";
 *)
i_319 ( .Y( n_479 ),
.B( cnt160_next_3f ), .A( clk160_disb_pll ) );
NOR2X1 (*
integer library_binding = "gsclib090";
 *)
i_324 ( .Y( n_478 ),
.B( Flag_rclk2_5_int_to_ext ), .A( n_12980 ) );
NOR2X1 (*
integer library_binding = "gsclib090";
 *)
i_8 ( .Y( n_462 ),
.B( cnt125_at_4 ), .A( cnt125_at_9 ) );
NOR2X1 (*
integer library_binding = "gsclib090";
 *)
i_30 ( .Y( n_458 ),
.B( txc2_5_disb ), .A( slvtxc2_5_pd ) );
NOR2X1 (*
integer library_binding = "gsclib090";
 *)
i_173 ( .Y( n_440 ),
.B( n_227 ), .A( prev2xtal_10disb ) );
NOR2X1 (*
integer library_binding = "gsclib090";
 *)
i_187 ( .Y( n_380 ),
.B( n_14083 ), .A( prev2_5_mr100 ) );
NOR2X1 (*
integer library_binding = "gsclib090";
 *)
i_10866 ( .Y(
n_382 ), .B( n_422 ), .A( n_278 ) );
NOR2X1 (*
integer library_binding = "gsclib090";
 *)
i_29 ( .Y( n_8 ),
.B( Flag_in_to_rec ), .A( n_438 ) );
NOR2X1 (*
integer library_binding = "gsclib090";
 *)
i_56 ( .Y( n_39 ),
.B( n_438 ), .A( n_318 ) );

NAND2X6 (*
integer library_binding = "gsclib090";
 *)
i_1069 ( .Y(
n_1129 ), .B( n_14445 ), .A( n_1151 ) );
NAND2X6 (*
integer library_binding = "gsclib090";
 *)
i_77 ( .Y( n_12 ),
.B( n_482 ), .A( n_354 ) );
NAND2X6 (*
integer library_binding = "gsclib090";
 *)
i_78 ( .Y(
n_78342 ), .B( n_19 ), .A( n_61 ) );
NAND2X6 (*
integer library_binding = "gsclib090";
 *)
i_79 ( .Y( n_61 ),
.B( n_14445 ), .A( n_130008257 ) );
NAND2X6 (*
integer library_binding = "gsclib090";
 *)
i_71 ( .Y( n_13 ),
.B( n_3 ), .A( n_12 ) );

NAND2X8 (*
integer library_binding = "gsclib090";
 *)
i_1089 ( .Y(
n_1151 ), .B( rclk25_sync1 ), .A( n_1997 ) );
NAND2X8 (*
integer library_binding = "gsclib090";
 *)
i_10340 ( .Y(
n_130008257 ), .B( rclk25_sync1 ), .A( RX100_RCLK25 ) );

BUFX16 (*
integer library_binding = "gsclib090";
 *)
i_1733 ( .Y(
n_1955 ), .A( net119 ) );

BUFX20 (*
integer library_binding = "gsclib090";
 *)
i_1754 ( .Y(
n_1976 ), .A( n_1905 ) );
BUFX20 (*
integer library_binding = "gsclib090";
 *)
i_1717 ( .Y(
n_1939 ), .A( n_2223 ) );
BUFX20 (*
integer library_binding = "gsclib090";
 *)
i_1706 ( .Y(
n_1928 ), .A( n_2154 ) );
BUFX20 (*
integer library_binding = "gsclib090";
 *)
i_1704 ( .Y(
n_1926 ), .A( n_2132 ) );
BUFX20 (*
integer library_binding = "gsclib090";
 *)
i_1687 ( .Y(
n_1909 ), .A( n_1976 ) );

BUFX3 (*
integer library_binding = "gsclib090";
 *)
i_1919 ( .Y(
n_2146 ), .A( nbus_1111_0_ ) );
BUFX3 (*
integer library_binding = "gsclib090";
 *)
i_1918 ( .Y(
n_2145 ), .A( net106 ) );
BUFX3 (*
integer library_binding = "gsclib090";
 *)
i_1917 ( .Y(
n_2144 ), .A( net84 ) );
BUFX3 (*
integer library_binding = "gsclib090";
 *)
i_1916 ( .Y(
n_2143 ), .A( net91 ) );
BUFX3 (*
integer library_binding = "gsclib090";
 *)
i_1838 ( .Y(
n_2061 ), .A( scan_in4 ) );
BUFX3 (*
integer library_binding = "gsclib090";
 *)
i_1837 ( .Y(
n_2060 ), .A( net154 ) );
BUFX3 (*
integer library_binding = "gsclib090";
 *)
i_1836 ( .Y(
n_2059 ), .A( net153 ) );
BUFX3 (*
integer library_binding = "gsclib090";
 *)
i_1835 ( .Y(
n_2058 ), .A( net151 ) );
BUFX3 (*
integer library_binding = "gsclib090";
 *)
i_1834 ( .Y(
n_2057 ), .A( net150 ) );
BUFX3 (*
integer library_binding = "gsclib090";
 *)
i_1833 ( .Y(
n_2056 ), .A( net149 ) );
BUFX3 (*
integer library_binding = "gsclib090";
 *)
i_1832 ( .Y(
n_2055 ), .A( net148 ) );
BUFX3 (*
integer library_binding = "gsclib090";
 *)
i_1831 ( .Y(
n_2054 ), .A( net146 ) );
BUFX3 (*
integer library_binding = "gsclib090";
 *)
i_1808 ( .Y(
n_2031 ), .A( net118 ) );
BUFX3 (*
integer library_binding = "gsclib090";
 *)
i_1807 ( .Y(
n_2030 ), .A( net117 ) );
BUFX3 (*
integer library_binding = "gsclib090";
 *)
i_1806 ( .Y(
n_2029 ), .A( net116 ) );
BUFX3 (*
integer library_binding = "gsclib090";
 *)
i_1805 ( .Y(
n_2028 ), .A( net115 ) );
BUFX3 (*
integer library_binding = "gsclib090";
 *)
i_1804 ( .Y(
n_2027 ), .A( net114 ) );
BUFX3 (*
integer library_binding = "gsclib090";
 *)
i_1803 ( .Y(
n_2026 ), .A( net113 ) );
BUFX3 (*
integer library_binding = "gsclib090";
 *)
i_1802 ( .Y(
n_2025 ), .A( net112 ) );
BUFX3 (*
integer library_binding = "gsclib090";
 *)
i_1801 ( .Y(
n_2024 ), .A( n_12920 ) );
BUFX3 (*
integer library_binding = "gsclib090";
 *)
i_1800 ( .Y(
n_2023 ), .A( net111 ) );
BUFX3 (*
integer library_binding = "gsclib090";
 *)
i_1799 ( .Y(
n_2022 ), .A( net110 ) );
BUFX3 (*
integer library_binding = "gsclib090";
 *)
i_1798 ( .Y(
n_2021 ), .A( net109 ) );
BUFX3 (*
integer library_binding = "gsclib090";
 *)
i_1797 ( .Y(
n_2020 ), .A( net108 ) );
BUFX3 (*
integer library_binding = "gsclib090";
 *)
i_1796 ( .Y(
n_2019 ), .A( net107 ) );
BUFX3 (*
integer library_binding = "gsclib090";
 *)
i_1795 ( .Y(
n_2018 ), .A( net104 ) );
BUFX3 (*
integer library_binding = "gsclib090";
 *)
i_1794 ( .Y(
n_2017 ), .A( net103 ) );
BUFX3 (*
integer library_binding = "gsclib090";
 *)
i_1793 ( .Y(
n_2016 ), .A( net102 ) );
BUFX3 (*
integer library_binding = "gsclib090";
 *)
i_1792 ( .Y(
n_2015 ), .A( net99 ) );
BUFX3 (*
integer library_binding = "gsclib090";
 *)
i_1791 ( .Y(
n_2013 ), .A( net98 ) );
BUFX3 (*
integer library_binding = "gsclib090";
 *)
i_1790 ( .Y(
n_2012 ), .A( net95 ) );
BUFX3 (*
integer library_binding = "gsclib090";
 *)
i_1789 ( .Y(
n_2011 ), .A( net94 ) );
BUFX3 (*
integer library_binding = "gsclib090";
 *)
i_1788 ( .Y(
n_2010 ), .A( net90 ) );
BUFX3 (*
integer library_binding = "gsclib090";
 *)
i_1787 ( .Y(
n_2009 ), .A( net89 ) );
BUFX3 (*
integer library_binding = "gsclib090";
 *)
i_1786 ( .Y(
n_2008 ), .A( net88 ) );
BUFX3 (*
integer library_binding = "gsclib090";
 *)
i_1785 ( .Y(
n_2007 ), .A( net86 ) );
BUFX3 (*
integer library_binding = "gsclib090";
 *)
i_1784 ( .Y(
n_2006 ), .A( net85 ) );
BUFX3 (*
integer library_binding = "gsclib090";
 *)
i_346 ( .Y( n_346 ),
.A( n_464 ) );
BUFX3 (*
integer library_binding = "gsclib090";
 *)
i_341 ( .Y( n_342 ),
.A( n_349 ) );
BUFX3 (*
integer library_binding = "gsclib090";
 *)
i_328 ( .Y( n_324 ),
.A( n_433 ) );

BUFX2 (*
integer library_binding = "gsclib090";
 *)
i_1927 ( .Y(
n_2154 ), .A( n_14039 ) );
BUFX2 (*
integer library_binding = "gsclib090";
 *)
i_1775 ( .Y(
n_1997 ), .A( RX100_RCLK25 ) );
BUFX2 (*
integer library_binding = "gsclib090";
 *)
i_1684 ( .Y(
n_1905 ), .A( n_2352 ) );
BUFX2 (*
integer library_binding = "gsclib090";
 *)
i_297 ( .Y( n_304 ),
.A( n_261 ) );
BUFX2 (*
integer library_binding = "gsclib090";
 *)
i_441 ( .Y( n_501 ),
.A( n_500 ) );
BUFX2 (*
integer library_binding = "gsclib090";
 *)
i_2599 ( .Y(
n_2736 ), .A( SCAN_ENABLE ) );
BUFX2 (*
integer library_binding = "gsclib090";
 *)
i_2197 ( .Y(
n_2311 ), .A( net4 ) );
BUFX2 (*
integer library_binding = "gsclib090";
 *)
i_2195 ( .Y(
n_2309 ), .A( n_2298 ) );
BUFX2 (*
integer library_binding = "gsclib090";
 *)
i_2193 ( .Y(
n_2307 ), .A( n_2299 ) );
BUFX2 (*
integer library_binding = "gsclib090";
 *)
i_2191 ( .Y(
n_2305 ), .A( n_2298 ) );
BUFX2 (*
integer library_binding = "gsclib090";
 *)
i_2187 ( .Y(
n_2301 ), .A( n_1256 ) );
BUFX2 (*
integer library_binding = "gsclib090";
 *)
i_2185 ( .Y(
n_2299 ), .A( n_2301 ) );
BUFX2 (*
integer library_binding = "gsclib090";
 *)
i_2184 ( .Y(
n_2298 ), .A( n_2736 ) );
BUFX2 (*
integer library_binding = "gsclib090";
 *)
i_2181 ( .Y(
n_2294 ), .A( n_2283 ) );
BUFX2 (*
integer library_binding = "gsclib090";
 *)
i_2179 ( .Y(
n_2292 ), .A( n_2284 ) );
BUFX2 (*
integer library_binding = "gsclib090";
 *)
i_2177 ( .Y(
n_2290 ), .A( n_2283 ) );
BUFX2 (*
integer library_binding = "gsclib090";
 *)
i_2173 ( .Y(
n_2286 ), .A( n_2736 ) );
BUFX2 (*
integer library_binding = "gsclib090";
 *)
i_2171 ( .Y(
n_2284 ), .A( n_2286 ) );
BUFX2 (*
integer library_binding = "gsclib090";
 *)
i_2170 ( .Y(
n_2283 ), .A( n_2736 ) );
BUFX2 (*
integer library_binding = "gsclib090";
 *)
i_1815 ( .Y(
n_1907 ), .A( scan_setinv ) );
BUFX2 (*
integer library_binding = "gsclib090";
 *)
i_1608 ( .Y(
n_1696 ), .A( n_1684 ) );
BUFX2 (*
integer library_binding = "gsclib090";
 *)
i_1606 ( .Y(
n_1694 ), .A( n_2283 ) );
BUFX2 (*
integer library_binding = "gsclib090";
 *)
i_1604 ( .Y(
n_1692 ), .A( n_1684 ) );
BUFX2 (*
integer library_binding = "gsclib090";
 *)
i_1600 ( .Y(
n_1688 ), .A( n_1256 ) );
BUFX2 (*
integer library_binding = "gsclib090";
 *)
i_1597 ( .Y(
n_1684 ), .A( n_2736 ) );
BUFX2 (*
integer library_binding = "gsclib090";
 *)
i_1364 ( .Y(
n_1446 ), .A( n_1396 ) );
BUFX2 (*
integer library_binding = "gsclib090";
 *)
i_1320 ( .Y(
n_1399 ), .A( SCAN_MODE ) );
BUFX2 (*
integer library_binding = "gsclib090";
 *)
i_1317 ( .Y(
n_1396 ), .A( n_1399 ) );
BUFX2 (*
integer library_binding = "gsclib090";
 *)
i_1184 ( .Y(
n_1257 ), .A( n_2736 ) );
BUFX2 (*
integer library_binding = "gsclib090";
 *)
i_1183 ( .Y(
n_1256 ), .A( n_2736 ) );
BUFX2 (*
integer library_binding = "gsclib090";
 *)
i_1138 ( .Y(
n_1201 ), .A( rclk25_disb ) );
BUFX2 (*
integer library_binding = "gsclib090";
 *)
i_921 ( .Y( n_981 ),
.A( n_258 ) );
BUFX2 (*
integer library_binding = "gsclib090";
 *)
i_839 ( .Y( n_899 ),
.A( n_710 ) );
BUFX2 (*
integer library_binding = "gsclib090";
 *)
i_650 ( .Y( n_710 ),
.A( sqw25_125 ) );
BUFX2 (*
integer library_binding = "gsclib090";
 *)
i_482 ( .Y( n_535 ),
.A( n_13227 ) );
BUFX2 (*
integer library_binding = "gsclib090";
 *)
i_348 ( .Y( n_348 ),
.A( cont2_5_sel ) );
BUFX2 (*
integer library_binding = "gsclib090";
 *)
i_266 ( .Y( n_258 ),
.A( RX10_RCLK2_5 ) );
BUFX2 (*
integer library_binding = "gsclib090";
 *)
i_31564 ( .Y(
n_13533 ), .A( n_6384 ) );
BUFX2 (*
integer library_binding = "gsclib090";
 *)
i_31565 ( .Y(
n_13534 ), .A( n_6384 ) );
BUFX2 (*
integer library_binding = "gsclib090";
 *)
i_34650 ( .Y(
n_19560 ), .A( n_12945 ) );
BUFX2 (*
integer library_binding = "gsclib090";
 *)
i_12120 ( .Y(
n_13529 ), .A( n_6875 ) );
BUFX2 (*
integer library_binding = "gsclib090";
 *)
i_12121 ( .Y(
n_13530 ), .A( n_6875 ) );
BUFX2 (*
integer library_binding = "gsclib090";
 *)
i_12122 ( .Y(
n_13532 ), .A( n_6875 ) );
BUFX2 (*
integer library_binding = "gsclib090";
 *)
i_12123 ( .Y(
n_13535 ), .A( n_6875 ) );
BUFX2 (*
integer library_binding = "gsclib090";
 *)
i_12125 ( .Y(
n_13537 ), .A( n_6875 ) );
BUFX2 (*
integer library_binding = "gsclib090";
 *)
i_12126 ( .Y(
n_13538 ), .A( n_6875 ) );
BUFX2 (*
integer library_binding = "gsclib090";
 *)
i_12127 ( .Y(
n_13539 ), .A( n_6875 ) );
BUFX2 (*
integer library_binding = "gsclib090";
 *)
i_12128 ( .Y(
n_13540 ), .A( n_6875 ) );
BUFX2 (*
integer library_binding = "gsclib090";
 *)
i_12129 ( .Y(
n_13541 ), .A( n_6875 ) );
BUFX2 (*
integer library_binding = "gsclib090";
 *)
i_12132 ( .Y(
n_13544 ), .A( n_13541 ) );
BUFX2 (*
integer library_binding = "gsclib090";
 *)
i_12133 ( .Y(
n_13545 ), .A( n_13541 ) );
BUFX2 (*
integer library_binding = "gsclib090";
 *)
i_12135 ( .Y(
n_13547 ), .A( n_13541 ) );
BUFX2 (*
integer library_binding = "gsclib090";
 *)
i_12136 ( .Y(
n_13548 ), .A( n_13541 ) );
BUFX2 (*
integer library_binding = "gsclib090";
 *)
i_12376 ( .Y(
n_13929 ), .A( net121 ) );
BUFX2 (*
integer library_binding = "gsclib090";
 *)
i_12377 ( .Y(
n_13930 ), .A( net121 ) );
BUFX2 (*
integer library_binding = "gsclib090";
 *)
i_12378 ( .Y(
n_13931 ), .A( net121 ) );
BUFX2 (*
integer library_binding = "gsclib090";
 *)
i_12380 ( .Y(
n_13933 ), .A( net121 ) );
BUFX2 (*
integer library_binding = "gsclib090";
 *)
i_12715 ( .Y(
n_14445 ), .A( rclk25_sel ) );
BUFX2 (*
integer library_binding = "gsclib090";
 *)
i_14038 ( .Y(
n_15822 ), .A( n_6844 ) );
BUFX2 (*
integer library_binding = "gsclib090";
 *)
i_244 ( .Y( n_188 ),
.A( n_2014 ) );
BUFX2 (*
integer library_binding = "gsclib090";
 *)
i_2265 ( .Y(
n_2352 ), .A( n_6454 ) );
BUFX2 (*
integer library_binding = "gsclib090";
 *)
i_4257 ( .Y(
n_4397 ), .A( n_6706 ) );
BUFX2 (*
integer library_binding = "gsclib090";
 *)
i_262 ( .Y( n_206 ),
.A( n_2352 ) );

BUFX8 (*
integer library_binding = "gsclib090";
 *)
i_2119 ( .Y(
n_2346 ), .A( n_281 ) );
BUFX8 (*
integer library_binding = "gsclib090";
 *)
i_1996 ( .Y(
n_2223 ), .A( scan_in2 ) );
BUFX8 (*
integer library_binding = "gsclib090";
 *)
i_1905 ( .Y(
n_2132 ), .A( net105 ) );
BUFX8 (*
integer library_binding = "gsclib090";
 *)
i_6250 ( .Y(
n_6454 ), .A( n_281 ) );

endmodule
