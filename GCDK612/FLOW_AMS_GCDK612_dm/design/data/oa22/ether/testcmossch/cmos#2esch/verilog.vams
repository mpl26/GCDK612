// Verilog-AMS netlist generated by the AMS netlister, version  IC6.1.4.500.1 .
// Cadence Design Systems, Inc.

`include "disciplines.vams"

(* cds_ams_schematic *)
module testcmossch (  );

endmodule
