// Verilog-AMS netlist generated by the AMS netlister, version 5.10.41.500.2.24.
// Cadence Design Systems, Inc.

`include "disciplines.vams"

module top ( TXC,RXDV,ANLG_TST,LEDL,XTAL25,RXC,TXER,LEDR,SIDDQ,TPON,
ANDIS,B10_DIS,SCAN_MODE,SCAN_ENABLE,TXEN,MDIO_IN,LEDT,.TX_SLP_TRIM(
{ \TX_SLP_TRIM(1) ,\TX_SLP_TRIM(0)  }),VDDRX,MDINT,LEDS,B100_DIS,LEDC,
RBIAS_SENSE,RBIAS,.PHY(
{ \PHY(4) ,\PHY(3) ,\PHY(2) ,\PHY(1) ,\PHY(0)  }),LEDD,TPOP,RESETN,VDD,
TRISTATE,SYMBOL_MODE,COL,TPIP,VDDTX,DISABLE10,VDDA_250,GNDRX,GNDA_160,
GNDA_250,VDDA_160,MDIO_OE,MDC,.TX_AMP_TRIM(
{ \TX_AMP_TRIM(1) ,\TX_AMP_TRIM(0)  }),TPIN,.TXD(
{ \TXD(4) ,\TXD(3) ,\TXD(2) ,\TXD(1) ,\TXD(0)  }),DISABLE100,GND,GNDTX,
.BGTRIM({ \BGTRIM(3) ,\BGTRIM(2) ,\BGTRIM(1) ,\BGTRIM(0)  }),MDIO_OUT,
CRS,.RXD({ \RXD(4) ,\RXD(3) ,\RXD(2) ,\RXD(1) ,\RXD(0)  }),RXER );

output   TXC;
output   RXDV;
output   ANLG_TST;
output   LEDL;

input   XTAL25;
output   RXC;
input   TXER;
output   LEDR;
input
 SIDDQ;
output   TPON;
input   ANDIS;
output   B10_DIS;
input
 SCAN_MODE;
input   SCAN_ENABLE;
input   TXEN;
input   MDIO_IN;

output   LEDT;
input   \TX_SLP_TRIM(0) ;
input   \TX_SLP_TRIM(1) ;

input   VDDRX;
output   MDINT;
output   LEDS;
output   B100_DIS;

output   LEDC;
input   RBIAS_SENSE;
input   RBIAS;
input   \PHY(0) ;

input   \PHY(1) ;
input   \PHY(2) ;
input   \PHY(3) ;
input
 \PHY(4) ;
output   LEDD;
output   TPOP;
input   RESETN;
input   VDD;

output   TRISTATE;
output   SYMBOL_MODE;
output   COL;
input   TPIP;

input   VDDTX;
input   DISABLE10;
input   VDDA_250;
input   GNDRX;

input   GNDA_160;
input   GNDA_250;
input   VDDA_160;
output
 MDIO_OE;
input   MDC;
input   \TX_AMP_TRIM(0) ;
input
 \TX_AMP_TRIM(1) ;
input   TPIN;
input   \TXD(0) ;
input   \TXD(1) ;

input   \TXD(2) ;
input   \TXD(3) ;
input   \TXD(4) ;
input
 DISABLE100;
input   GND;
input   GNDTX;
input   \BGTRIM(0) ;
input
 \BGTRIM(1) ;
input   \BGTRIM(2) ;
input   \BGTRIM(3) ;
output
 MDIO_OUT;
output   CRS;
output   \RXD(0) ;
output   \RXD(1) ;

output   \RXD(2) ;
output   \RXD(3) ;
output   \RXD(4) ;
output
 RXER;

top_rcx (*
integer library_binding = "av_hrcx_ether";
 *)

top_instclash ( .TXC( TXC ), .ANLG_TST( ANLG_TST ), .RXDV( RXDV ), .LEDR(
LEDR ), .TXER( TXER ), .RXC( RXC ), .XTAL25( XTAL25 ), .LEDL( LEDL ),
.ANDIS( ANDIS ), .TPON( TPON ), .SIDDQ( SIDDQ ), .B10_DIS( B10_DIS ),
.SCAN_MODE( SCAN_MODE ), .TXEN( TXEN ), .SCAN_ENABLE( SCAN_ENABLE ), .MDIO_IN(
MDIO_IN ), .TX_SLP_TRIM( { \TX_SLP_TRIM(1) ,\TX_SLP_TRIM(0)  } ), .LEDT(
LEDT ), .B100_DIS( B100_DIS ), .LEDS( LEDS ), .MDINT( MDINT ), .VDDRX(
VDDRX ), .LEDC( LEDC ), .RBIAS_SENSE( RBIAS_SENSE ), .RBIAS( RBIAS ),
.RESETN( RESETN ), .TPOP( TPOP ), .LEDD( LEDD ), .PHY( { \PHY(4) ,
\PHY(3) ,\PHY(2) ,\PHY(1) ,\PHY(0)  } ), .TRISTATE( TRISTATE ), .VDD(
VDD ), .SYMBOL_MODE( SYMBOL_MODE ), .TPIP( TPIP ), .COL( COL ), .DISABLE10(
DISABLE10 ), .VDDTX( VDDTX ), .GNDRX( GNDRX ), .VDDA_250( VDDA_250 ),
.VDDA_160( VDDA_160 ), .GNDA_250( GNDA_250 ), .GNDA_160( GNDA_160 ), .MDIO_OE(
MDIO_OE ), .MDC( MDC ), .TPIN( TPIN ), .TX_AMP_TRIM( { \TX_AMP_TRIM(1) ,
\TX_AMP_TRIM(0)  } ), .TXD( { \TXD(4) ,
\TXD(3) ,\TXD(2) ,\TXD(1) ,\TXD(0)  } ), .DISABLE100( DISABLE100 ), .GNDTX(
GNDTX ), .GND( GND ), .MDIO_OUT( MDIO_OUT ), .BGTRIM( { \BGTRIM(3) ,
\BGTRIM(2) ,\BGTRIM(1) ,\BGTRIM(0)  } ), .RXER( RXER ), .RXD( { \RXD(4) ,
\RXD(3) ,\RXD(2) ,\RXD(1) ,\RXD(0)  } ), .CRS( CRS ) );

endmodule
