// Verilog-AMS netlist generated by the AMS netlister, version 5.10.41.500.2.24.
// Cadence Design Systems, Inc.

`include "disciplines.vams"

module top ( TXC,ANLG_TST,RXDV,LEDR,TXER,RXC,XTAL25,LEDL,ANDIS,TPON,
SIDDQ,B10_DIS,SCAN_MODE,TXEN,SCAN_ENABLE,MDIO_IN,.TX_SLP_TRIM(
{ \TX_SLP_TRIM(1) ,\TX_SLP_TRIM(0)  }),LEDT,B100_DIS,LEDS,MDINT,VDDRX,
LEDC,RBIAS_SENSE,RBIAS,RESETN,TPOP,LEDD,.PHY(
{ \PHY(4) ,\PHY(3) ,\PHY(2) ,\PHY(1) ,\PHY(0)  }),TRISTATE,VDD,
SYMBOL_MODE,TPIP,COL,DISABLE10,VDDTX,GNDRX,VDDA_250,VDDA_160,GNDA_250,
GNDA_160,MDIO_OE,MDC,TPIN,.TX_AMP_TRIM(
{ \TX_AMP_TRIM(1) ,\TX_AMP_TRIM(0)  }),.TXD(
{ \TXD(4) ,\TXD(3) ,\TXD(2) ,\TXD(1) ,\TXD(0)  }),DISABLE100,GNDTX,GND,
MDIO_OUT,.BGTRIM({ \BGTRIM(3) ,\BGTRIM(2) ,\BGTRIM(1) ,\BGTRIM(0)  }),
RXER,.RXD({ \RXD(4) ,\RXD(3) ,\RXD(2) ,\RXD(1) ,\RXD(0)  }),CRS );

output   TXC;
output   ANLG_TST;
output   RXDV;
output   LEDR;

input   TXER;
output   RXC;
input   XTAL25;
output   LEDL;
input
 ANDIS;
output   TPON;
input   SIDDQ;
output   B10_DIS;
input
 SCAN_MODE;
input   TXEN;
input   SCAN_ENABLE;
input   MDIO_IN;

input   \TX_SLP_TRIM(0) ;
input   \TX_SLP_TRIM(1) ;
output   LEDT;

output   B100_DIS;
output   LEDS;
output   MDINT;
input   VDDRX;

output   LEDC;
input   RBIAS_SENSE;
input   RBIAS;
input   RESETN;

output   TPOP;
output   LEDD;
input   \PHY(0) ;
input   \PHY(1) ;

input   \PHY(2) ;
input   \PHY(3) ;
input   \PHY(4) ;
output
 TRISTATE;
input   VDD;
output   SYMBOL_MODE;
input   TPIP;
output
 COL;
input   DISABLE10;
input   VDDTX;
input   GNDRX;
input
 VDDA_250;
input   VDDA_160;
input   GNDA_250;
input   GNDA_160;

output   MDIO_OE;
input   MDC;
input   TPIN;
input
 \TX_AMP_TRIM(0) ;
input   \TX_AMP_TRIM(1) ;
input   \TXD(0) ;
input
 \TXD(1) ;
input   \TXD(2) ;
input   \TXD(3) ;
input   \TXD(4) ;

input   DISABLE100;
input   GNDTX;
input   GND;
output   MDIO_OUT;

input   \BGTRIM(0) ;
input   \BGTRIM(1) ;
input   \BGTRIM(2) ;
input
 \BGTRIM(3) ;
output   RXER;
output   \RXD(0) ;
output   \RXD(1) ;

output   \RXD(2) ;
output   \RXD(3) ;
output   \RXD(4) ;
output
 CRS;

Bias_port (*
integer library_binding = "ether";
 *)
I36 ( .I_REXT_REF100(
\8:I_REXT_REF100  ), .SIDDQ( \10:SIDDQ  ), .I_RPOLY_100( { \4:I_RPOLY_100(5) ,
\I_RPOLY_100(4) ,\4:I_RPOLY_100(3) ,\4:I_RPOLY_100(2) ,
\4:I_RPOLY_100(1) ,\4:I_RPOLY_100(0)  } ), .I_REXT_100( { \4:I_REXT_100(6) ,
\4:I_REXT_100(5) ,\4:I_REXT_100(4) ,\4:I_REXT_100(3) ,
\4:I_REXT_100(2) ,\I_REXT_100(1) ,\4:I_REXT_100(0)  } ), .I_REXT_50( { \I_REXT_50(1) ,
\7:I_REXT_50(0)  } ), .VDD( \4:VDDRX  ), .I_RPOLY_REF100(
\12:I_RPOLY_REF100  ), .VSS( \7:GNDRX  ), .I_REXT_100_NC(
\10:I_REXT_100_NC  ) );

anlg_cntl (*
integer library_binding = "ether";
 *)
I42 ( .PHASE_IN( { \7:PHASE_IN(10) ,
\7:PHASE_IN(9) ,\7:PHASE_IN(8) ,\7:PHASE_IN(7) ,\7:PHASE_IN(6) ,
\5:PHASE_IN(5) ,\7:PHASE_IN(4) ,\7:PHASE_IN(3) ,\PHASE_IN(2) ,
\5:PHASE_IN(1) ,\7:PHASE_IN(0)  } ), .TEST_MODE( { \TEST_MODE(2) ,
\TEST_MODE(1) ,\4:TEST_MODE(0)  } ), .PHASE_125( { \PHASE_125(10) ,
\PHASE_125(9) ,\PHASE_125(8) ,\PHASE_125(7) ,\PHASE_125(6) ,
\PHASE_125(5) ,\PHASE_125(4) ,\PHASE_125(3) ,\PHASE_125(2) ,
\PHASE_125(1) ,\PHASE_125(0)  } ), .XTAL25( XTAL25_1p0 ), .TXER(
\5:TXER  ), .X_160( X_160 ), .SIDDQ( \9:SIDDQ  ), .TP_DISC_1p0(
TP_DISC_1p0 ), .RX10_PRESENT_2p5( \6:RX10_PRESENT_2p5  ), .MR_SQUELCH_RANGE_1p0( { \4:MR_SQUELCH_RANGE_1p0(1) ,
\MR_SQUELCH_RANGE_1p0(0)  } ), .MLT3_TDATA_2p5( { \4:MLT3_TDATA_2p5(1) ,
\MLT3_TDATA_2p5(0)  } ), .ADC_DIS_2p5( ADC_DIS_2p5 ), .ADC_TEST_2p5(
ADC_TEST_2p5 ), .SLICER_OUT_2p5( \4:SLICER_OUT_2p5  ), .X10_DIS_2p5(
\7:X10_DIS_2p5  ), .BASE10_DIS( \5:B10_DIS  ), .TP_DISC_2p5(
TP_DISC_2p5 ), .BASE100TX_DIS( \5:B100_DIS  ), .PHASE_250( { \4:PHASE_250(10) ,
\PHASE_250(9) ,\4:PHASE_250(8) ,\4:PHASE_250(7) ,\4:PHASE_250(6) ,
\4:PHASE_250(5) ,\4:PHASE_250(4) ,\4:PHASE_250(3) ,\4:PHASE_250(2) ,
\PHASE_250(1) ,\4:PHASE_250(0)  } ), .RX10_PRESENT_1p0(
\4:RX10_PRESENT_1p0  ), .TX_AMPTRIM_1p0( { \4:TX_AMPTRIM_1p0(1) ,
\TX_AMPTRIM_1p0(0)  } ), .POS_DETECT_1p0( POS_DETECT_1p0 ), .MLT3_TDATA_1p0( { \4:MLT3_TDATA_1p0(1) ,
\4:MLT3_TDATA_1p0(0)  } ), .SLICER_OUT_1p0( \4:SLICER_OUT_1p0  ), .VDDRX(
\3:VDDRX  ), .MR_SQUELCH_DISB_2p5( MR_SQUELCH_DISB_2p5 ), .NEG_DETECT_2p5(
\4:NEG_DETECT_2p5  ), .NEG_DETECT_1p0( NEG_DETECT_1p0 ), .RESETN(
\6:RESETN  ), .RCLK125_TST_SEL( RCLK125_TST_SEL ), .VDD( \12:VDD  ), .MR_SQUELCH_DISB_1p0(
\4:MR_SQUELCH_DISB_1p0  ), .X_125( \4:X_125  ), .PLL_160_IN(
\4:PLL_160_IN  ), .BASEFX_DIS( \9:BASEFX_DIS  ), .VDDTX( \25:VDDTX  ),
.RCLK125_TST( \4:RCLK125_TST  ), .GNDRX( \6:GNDRX  ), .MR_SQUELCH_RANGE_2p5( { \MR_SQUELCH_RANGE_2p5(1) ,
\4:MR_SQUELCH_RANGE_2p5(0)  } ), .XTAL25_IN( \6:XTAL25  ), .POS_DETECT_2p5(
POS_DETECT_2p5 ), .AEQ_DIS_2p5( \6:AEQ_DIS_2p5  ), .BLW_DIS_2p5(
BLW_DIS_2p5 ), .TX100_DIS_2p5( \9:TX100_DIS_2p5  ), .TX_SLOPETRIM_1p0( { \4:TX_SLOPETRIM_1p0(1) ,
\TX_SLOPETRIM_1p0(0)  } ), .GND( \27:GND  ), .GNDTX( \23:GNDTX  ) );

top_1_port_pnr (*
integer library_binding = "ether";
integer
cds_net_set[0:1] = { "VDD","VSS" };
integer VDD = "VDD";
integer VSS
 = "GND";
 *)
I45 ( .AEQ_BYPASS( \6:AEQ_BYPASS  ), .TX_AMPTRIM( { \TX_AMPTRIM_1p0(1) ,
\3:TX_AMPTRIM_1p0(0)  } ), .TEST_MODE( { \3:TEST_MODE(2) ,
\3:TEST_MODE(1) ,\TEST_MODE(0)  } ), .TXC( \1:TXC  ), .MR_SQUELCH_DISB(
MR_SQUELCH_DISB_1p0 ), .RXDV( \1:RXDV  ), .ANLG_TST( \1:ANLG_TST  ), .TXER(
\4:TXER  ), .XTAL25( \3:XTAL25_1p0  ), .LEDL( \1:LEDL  ), .LEDR(
\1:LEDR  ), .RESET( RESET_10BT ), .RXC( \1:RXC  ), .ANDIS( \1:ANDIS  ),
.X_160( \3:X_160  ), .MR_BYPASS10RX_FILTER( MR_BYPASS10RX_FILTER ), .CLKPLL_SC(
clkpll_sc ), .SCAN_MODE( \1:SCAN_MODE  ), .RX10_PRESENT(
RX10_PRESENT_1p0 ), .TXEN( \1:TXEN  ), .ADC( { \7:ADC_1p0(5) ,
\7:ADC_1p0(4) ,\7:ADC_1p0(3) ,\7:ADC_1p0(2) ,\ADC_1p0(1) ,
\7:ADC_1p0(0)  } ), .SCAN_ENABLE( \1:SCAN_ENABLE  ), .TIMING_DN_ANLG(
TIMING_DN_ANLG ), .MLT3_TDATA( { \MLT3_TDATA_1p0(1) ,
\MLT3_TDATA_1p0(0)  } ), .MDIO_IN( \1:MDIO_IN  ), .BASE10_DIS(
\4:B10_DIS  ), .RESET_DSP( \6:RESET_DSP  ), .TP_DISC( \3:TP_DISC_1p0  ),
.BASE100TX_DIS( \4:B100_DIS  ), .TENBT_CLK160( \6:TENBT_CLK160_1p0  ),
.TX_SLP_TRIM( { \1:TX_SLP_TRIM(1) ,\1:TX_SLP_TRIM(0)  } ), .LEDT(
\1:LEDT  ), .LEDS( \1:LEDS  ), .MDINT( \1:MDINT  ), .TIMING_UP_ANLG(
\6:TIMING_UP_ANLG  ), .MR_SQUELCH_RANGE( { \MR_SQUELCH_RANGE_1p0(1) ,
\3:MR_SQUELCH_RANGE_1p0(0)  } ), .BASE10_TX_DIS( BASE10_TX_DIS_1p0 ),
.LEDC( \1:LEDC  ), .MDIX( MDIX ), .RESETN( \5:RESETN  ), .PHY( { \1:PHY(4) ,
\1:PHY(3) ,\1:PHY(2) ,\1:PHY(1) ,\1:PHY(0)  } ), .LEDD( \1:LEDD  ), .TENBT_FILTER( { \6:TENBT_FILTER_1p0(4) ,
\TENBT_FILTER_1p0(3) ,\6:TENBT_FILTER_1p0(2) ,\TENBT_FILTER_1p0(1) ,
\6:TENBT_FILTER_1p0(0)  } ), .POS_DETECT( \3:POS_DETECT_1p0  ), .TRISTATE(
\1:TRISTATE  ), .VDD( \11:VDD  ), .X_125( X_125 ), .FLASH( { \7:FLASH_1p0(2) ,
\7:FLASH_1p0(1) ,\7:FLASH_1p0(0)  } ), .SYMBOL_MODE( \1:SYMBOL_MODE  ),
.BASEFX_DIS( BASEFX_DIS ), .COL( \1:COL  ), .RCLK125( \7:RCLK125_1p0  ),
.WANDER_CNT_ANLG( { \5:WANDER_CNT(6) ,
\WANDER_CNT(5) ,\5:WANDER_CNT(4) ,\WANDER_CNT(3) ,\5:WANDER_CNT(2) ,
\5:WANDER_CNT(1) ,\WANDER_CNT(0)  } ), .AEQ_CNT_ANLG( { \5:AEQ_CNT_ANLG(4) ,
\5:AEQ_CNT_ANLG(3) ,\AEQ_CNT_ANLG(2) ,\5:AEQ_CNT_ANLG(1) ,
\AEQ_CNT_ANLG(0)  } ), .MDIO_OE( \1:MDIO_OE  ), .TX_SLOPETRIM( { \TX_SLOPETRIM_1p0(1) ,
\3:TX_SLOPETRIM_1p0(0)  } ), .MDC( \1:MDC  ), .NEG_DETECT(
\3:NEG_DETECT_1p0  ), .TX_AMP_TRIM( { \1:TX_AMP_TRIM(1) ,
\1:TX_AMP_TRIM(0)  } ), .T2_MODE( \6:T2_MODE  ), .TXD( { \1:TXD(4) ,
\1:TXD(3) ,\1:TXD(2) ,\1:TXD(1) ,\1:TXD(0)  } ), .CLKPLL_IN(
\1:clkpll_sc  ), .VSS( \26:GND  ), .MDIO_OUT( \1:MDIO_OUT  ), .SLICER_OUT(
SLICER_OUT_1p0 ), .CRS( \1:CRS  ), .RXER( \1:RXER  ), .RXD( { \1:RXD(4) ,
\1:RXD(3) ,\1:RXD(2) ,\1:RXD(1) ,\1:RXD(0)  } ) );

top_1_port_receive (*
integer library_binding = "ether";
 *)
I44 ( .MR_SQUELCH_DISB(
\3:MR_SQUELCH_DISB_2p5  ), .RX10_SLICER_OUT( SLICER_OUT_2p5 ), .I_RPOLY_100( { \I_RPOLY_100(5) ,
\3:I_RPOLY_100(4) ,\I_RPOLY_100(3) ,\3:I_RPOLY_100(2) ,
\I_RPOLY_100(1) ,\I_RPOLY_100(0)  } ), .RX10_PRESENT( RX10_PRESENT_2p5 ),
.ADC_TEST_2p5( \5:ADC_TEST_2p5  ), .ADC_DIS_2p5( \5:ADC_DIS_2p5  ), .X10_DIS_2p5(
\6:X10_DIS_2p5  ), .ADC( { \6:ADC_1p0(5) ,
\6:ADC_1p0(4) ,\6:ADC_1p0(3) ,\6:ADC_1p0(2) ,\6:ADC_1p0(1) ,
\6:ADC_1p0(0)  } ), .RX10_NEG_SIG_DET( \5:POS_DETECT_2p5  ), .RESET_DSP(
RESET_DSP ), .BASE100TX_DIS( \8:TX100_DIS_2p5  ), .TIMING_DN(
\5:TIMING_DN_ANLG  ), .AEQ_CNT( { \AEQ_CNT_ANLG(4) ,
\AEQ_CNT_ANLG(3) ,\4:AEQ_CNT_ANLG(2) ,\AEQ_CNT_ANLG(1) ,
\4:AEQ_CNT_ANLG(0)  } ), .PHASE_250( { \PHASE_250(10) ,
\3:PHASE_250(9) ,\PHASE_250(8) ,\PHASE_250(7) ,\PHASE_250(6) ,
\PHASE_250(5) ,\PHASE_250(4) ,\PHASE_250(3) ,\PHASE_250(2) ,
\3:PHASE_250(1) ,\PHASE_250(0)  } ), .I_REXT_100( { \I_REXT_100(6) ,
\3:I_REXT_100(5) ,\I_REXT_100(4) ,\I_REXT_100(3) ,\I_REXT_100(2) ,
\3:I_REXT_100(1) ,\I_REXT_100(0)  } ), .RCLK_125( RCLK125_1p0 ), .MR_SQUELCH_RANGE( { \3:MR_SQUELCH_RANGE_2p5(1) ,
\MR_SQUELCH_RANGE_2p5(0)  } ), .VDDRX( \2:VDDRX  ), .TIMING_UP(
TIMING_UP_ANLG ), .RCLK125_TST_SEL( \3:RCLK125_TST_SEL  ), .VDD(
\10:VDD  ), .FLASH( { \6:FLASH_1p0(2) ,
\6:FLASH_1p0(1) ,\6:FLASH_1p0(0)  } ), .MR_10BT_FILTER(
\5:MR_BYPASS10RX_FILTER  ), .MR_AEQ_BYPASS( AEQ_BYPASS ), .BASEFX_DIS(
\7:BASEFX_DIS  ), .TPIP( \1:TPIP  ), .RCLK125_TST( RCLK125_TST ), .GNDRX(
\5:GNDRX  ), .AEQ_DIS_2p5( AEQ_DIS_2p5 ), .BLW_DIS_2p5(
\5:BLW_DIS_2p5  ), .T2_MODE( T2_MODE ), .TPIN( \1:TPIN  ), .WANDER_CNT( { \WANDER_CNT(6) ,
\4:WANDER_CNT(5) ,\WANDER_CNT(4) ,\4:WANDER_CNT(3) ,\WANDER_CNT(2) ,
\WANDER_CNT(1) ,\4:WANDER_CNT(0)  } ), .GND( \25:GND  ), .RX10_POS_SIG_DET(
NEG_DETECT_2p5 ) );

top_1_port_transmit (*
integer library_binding = "ether";
 *)
I46 ( .TENBT_CLK_160(
TENBT_CLK160_1p0 ), .SIDDQ( \8:SIDDQ  ), .TPON( \1:TPON  ), .X10_DIS_2p5(
X10_DIS_2p5 ), .I_REXT_400_TX( \8:I_REXT_400_TX  ), .BASE10_TX_DIS(
\5:BASE10_TX_DIS_1p0  ), .TENBT_FILTER( { \TENBT_FILTER_1p0(4) ,
\5:TENBT_FILTER_1p0(3) ,\TENBT_FILTER_1p0(2) ,\5:TENBT_FILTER_1p0(1) ,
\TENBT_FILTER_1p0(0)  } ), .TPOP( \1:TPOP  ), .VDD( \9:VDD  ), .TP_DIS(
\3:TP_DISC_2p5  ), .VDDTX( \24:VDDTX  ), .I_REXT_50u( { \6:I_REXT_50(1) ,
\6:I_REXT_50(0)  } ), .RESET_10BT( \5:RESET_10BT  ), .TX100_DIS_2p5(
TX100_DIS_2p5 ), .I_100u_Rext_NC( \9:I_REXT_100_NC  ), .GNDTX(
\22:GNDTX  ), .GND( \24:GND  ), .MLT3ENC_DATA( { \MLT3_TDATA_2p5(1) ,
\3:MLT3_TDATA_2p5(0)  } ) );

top_common #(.ieIO("output"), .ieLib("schroeder_sims"), .\.usim_opt ("sim_mode=ms acc=2 analog=2"))
(*
integer library_binding = "ether";
 *)
I22 ( .CLKXTAL( \5:XTAL25  ),
.SIDDQ( \7:SIDDQ  ), .I_RPOLY_100( \11:I_RPOLY_REF100  ), .PHASE( { \6:PHASE_IN(10) ,
\PHASE_IN(9) ,\6:PHASE_IN(8) ,\PHASE_IN(7) ,\PHASE_IN(6) ,
\PHASE_IN(5) ,\6:PHASE_IN(4) ,\PHASE_IN(3) ,\6:PHASE_IN(2) ,
\PHASE_IN(1) ,\6:PHASE_IN(0)  } ), .I_REXT_100( \7:I_REXT_REF100  ), .I_REXT_400_TX(
\7:I_REXT_400_TX  ), .RBIAS_SENSE( \1:RBIAS_SENSE  ), .RBIAS(
\1:RBIAS  ), .DISABLE10( \1:DISABLE10  ), .PLL160( PLL_160_IN ), .VDDA_250(
\1:VDDA_250  ), .VDDA_160( \1:VDDA_160  ), .GNDA_160( \1:GNDA_160  ),
.GNDA_250( \1:GNDA_250  ), .DISABLE100( \1:DISABLE100  ), .BGTRIM( { \1:BGTRIM(3) ,
\1:BGTRIM(2) ,\1:BGTRIM(1) ,\1:BGTRIM(0)  } ) );

resistor #(.r(57.424)) (*
integer library_binding = "analogLib";
 *)

rd49 ( \1:TXD(2) , \TXD(2)  );
resistor #(.r(75.071)) (*
integer library_binding = "analogLib";
 *)

rd48 ( \FLASH_1p0(2) , \3:FLASH_1p0(2)  );
resistor #(.r(230.202)) (*
integer library_binding = "analogLib";
 *)

rd59 ( \FLASH_1p0(2) , \6:FLASH_1p0(2)  );
resistor #(.r(157.341)) (*
integer library_binding = "analogLib";
 *)

rd60 ( \3:FLASH_1p0(2) , \7:FLASH_1p0(2)  );
resistor #(.r(57.424)) (*
integer library_binding = "analogLib";
 *)

rd63 ( MDIO_OE, \1:MDIO_OE  );
resistor #(.r(100.719)) (*
integer library_binding = "analogLib";
 *)

rd64 ( \AEQ_CNT_ANLG(3) , \5:AEQ_CNT_ANLG(3)  );
resistor #(.r(1.1074)) (*
integer library_binding = "analogLib";
 *)

rd35 ( clkpll_sc, \1:clkpll_sc  );
resistor #(.r(57.424)) (*
integer library_binding = "analogLib";
 *)

rd24 ( \1:SYMBOL_MODE , SYMBOL_MODE );
resistor #(.r(236.022)) (*
integer library_binding = "analogLib";
 *)

rd36 ( \PHASE_IN(0) , \2:PHASE_IN(0)  );
resistor #(.r(53.894)) (*
integer library_binding = "analogLib";
 *)

rd27 ( \2:PHASE_IN(0) , \6:PHASE_IN(0)  );
resistor #(.r(103.222)) (*
integer library_binding = "analogLib";
 *)

rd26 ( ADC_TEST_2p5, \5:ADC_TEST_2p5  );
resistor #(.r(646.09)) (*
integer library_binding = "analogLib";
 *)

rd47 ( I_RPOLY_REF100, \4:I_RPOLY_REF100  );
resistor #(.r(333.476)) (*
integer library_binding = "analogLib";
 *)

rd33 ( I_RPOLY_REF100, \11:I_RPOLY_REF100  );
resistor #(.r(114.613)) (*
integer library_binding = "analogLib";
 *)

rd32 ( \4:I_RPOLY_REF100 , \12:I_RPOLY_REF100  );
resistor #(.r(17.6583)) (*
integer library_binding = "analogLib";
 *)

rd39 ( \TENBT_FILTER_1p0(4) , \6:TENBT_FILTER_1p0(4)  );
resistor #(.r(57.424)) (*
integer library_binding = "analogLib";
 *)

rd25 ( TRISTATE, \1:TRISTATE  );
resistor #(.r(108.844)) (*
integer library_binding = "analogLib";
 *)

rd18 ( \MR_SQUELCH_RANGE_2p5(0) , \4:MR_SQUELCH_RANGE_2p5(0)  );
resistor #(.r(0.2048)) (*
integer library_binding = "analogLib";
 *)

rd37 ( \7:GNDRX , \5:GNDRX  );
resistor #(.r(1.0008)) (*
integer library_binding = "analogLib";
 *)

rd38 ( \5:GNDRX , \6:GNDRX  );
resistor #(.r(60)) (*
integer library_binding = "analogLib";
 *)
rd19
 ( \5:GNDRX , GNDRX );
resistor #(.r(0.3173)) (*
integer library_binding = "analogLib";
 *)

rd20 ( \26:GND , \24:GND  );
resistor #(.r(16.9979)) (*
integer library_binding = "analogLib";
 *)

rd21 ( \26:GND , \4:GND  );
resistor #(.r(3.2117)) (*
integer library_binding = "analogLib";
 *)

rd22 ( \4:GND , \5:GND  );
resistor #(.r(0.8542)) (*
integer library_binding = "analogLib";
 *)

rd23 ( \4:GND , GND );
resistor #(.r(57.424)) (*
integer library_binding = "analogLib";
 *)

rd65 ( \1:PHY(2) , \PHY(2)  );
resistor #(.r(45.2435)) (*
integer library_binding = "analogLib";
 *)

rd31 ( \1:B10_DIS , \5:B10_DIS  );
resistor #(.r(57.424)) (*
integer library_binding = "analogLib";
 *)

rd50 ( \1:SCAN_MODE , SCAN_MODE );
resistor #(.r(139.829)) (*
integer library_binding = "analogLib";
 *)

rd51 ( \WANDER_CNT(3) , \4:WANDER_CNT(3)  );
resistor #(.r(72.871)) (*
integer library_binding = "analogLib";
 *)

rd52 ( \ADC_1p0(5) , \3:ADC_1p0(5)  );
resistor #(.r(233.194)) (*
integer library_binding = "analogLib";
 *)

rd53 ( \ADC_1p0(5) , \6:ADC_1p0(5)  );
resistor #(.r(68.0868)) (*
integer library_binding = "analogLib";
 *)

rd54 ( \3:ADC_1p0(5) , \2:ADC_1p0(5)  );
resistor #(.r(120.267)) (*
integer library_binding = "analogLib";
 *)

rd29 ( \2:ADC_1p0(5) , \7:ADC_1p0(5)  );
resistor #(.r(57.424)) (*
integer library_binding = "analogLib";
 *)

rd58 ( RXDV, \1:RXDV  );
resistor #(.r(89.1551)) (*
integer library_binding = "analogLib";
 *)

rd17 ( \TX_SLOPETRIM_1p0(0) , \3:TX_SLOPETRIM_1p0(0)  );
resistor #(.r(31.7995)) (*
integer library_binding = "analogLib";
 *)

rd16 ( \I_REXT_100(6) , \2:I_REXT_100(6)  );
resistor #(.r(49.2445)) (*
integer library_binding = "analogLib";
 *)

rd28 ( \3:TXER , \5:TXER  );
resistor #(.r(73.5255)) (*
integer library_binding = "analogLib";
 *)

rd30 ( \ADC_1p0(3) , \3:ADC_1p0(3)  );
resistor #(.r(230.718)) (*
integer library_binding = "analogLib";
 *)

rd57 ( \3:ADC_1p0(3) , \6:ADC_1p0(3)  );
resistor #(.r(120.527)) (*
integer library_binding = "analogLib";
 *)

rd42 ( \2:ADC_1p0(3) , \7:ADC_1p0(3)  );
resistor #(.r(42.6475)) (*
integer library_binding = "analogLib";
 *)

rd43 ( RESET_DSP, \6:RESET_DSP  );
resistor #(.r(57.424)) (*
integer library_binding = "analogLib";
 *)

rd44 ( \1:LEDD , LEDD );
resistor #(.r(72.485)) (*
integer library_binding = "analogLib";
 *)

rd45 ( \ADC_1p0(0) , \3:ADC_1p0(0)  );
resistor #(.r(235.148)) (*
integer library_binding = "analogLib";
 *)

rd46 ( \ADC_1p0(0) , \6:ADC_1p0(0)  );
resistor #(.r(69.1434)) (*
integer library_binding = "analogLib";
 *)

rd34 ( \3:ADC_1p0(0) , \2:ADC_1p0(0)  );
resistor #(.r(118.641)) (*
integer library_binding = "analogLib";
 *)

rd61 ( \2:ADC_1p0(0) , \7:ADC_1p0(0)  );
resistor #(.r(17.6611)) (*
integer library_binding = "analogLib";
 *)

rd62 ( \TENBT_FILTER_1p0(2) , \6:TENBT_FILTER_1p0(2)  );
resistor #(.r(89.167)) (*
integer library_binding = "analogLib";
 *)

rd40 ( X_160, \3:X_160  );
resistor #(.r(115.594)) (*
integer library_binding = "analogLib";
 *)

rd41 ( AEQ_BYPASS, \6:AEQ_BYPASS  );
resistor #(.r(57.424)) (*
integer library_binding = "analogLib";
 *)

rd55 ( \1:PHY(0) , \PHY(0)  );
resistor #(.r(50.88)) (*
integer library_binding = "analogLib";
 *)

rd56 ( \PHASE_IN(3) , \2:PHASE_IN(3)  );
resistor #(.r(29.9402)) (*
integer library_binding = "analogLib";
 *)

re1 ( \I_REXT_100(0) , \2:I_REXT_100(0)  );
resistor #(.r(114.962)) (*
integer library_binding = "analogLib";
 *)

re20 ( \2:I_REXT_100(0) , \4:I_REXT_100(0)  );
resistor #(.r(57.424)) (*
integer library_binding = "analogLib";
 *)

re22 ( RXC, \1:RXC  );
resistor #(.r(49.5925)) (*
integer library_binding = "analogLib";
 *)

re4 ( \5:B100_DIS , \1:B100_DIS  );
resistor #(.r(49.224)) (*
integer library_binding = "analogLib";
 *)

re17 ( \PHASE_IN(6) , \3:PHASE_IN(6)  );
resistor #(.r(117.204)) (*
integer library_binding = "analogLib";
 *)

re19 ( I_REXT_REF100, \8:I_REXT_REF100  );
resistor #(.r(1.3257)) (*
integer library_binding = "analogLib";
 *)

re23 ( \3:VDDRX , \2:VDDRX  );
resistor #(.r(100.627)) (*
integer library_binding = "analogLib";
 *)

re21 ( \AEQ_CNT_ANLG(1) , \5:AEQ_CNT_ANLG(1)  );
resistor #(.r(30.9151)) (*
integer library_binding = "analogLib";
 *)

re18 ( \PHASE_IN(2) , \4:PHASE_IN(2)  );
resistor #(.r(89.1665)) (*
integer library_binding = "analogLib";
 *)

rf13 ( TP_DISC_1p0, \3:TP_DISC_1p0  );
resistor #(.r(20.707)) (*
integer library_binding = "analogLib";
 *)

rf14 ( SLICER_OUT_2p5, \4:SLICER_OUT_2p5  );
resistor #(.r(1.0632)) (*
integer library_binding = "analogLib";
 *)

rf74 ( \2:RESETN , \6:RESETN  );
resistor #(.r(87.4609)) (*
integer library_binding = "analogLib";
 *)

rf75 ( \2:RESETN , \5:RESETN  );
resistor #(.r(24.8755)) (*
integer library_binding = "analogLib";
 *)

rf92 ( \2:RESETN , RESETN );
resistor #(.r(57.424)) (*
integer library_binding = "analogLib";
 *)

rf93 ( \1:LEDS , LEDS );
resistor #(.r(66.674)) (*
integer library_binding = "analogLib";
 *)

rf94 ( \PHASE_IN(4) , \6:PHASE_IN(4)  );
resistor #(.r(36.344)) (*
integer library_binding = "analogLib";
 *)

rf17 ( \1:B100_DIS , \4:B100_DIS  );
resistor #(.r(21.08)) (*
integer library_binding = "analogLib";
 *)

rf19 ( \1:B100_DIS , B100_DIS );
resistor #(.r(4.4702)) (*
integer library_binding = "analogLib";
 *)

rf16 ( \1:BGTRIM(1) , \BGTRIM(1)  );
resistor #(.r(57.424)) (*
integer library_binding = "analogLib";
 *)

rf95 ( \TXD(0) , \1:TXD(0)  );
resistor #(.r(31.207)) (*
integer library_binding = "analogLib";
 *)

rf96 ( \PHASE_250(0) , \4:PHASE_250(0)  );
resistor #(.r(115.11)) (*
integer library_binding = "analogLib";
 *)

rf98 ( \I_REXT_100(1) , \2:I_REXT_100(1)  );
resistor #(.r(30.2622)) (*
integer library_binding = "analogLib";
 *)

rf100 ( \2:I_REXT_100(1) , \3:I_REXT_100(1)  );
resistor #(.r(407.8)) (*
integer library_binding = "analogLib";
 *)

rf71 ( \3:PHASE_IN(6) , \4:PHASE_IN(6)  );
resistor #(.r(644.947)) (*
integer library_binding = "analogLib";
 *)

rf73 ( I_REXT_REF100, \2:I_REXT_REF100  );
resistor #(.r(0.1689)) (*
integer library_binding = "analogLib";
 *)

rf103 ( \2:VDDRX , \4:VDDRX  );
resistor #(.r(60)) (*
integer library_binding = "analogLib";
 *)
rf101
 ( \2:VDDRX , VDDRX );
resistor #(.r(141.219)) (*
integer library_binding = "analogLib";
 *)

rf102 ( \WANDER_CNT(1) , \5:WANDER_CNT(1)  );
resistor #(.r(89.1625)) (*
integer library_binding = "analogLib";
 *)

rf105 ( \MLT3_TDATA_1p0(1) , \4:MLT3_TDATA_1p0(1)  );
resistor #(.r(31.4755)) (*
integer library_binding = "analogLib";
 *)

rf21 ( \I_REXT_100(5) , \3:I_REXT_100(5)  );
resistor #(.r(115.702)) (*
integer library_binding = "analogLib";
 *)

rf24 ( \I_REXT_100(5) , \4:I_REXT_100(5)  );
resistor #(.r(38.4885)) (*
integer library_binding = "analogLib";
 *)

rf25 ( GNDTX, \22:GNDTX  );
resistor #(.r(3.856)) (*
integer library_binding = "analogLib";
 *)

rf26 ( \22:GNDTX , \23:GNDTX  );
resistor #(.r(36.3825)) (*
integer library_binding = "analogLib";
 *)

rf27 ( RCLK125_TST_SEL, \3:RCLK125_TST_SEL  );
resistor #(.r(64.4201)) (*
integer library_binding = "analogLib";
 *)

rf28 ( \ADC_1p0(2) , \3:ADC_1p0(2)  );
resistor #(.r(117.737)) (*
integer library_binding = "analogLib";
 *)

rf29 ( \ADC_1p0(2) , \7:ADC_1p0(2)  );
resistor #(.r(73.7371)) (*
integer library_binding = "analogLib";
 *)

rf30 ( \3:ADC_1p0(2) , \4:ADC_1p0(2)  );
resistor #(.r(236.154)) (*
integer library_binding = "analogLib";
 *)

rf31 ( \4:ADC_1p0(2) , \6:ADC_1p0(2)  );
resistor #(.r(124.675)) (*
integer library_binding = "analogLib";
 *)

rf32 ( \I_REXT_50(1) , \2:I_REXT_50(1)  );
resistor #(.r(57.424)) (*
integer library_binding = "analogLib";
 *)

rf84 ( MDINT, \1:MDINT  );
resistor #(.r(30.2284)) (*
integer library_binding = "analogLib";
 *)

rf85 ( \PHASE_250(5) , \4:PHASE_250(5)  );
resistor #(.r(89.1618)) (*
integer library_binding = "analogLib";
 *)

rf41 ( \TX_AMPTRIM_1p0(1) , \4:TX_AMPTRIM_1p0(1)  );
resistor #(.r(72.1431)) (*
integer library_binding = "analogLib";
 *)

rf39 ( \ADC_1p0(3) , \2:ADC_1p0(3)  );
resistor #(.r(395.597)) (*
integer library_binding = "analogLib";
 *)

rf72 ( \4:PHASE_IN(2) , \2:PHASE_IN(2)  );
resistor #(.r(109.088)) (*
integer library_binding = "analogLib";
 *)

rf107 ( \MR_SQUELCH_RANGE_2p5(1) , \3:MR_SQUELCH_RANGE_2p5(1)  );
resistor #(.r(57.424)) (*
integer library_binding = "analogLib";
 *)

rf106 ( LEDT, \1:LEDT  );
resistor #(.r(33.3895)) (*
integer library_binding = "analogLib";
 *)

rf5 ( \2:I_RPOLY_100(4) , \3:I_RPOLY_100(4)  );
resistor #(.r(17.694)) (*
integer library_binding = "analogLib";
 *)

rf9 ( BASE10_TX_DIS_1p0, \5:BASE10_TX_DIS_1p0  );
resistor #(.r(57.424)) (*
integer library_binding = "analogLib";
 *)

rf7 ( \1:RXER , RXER );
resistor #(.r(96.5077)) (*
integer library_binding = "analogLib";
 *)

rf8 ( \5:BASEFX_DIS , \7:BASEFX_DIS  );
resistor #(.r(19.5248)) (*
integer library_binding = "analogLib";
 *)

rf10 ( \5:BASEFX_DIS , \9:BASEFX_DIS  );
resistor #(.r(8.4575)) (*
integer library_binding = "analogLib";
 *)

rf11 ( \5:BASEFX_DIS , BASEFX_DIS );
resistor #(.r(294.02)) (*
integer library_binding = "analogLib";
 *)

rf12 ( \8:I_REXT_400_TX , \7:I_REXT_400_TX  );
resistor #(.r(230.655)) (*
integer library_binding = "analogLib";
 *)

rf1 ( \4:FLASH_1p0(1) , \6:FLASH_1p0(1)  );
resistor #(.r(30.5055)) (*
integer library_binding = "analogLib";
 *)

rf45 ( \I_REXT_100(2) , \2:I_REXT_100(2)  );
resistor #(.r(115.258)) (*
integer library_binding = "analogLib";
 *)

rf46 ( \2:I_REXT_100(2) , \4:I_REXT_100(2)  );
resistor #(.r(69.8131)) (*
integer library_binding = "analogLib";
 *)

rf43 ( \9:TX100_DIS_2p5 , \2:TX100_DIS_2p5  );
resistor #(.r(30.8258)) (*
integer library_binding = "analogLib";
 *)

rf56 ( \PHASE_250(2) , \4:PHASE_250(2)  );
resistor #(.r(57.424)) (*
integer library_binding = "analogLib";
 *)

rf90 ( \TXD(3) , \1:TXD(3)  );
resistor #(.r(399.938)) (*
integer library_binding = "analogLib";
 *)

rf62 ( \2:PHASE_IN(5) , \1:PHASE_IN(5)  );
resistor #(.r(57.424)) (*
integer library_binding = "analogLib";
 *)

rf63 ( \1:PHY(3) , \PHY(3)  );
resistor #(.r(89.1691)) (*
integer library_binding = "analogLib";
 *)

rf50 ( \MLT3_TDATA_1p0(0) , \4:MLT3_TDATA_1p0(0)  );
resistor #(.r(105.603)) (*
integer library_binding = "analogLib";
 *)

rf54 ( \2:I_REXT_50(0) , \6:I_REXT_50(0)  );
resistor #(.r(89.1711)) (*
integer library_binding = "analogLib";
 *)

rf82 ( POS_DETECT_1p0, \3:POS_DETECT_1p0  );
resistor #(.r(372.257)) (*
integer library_binding = "analogLib";
 *)

rg273 ( \PHASE_IN(4) , \4:PHASE_IN(4)  );
resistor #(.r(27.0765)) (*
integer library_binding = "analogLib";
 *)

rg243 ( \4:PHASE_IN(4) , \7:PHASE_IN(4)  );
resistor #(.r(119.175)) (*
integer library_binding = "analogLib";
 *)

rg258 ( \ADC_1p0(1) , \1:ADC_1p0(1)  );
resistor #(.r(72.4626)) (*
integer library_binding = "analogLib";
 *)

rg257 ( \1:ADC_1p0(1) , \3:ADC_1p0(1)  );
resistor #(.r(73.829)) (*
integer library_binding = "analogLib";
 *)

rg261 ( \3:ADC_1p0(1) , \4:ADC_1p0(1)  );
resistor #(.r(231.72)) (*
integer library_binding = "analogLib";
 *)

rg262 ( \4:ADC_1p0(1) , \6:ADC_1p0(1)  );
resistor #(.r(264.378)) (*
integer library_binding = "analogLib";
 *)

rg236 ( \3:SIDDQ , \5:SIDDQ  );
resistor #(.r(89.1457)) (*
integer library_binding = "analogLib";
 *)

rg237 ( \3:SIDDQ , \2:SIDDQ  );
resistor #(.r(12.1615)) (*
integer library_binding = "analogLib";
 *)

rg238 ( \2:SIDDQ , \7:SIDDQ  );
resistor #(.r(0.1922)) (*
integer library_binding = "analogLib";
 *)

rg240 ( \2:SIDDQ , \8:SIDDQ  );
resistor #(.r(4.4702)) (*
integer library_binding = "analogLib";
 *)

rg241 ( \7:SIDDQ , SIDDQ );
resistor #(.r(400.738)) (*
integer library_binding = "analogLib";
 *)

rg239 ( \5:SIDDQ , \10:SIDDQ  );
resistor #(.r(23.2128)) (*
integer library_binding = "analogLib";
 *)

rg227 ( \4:PHASE_IN(6) , \7:PHASE_IN(6)  );
resistor #(.r(382.326)) (*
integer library_binding = "analogLib";
 *)

rg207 ( \2:I_REXT_REF100 , \7:I_REXT_REF100  );
resistor #(.r(30.1857)) (*
integer library_binding = "analogLib";
 *)

rg14 ( \PHASE_250(7) , \4:PHASE_250(7)  );
resistor #(.r(160.742)) (*
integer library_binding = "analogLib";
 *)

rg13 ( \3:I_REXT_100_NC , \6:I_REXT_100_NC  );
resistor #(.r(87.2449)) (*
integer library_binding = "analogLib";
 *)

rg12 ( \3:I_REXT_100_NC , \9:I_REXT_100_NC  );
resistor #(.r(131.366)) (*
integer library_binding = "analogLib";
 *)

rg11 ( \6:I_REXT_100_NC , \10:I_REXT_100_NC  );
resistor #(.r(138.345)) (*
integer library_binding = "analogLib";
 *)

rg16 ( \WANDER_CNT(5) , \4:WANDER_CNT(5)  );
resistor #(.r(32.4335)) (*
integer library_binding = "analogLib";
 *)

rg17 ( \I_RPOLY_100(1) , \2:I_RPOLY_100(1)  );
resistor #(.r(116.466)) (*
integer library_binding = "analogLib";
 *)

rg3 ( \2:I_RPOLY_100(1) , \4:I_RPOLY_100(1)  );
resistor #(.r(57.424)) (*
integer library_binding = "analogLib";
 *)

rg1 ( SCAN_ENABLE, \1:SCAN_ENABLE  );
resistor #(.r(89.1599)) (*
integer library_binding = "analogLib";
 *)

rg274 ( \TEST_MODE(0) , \4:TEST_MODE(0)  );
resistor #(.r(217.505)) (*
integer library_binding = "analogLib";
 *)

rg275 ( \MLT3_TDATA_2p5(0) , \3:MLT3_TDATA_2p5(0)  );
resistor #(.r(445.706)) (*
integer library_binding = "analogLib";
 *)

rg71 ( \2:I_REXT_50(1) , \6:I_REXT_50(1)  );
resistor #(.r(57.424)) (*
integer library_binding = "analogLib";
 *)

rg63 ( \TX_AMP_TRIM(1) , \1:TX_AMP_TRIM(1)  );
resistor #(.r(100.714)) (*
integer library_binding = "analogLib";
 *)

rg70 ( \AEQ_CNT_ANLG(2) , \4:AEQ_CNT_ANLG(2)  );
resistor #(.r(57.424)) (*
integer library_binding = "analogLib";
 *)

rg69 ( \1:RXD(0) , \RXD(0)  );
resistor #(.r(89.1718)) (*
integer library_binding = "analogLib";
 *)

rg65 ( \TEST_MODE(1) , \3:TEST_MODE(1)  );
resistor #(.r(21.133)) (*
integer library_binding = "analogLib";
 *)

rg73 ( NEG_DETECT_2p5, \4:NEG_DETECT_2p5  );
resistor #(.r(18.9321)) (*
integer library_binding = "analogLib";
 *)

rg72 ( \4:VDD , \9:VDD  );
resistor #(.r(5.0426)) (*
integer library_binding = "analogLib";
 *)

rg68 ( \4:VDD , \7:VDD  );
resistor #(.r(0.09274)) (*
integer library_binding = "analogLib";
 *)

rg74 ( \4:VDD , \11:VDD  );
resistor #(.r(3.0666)) (*
integer library_binding = "analogLib";
 *)

rg67 ( \7:VDD , \6:VDD  );
resistor #(.r(0.4097)) (*
integer library_binding = "analogLib";
 *)

rg155 ( \7:VDD , VDD );
resistor #(.r(0.375)) (*
integer library_binding = "analogLib";
 *)

rg157 ( \6:VDD , \10:VDD  );
resistor #(.r(0.01002)) (*
integer library_binding = "analogLib";
 *)

rg7 ( \5:GND , \25:GND  );
resistor #(.r(0.09197)) (*
integer library_binding = "analogLib";
 *)

rg9 ( \5:GND , \27:GND  );
resistor #(.r(39.468)) (*
integer library_binding = "analogLib";
 *)

rg194 ( \1:B10_DIS , \4:B10_DIS  );
resistor #(.r(17.956)) (*
integer library_binding = "analogLib";
 *)

rg208 ( \1:B10_DIS , B10_DIS );
resistor #(.r(115.903)) (*
integer library_binding = "analogLib";
 *)

rg15 ( \2:I_REXT_100(6) , \4:I_REXT_100(6)  );
resistor #(.r(16.9855)) (*
integer library_binding = "analogLib";
 *)

rg43 ( \TENBT_FILTER_1p0(3) , \5:TENBT_FILTER_1p0(3)  );
resistor #(.r(20.919)) (*
integer library_binding = "analogLib";
 *)

rg44 ( POS_DETECT_2p5, \5:POS_DETECT_2p5  );
resistor #(.r(116.158)) (*
integer library_binding = "analogLib";
 *)

rg175 ( \2:I_RPOLY_100(0) , \4:I_RPOLY_100(0)  );
resistor #(.r(50.99)) (*
integer library_binding = "analogLib";
 *)

rg226 ( \2:PHASE_IN(2) , \6:PHASE_IN(2)  );
resistor #(.r(399.51)) (*
integer library_binding = "analogLib";
 *)

rg18 ( \2:PHASE_IN(3) , \4:PHASE_IN(3)  );
resistor #(.r(26.1568)) (*
integer library_binding = "analogLib";
 *)

rg20 ( \4:PHASE_IN(3) , \7:PHASE_IN(3)  );
resistor #(.r(30.6643)) (*
integer library_binding = "analogLib";
 *)

rg277 ( \PHASE_250(3) , \4:PHASE_250(3)  );
resistor #(.r(117.39)) (*
integer library_binding = "analogLib";
 *)

rg276 ( \I_RPOLY_100(4) , \2:I_RPOLY_100(4)  );
resistor #(.r(31.1535)) (*
integer library_binding = "analogLib";
 *)

rg81 ( \I_REXT_100(4) , \2:I_REXT_100(4)  );
resistor #(.r(115.554)) (*
integer library_binding = "analogLib";
 *)

rg83 ( \2:I_REXT_100(4) , \4:I_REXT_100(4)  );
resistor #(.r(57.424)) (*
integer library_binding = "analogLib";
 *)

rg88 ( \RXD(3) , \1:RXD(3)  );
resistor #(.r(89.1711)) (*
integer library_binding = "analogLib";
 *)

rg87 ( \TX_AMPTRIM_1p0(0) , \3:TX_AMPTRIM_1p0(0)  );
resistor #(.r(249.506)) (*
integer library_binding = "analogLib";
 *)

rg86 ( \1:PLL_160_IN , \4:PLL_160_IN  );
resistor #(.r(259.395)) (*
integer library_binding = "analogLib";
 *)

rg89 ( \1:PLL_160_IN , PLL_160_IN );
resistor #(.r(40)) (*
integer library_binding = "analogLib";
 *)
rg85
 ( \1:TPIP , TPIP );
resistor #(.r(267.493)) (*
integer library_binding = "analogLib";
 *)

rg148 ( \3:XTAL25 , \6:XTAL25  );
resistor #(.r(89.0132)) (*
integer library_binding = "analogLib";
 *)

rg153 ( \3:XTAL25 , \5:XTAL25  );
resistor #(.r(5.985)) (*
integer library_binding = "analogLib";
 *)

rg152 ( \5:XTAL25 , XTAL25 );
resistor #(.r(16.962)) (*
integer library_binding = "analogLib";
 *)

rg151 ( \TENBT_FILTER_1p0(1) , \5:TENBT_FILTER_1p0(1)  );
resistor #(.r(4.4702)) (*
integer library_binding = "analogLib";
 *)

rg154 ( \1:DISABLE100 , DISABLE100 );
resistor #(.r(142.133)) (*
integer library_binding = "analogLib";
 *)

rg150 ( X10_DIS_2p5, \3:X10_DIS_2p5  );
resistor #(.r(57.424)) (*
integer library_binding = "analogLib";
 *)

rg5 ( \TXD(4) , \1:TXD(4)  );
resistor #(.r(25)) (*
integer library_binding = "analogLib";
 *)
rg24
 ( \1:RBIAS , RBIAS );
resistor #(.r(235.804)) (*
integer library_binding = "analogLib";
 *)

rg174 ( RCLK125_1p0, \4:RCLK125_1p0  );
resistor #(.r(397.797)) (*
integer library_binding = "analogLib";
 *)

rg256 ( \PHASE_IN(8) , \4:PHASE_IN(8)  );
resistor #(.r(22.1984)) (*
integer library_binding = "analogLib";
 *)

rg255 ( \7:PHASE_IN(10) , \4:PHASE_IN(10)  );
resistor #(.r(57.424)) (*
integer library_binding = "analogLib";
 *)

rg254 ( ANLG_TST, \1:ANLG_TST  );
resistor #(.r(117.582)) (*
integer library_binding = "analogLib";
 *)

rg253 ( \2:I_RPOLY_100(5) , \4:I_RPOLY_100(5)  );
resistor #(.r(48.2628)) (*
integer library_binding = "analogLib";
 *)

rg252 ( \PHASE_IN(1) , \1:PHASE_IN(1)  );
resistor #(.r(117.082)) (*
integer library_binding = "analogLib";
 *)

rg251 ( \4:I_RPOLY_100(3) , \2:I_RPOLY_100(3)  );
resistor #(.r(142.051)) (*
integer library_binding = "analogLib";
 *)

rg250 ( \WANDER_CNT(0) , \4:WANDER_CNT(0)  );
resistor #(.r(140.004)) (*
integer library_binding = "analogLib";
 *)

rg60 ( \2:TX100_DIS_2p5 , TX100_DIS_2p5 );
resistor #(.r(71.7544)) (*
integer library_binding = "analogLib";
 *)

rg234 ( \2:TX100_DIS_2p5 , \8:TX100_DIS_2p5  );
resistor #(.r(115.251)) (*
integer library_binding = "analogLib";
 *)

rg90 ( \7:ADC_1p0(4) , \1:ADC_1p0(4)  );
resistor #(.r(75.3768)) (*
integer library_binding = "analogLib";
 *)

rg235 ( \1:ADC_1p0(4) , \ADC_1p0(4)  );
resistor #(.r(72.6615)) (*
integer library_binding = "analogLib";
 *)

rg263 ( \ADC_1p0(4) , \3:ADC_1p0(4)  );
resistor #(.r(57.424)) (*
integer library_binding = "analogLib";
 *)

rg270 ( \1:TXEN , TXEN );
resistor #(.r(48.782)) (*
integer library_binding = "analogLib";
 *)

rg271 ( \PHASE_IN(9) , \2:PHASE_IN(9)  );
resistor #(.r(89.1576)) (*
integer library_binding = "analogLib";
 *)

rg39 ( X_125, \4:X_125  );
resistor #(.r(30.7702)) (*
integer library_binding = "analogLib";
 *)

rg264 ( \PHASE_250(9) , \3:PHASE_250(9)  );
resistor #(.r(115.406)) (*
integer library_binding = "analogLib";
 *)

rg249 ( \2:I_REXT_100(3) , \4:I_REXT_100(3)  );
resistor #(.r(57.424)) (*
integer library_binding = "analogLib";
 *)

rg248 ( \1:TX_SLP_TRIM(0) , \TX_SLP_TRIM(0)  );
resistor #(.r(4.4702)) (*
integer library_binding = "analogLib";
 *)

rg247 ( \1:BGTRIM(2) , \BGTRIM(2)  );
resistor #(.r(57.424)) (*
integer library_binding = "analogLib";
 *)

rg246 ( \TXD(1) , \1:TXD(1)  );
resistor #(.r(406.09)) (*
integer library_binding = "analogLib";
 *)

rg245 ( \3:PHASE_IN(7) , \5:PHASE_IN(7)  );
resistor #(.r(100.738)) (*
integer library_binding = "analogLib";
 *)

rg244 ( \AEQ_CNT_ANLG(4) , \5:AEQ_CNT_ANLG(4)  );
resistor #(.r(217.703)) (*
integer library_binding = "analogLib";
 *)

rg38 ( \MLT3_TDATA_2p5(1) , \4:MLT3_TDATA_2p5(1)  );
resistor #(.r(4.9308)) (*
integer library_binding = "analogLib";
 *)

rg37 ( \25:VDDTX , \24:VDDTX  );
resistor #(.r(60)) (*
integer library_binding = "analogLib";
 *)
rg268
 ( \24:VDDTX , VDDTX );
resistor #(.r(140.571)) (*
integer library_binding = "analogLib";
 *)

rg266 ( \WANDER_CNT(2) , \5:WANDER_CNT(2)  );
resistor #(.r(57.424)) (*
integer library_binding = "analogLib";
 *)

rg267 ( LEDC, \1:LEDC  );
resistor #(.r(47.1795)) (*
integer library_binding = "analogLib";
 *)

rg105 ( \1:PHASE_IN(5) , \PHASE_IN(5)  );
resistor #(.r(60)) (*
integer library_binding = "analogLib";
 *)
rg159
 ( \1:TPON , TPON );
resistor #(.r(57.424)) (*
integer library_binding = "analogLib";
 *)

rg99 ( MDIO_IN, \1:MDIO_IN  );
resistor #(.r(30.7682)) (*
integer library_binding = "analogLib";
 *)

rg161 ( \PHASE_250(6) , \4:PHASE_250(6)  );
resistor #(.r(50)) (*
integer library_binding = "analogLib";
 *)
rg160
 ( \1:GNDA_250 , GNDA_250 );
resistor #(.r(120.735)) (*
integer library_binding = "analogLib";
 *)

rg127 ( \7:I_REXT_50(0) , \I_REXT_50(0)  );
resistor #(.r(57.424)) (*
integer library_binding = "analogLib";
 *)

rg119 ( \TX_AMP_TRIM(0) , \1:TX_AMP_TRIM(0)  );
resistor #(.r(50)) (*
integer library_binding = "analogLib";
 *)
rg146
 ( \1:VDDA_160 , VDDA_160 );
resistor #(.r(57.424)) (*
integer library_binding = "analogLib";
 *)

rg145 ( \1:LEDL , LEDL );
resistor #(.r(102.509)) (*
integer library_binding = "analogLib";
 *)

rg147 ( ADC_DIS_2p5, \5:ADC_DIS_2p5  );
resistor #(.r(57.424)) (*
integer library_binding = "analogLib";
 *)

rg111 ( MDC, \1:MDC  );
resistor #(.r(25)) (*
integer library_binding = "analogLib";
 *)
rg193
 ( \1:RBIAS_SENSE , RBIAS_SENSE );
resistor #(.r(111.727)) (*
integer library_binding = "analogLib";
 *)

rg211 ( \5:MR_BYPASS10RX_FILTER , MR_BYPASS10RX_FILTER );
resistor #(.r(57.424)) (*
integer library_binding = "analogLib";
 *)

rg176 ( \RXD(2) , \1:RXD(2)  );
resistor #(.r(40)) (*
integer library_binding = "analogLib";
 *)
rg225
 ( \1:TPIN , TPIN );
resistor #(.r(0.09418)) (*
integer library_binding = "analogLib";
 *)

rh192 ( \5:SIDDQ , \9:SIDDQ  );
resistor #(.r(57.424)) (*
integer library_binding = "analogLib";
 *)

rh191 ( \1:PHY(4) , \PHY(4)  );
resistor #(.r(0.3048)) (*
integer library_binding = "analogLib";
 *)

rh48 ( \6:VDD , \12:VDD  );
resistor #(.r(57.424)) (*
integer library_binding = "analogLib";
 *)

rh47 ( \1:LEDR , LEDR );
resistor #(.r(31.8661)) (*
integer library_binding = "analogLib";
 *)

rh45 ( \PHASE_IN(0) , \7:PHASE_IN(0)  );
resistor #(.r(32.1175)) (*
integer library_binding = "analogLib";
 *)

rh14 ( \2:I_RPOLY_100(0) , \I_RPOLY_100(0)  );
resistor #(.r(72.1034)) (*
integer library_binding = "analogLib";
 *)

rh27 ( \FLASH_1p0(0) , \3:FLASH_1p0(0)  );
resistor #(.r(116.087)) (*
integer library_binding = "analogLib";
 *)

rh145 ( \FLASH_1p0(0) , \7:FLASH_1p0(0)  );
resistor #(.r(72.5891)) (*
integer library_binding = "analogLib";
 *)

rh146 ( \3:FLASH_1p0(0) , \4:FLASH_1p0(0)  );
resistor #(.r(230.042)) (*
integer library_binding = "analogLib";
 *)

rh212 ( \4:FLASH_1p0(0) , \6:FLASH_1p0(0)  );
resistor #(.r(27.064)) (*
integer library_binding = "analogLib";
 *)

rh149 ( \3:TXER , \4:TXER  );
resistor #(.r(89.153)) (*
integer library_binding = "analogLib";
 *)

rh147 ( RX10_PRESENT_1p0, \4:RX10_PRESENT_1p0  );
resistor #(.r(64.1816)) (*
integer library_binding = "analogLib";
 *)

rh50 ( \3:X10_DIS_2p5 , \7:X10_DIS_2p5  );
resistor #(.r(72.2577)) (*
integer library_binding = "analogLib";
 *)

rh57 ( \3:X10_DIS_2p5 , \6:X10_DIS_2p5  );
resistor #(.r(116.774)) (*
integer library_binding = "analogLib";
 *)

rh56 ( \I_RPOLY_100(2) , \4:I_RPOLY_100(2)  );
resistor #(.r(32.7515)) (*
integer library_binding = "analogLib";
 *)

rh52 ( \I_RPOLY_100(2) , \3:I_RPOLY_100(2)  );
resistor #(.r(69.5234)) (*
integer library_binding = "analogLib";
 *)

rh55 ( \FLASH_1p0(1) , \3:FLASH_1p0(1)  );
resistor #(.r(120.823)) (*
integer library_binding = "analogLib";
 *)

rh58 ( \FLASH_1p0(1) , \7:FLASH_1p0(1)  );
resistor #(.r(73.5191)) (*
integer library_binding = "analogLib";
 *)

rh54 ( \3:FLASH_1p0(1) , \4:FLASH_1p0(1)  );
resistor #(.r(141.308)) (*
integer library_binding = "analogLib";
 *)

rh13 ( \4:RCLK125_1p0 , \1:RCLK125_1p0  );
resistor #(.r(118.616)) (*
integer library_binding = "analogLib";
 *)

rh142 ( \1:RCLK125_1p0 , \7:RCLK125_1p0  );
resistor #(.r(48.362)) (*
integer library_binding = "analogLib";
 *)

rh181 ( \PHASE_IN(8) , \6:PHASE_IN(8)  );
resistor #(.r(31.8891)) (*
integer library_binding = "analogLib";
 *)

rh213 ( \4:PHASE_IN(8) , \7:PHASE_IN(8)  );
resistor #(.r(377.618)) (*
integer library_binding = "analogLib";
 *)

rh180 ( \4:PHASE_IN(10) , \PHASE_IN(10)  );
resistor #(.r(64.816)) (*
integer library_binding = "analogLib";
 *)

rh214 ( \PHASE_IN(10) , \6:PHASE_IN(10)  );
resistor #(.r(17.6722)) (*
integer library_binding = "analogLib";
 *)

rh179 ( \TENBT_FILTER_1p0(0) , \6:TENBT_FILTER_1p0(0)  );
resistor #(.r(33.7075)) (*
integer library_binding = "analogLib";
 *)

rh215 ( \I_RPOLY_100(5) , \2:I_RPOLY_100(5)  );
resistor #(.r(137.603)) (*
integer library_binding = "analogLib";
 *)

rh178 ( \WANDER_CNT(6) , \5:WANDER_CNT(6)  );
resistor #(.r(89.1618)) (*
integer library_binding = "analogLib";
 *)

rh216 ( \MR_SQUELCH_RANGE_1p0(1) , \4:MR_SQUELCH_RANGE_1p0(1)  );
resistor #(.r(239.262)) (*
integer library_binding = "analogLib";
 *)

rh177 ( \1:PHASE_IN(1) , \2:PHASE_IN(1)  );
resistor #(.r(31.4361)) (*
integer library_binding = "analogLib";
 *)

rh217 ( \2:PHASE_IN(1) , \5:PHASE_IN(1)  );
resistor #(.r(33.0715)) (*
integer library_binding = "analogLib";
 *)

rh176 ( \2:I_RPOLY_100(3) , \I_RPOLY_100(3)  );
resistor #(.r(57.424)) (*
integer library_binding = "analogLib";
 *)

rh218 ( \1:RXD(4) , \RXD(4)  );
resistor #(.r(30.789)) (*
integer library_binding = "analogLib";
 *)

rh175 ( \PHASE_250(1) , \3:PHASE_250(1)  );
resistor #(.r(57.424)) (*
integer library_binding = "analogLib";
 *)

rh219 ( \RXD(1) , \1:RXD(1)  );
resistor #(.r(41.8722)) (*
integer library_binding = "analogLib";
 *)

rh190 ( TIMING_UP_ANLG, \6:TIMING_UP_ANLG  );
resistor #(.r(113.363)) (*
integer library_binding = "analogLib";
 *)

rh209 ( BLW_DIS_2p5, \5:BLW_DIS_2p5  );
resistor #(.r(231.213)) (*
integer library_binding = "analogLib";
 *)

rh210 ( \3:ADC_1p0(4) , \6:ADC_1p0(4)  );
resistor #(.r(238.838)) (*
integer library_binding = "analogLib";
 *)

rh196 ( \2:PHASE_IN(9) , \4:PHASE_IN(9)  );
resistor #(.r(32.0678)) (*
integer library_binding = "analogLib";
 *)

rh40 ( \4:PHASE_IN(9) , \7:PHASE_IN(9)  );
resistor #(.r(107.117)) (*
integer library_binding = "analogLib";
 *)

rh197 ( AEQ_DIS_2p5, \6:AEQ_DIS_2p5  );
resistor #(.r(89.1579)) (*
integer library_binding = "analogLib";
 *)

rh12 ( XTAL25_1p0, \3:XTAL25_1p0  );
resistor #(.r(139.087)) (*
integer library_binding = "analogLib";
 *)

rh211 ( \WANDER_CNT(4) , \5:WANDER_CNT(4)  );
resistor #(.r(89.1711)) (*
integer library_binding = "analogLib";
 *)

rh26 ( MR_SQUELCH_DISB_1p0, \4:MR_SQUELCH_DISB_1p0  );
resistor #(.r(41.814)) (*
integer library_binding = "analogLib";
 *)

rh198 ( TIMING_DN_ANLG, \5:TIMING_DN_ANLG  );
resistor #(.r(30.8275)) (*
integer library_binding = "analogLib";
 *)

rh174 ( \2:I_REXT_100(3) , \I_REXT_100(3)  );
resistor #(.r(57.424)) (*
integer library_binding = "analogLib";
 *)

rh220 ( \1:ANDIS , ANDIS );
resistor #(.r(175.328)) (*
integer library_binding = "analogLib";
 *)

rh173 ( TP_DISC_2p5, \3:TP_DISC_2p5  );
resistor #(.r(116.672)) (*
integer library_binding = "analogLib";
 *)

rh221 ( T2_MODE, \6:T2_MODE  );
resistor #(.r(4.4702)) (*
integer library_binding = "analogLib";
 *)

rh172 ( \BGTRIM(3) , \1:BGTRIM(3)  );
resistor #(.r(60)) (*
integer library_binding = "analogLib";
 *)
rh222
 ( \1:TPOP , TPOP );
resistor #(.r(30.7682)) (*
integer library_binding = "analogLib";
 *)

rh171 ( \PHASE_250(10) , \4:PHASE_250(10)  );
resistor #(.r(48.6107)) (*
integer library_binding = "analogLib";
 *)

rh223 ( \PHASE_IN(7) , \3:PHASE_IN(7)  );
resistor #(.r(24.2386)) (*
integer library_binding = "analogLib";
 *)

rh170 ( \5:PHASE_IN(7) , \7:PHASE_IN(7)  );
resistor #(.r(57.424)) (*
integer library_binding = "analogLib";
 *)

rh224 ( MDIO_OUT, \1:MDIO_OUT  );
resistor #(.r(30.7682)) (*
integer library_binding = "analogLib";
 *)

rh169 ( \PHASE_250(8) , \4:PHASE_250(8)  );
resistor #(.r(57.424)) (*
integer library_binding = "analogLib";
 *)

rh225 ( \1:COL , COL );
resistor #(.r(50)) (*
integer library_binding = "analogLib";
 *)
rh199
 ( \1:VDDA_250 , VDDA_250 );
resistor #(.r(89.153)) (*
integer library_binding = "analogLib";
 *)

rh229 ( \TEST_MODE(2) , \3:TEST_MODE(2)  );
resistor #(.r(102.071)) (*
integer library_binding = "analogLib";
 *)

rh25 ( RX10_PRESENT_2p5, \6:RX10_PRESENT_2p5  );
resistor #(.r(4.4702)) (*
integer library_binding = "analogLib";
 *)

rh200 ( \1:BGTRIM(0) , \BGTRIM(0)  );
resistor #(.r(57.424)) (*
integer library_binding = "analogLib";
 *)

rh121 ( TXC, \1:TXC  );
resistor #(.r(89.1599)) (*
integer library_binding = "analogLib";
 *)

rh72 ( SLICER_OUT_1p0, \4:SLICER_OUT_1p0  );
resistor #(.r(89.1678)) (*
integer library_binding = "analogLib";
 *)

rh124 ( \4:TX_SLOPETRIM_1p0(1) , \TX_SLOPETRIM_1p0(1)  );
resistor #(.r(153.686)) (*
integer library_binding = "analogLib";
 *)

rh122 ( \I_REXT_50(0) , \2:I_REXT_50(0)  );
resistor #(.r(57.424)) (*
integer library_binding = "analogLib";
 *)

rh107 ( \1:PHY(1) , \PHY(1)  );
resistor #(.r(100.581)) (*
integer library_binding = "analogLib";
 *)

rh59 ( \4:AEQ_CNT_ANLG(0) , \AEQ_CNT_ANLG(0)  );
resistor #(.r(30.7702)) (*
integer library_binding = "analogLib";
 *)

rh123 ( \PHASE_250(4) , \4:PHASE_250(4)  );
resistor #(.r(4.4702)) (*
integer library_binding = "analogLib";
 *)

rh151 ( \1:DISABLE10 , DISABLE10 );
resistor #(.r(18.1875)) (*
integer library_binding = "analogLib";
 *)

rh38 ( RESET_10BT, \5:RESET_10BT  );
resistor #(.r(17.6504)) (*
integer library_binding = "analogLib";
 *)

rh113 ( TENBT_CLK160_1p0, \6:TENBT_CLK160_1p0  );
resistor #(.r(57.424)) (*
integer library_binding = "analogLib";
 *)

rh39 ( \1:TX_SLP_TRIM(1) , \TX_SLP_TRIM(1)  );
resistor #(.r(30.36)) (*
integer library_binding = "analogLib";
 *)

ri47 ( TXER, \3:TXER  );
resistor #(.r(57.424)) (*
integer library_binding = "analogLib";
 *)

ri46 ( CRS, \1:CRS  );
resistor #(.r(35.7558)) (*
integer library_binding = "analogLib";
 *)

ri37 ( RCLK125_TST, \4:RCLK125_TST  );
resistor #(.r(108.686)) (*
integer library_binding = "analogLib";
 *)

ri39 ( MR_SQUELCH_DISB_2p5, \3:MR_SQUELCH_DISB_2p5  );
resistor #(.r(31.6218)) (*
integer library_binding = "analogLib";
 *)

ri38 ( \5:PHASE_IN(5) , \2:PHASE_IN(5)  );
resistor #(.r(89.1258)) (*
integer library_binding = "analogLib";
 *)

ri21 ( NEG_DETECT_1p0, \3:NEG_DETECT_1p0  );
resistor #(.r(50)) (*
integer library_binding = "analogLib";
 *)
ri26
 ( \1:GNDA_160 , GNDA_160 );
resistor #(.r(89.0937)) (*
integer library_binding = "analogLib";
 *)

ri23 ( \3:MR_SQUELCH_RANGE_1p0(0) , \MR_SQUELCH_RANGE_1p0(0)  );

capacitor #(.c(1.028e-16)) (*
integer library_binding = "analogLib";

 *)
c1 ( \I_REXT_100(0) , \4:GND  );
capacitor #(.c(1.394e-17)) (*
integer library_binding = "analogLib";

 *)
c2 ( \I_REXT_100(0) , SLICER_OUT_2p5 );
capacitor #(.c(5.053e-16)) (*
integer library_binding = "analogLib";

 *)
c3 ( \I_REXT_100(0) , \2:I_REXT_100(1)  );
capacitor #(.c(1.384e-17)) (*
integer library_binding = "analogLib";

 *)
c4 ( \I_REXT_100(0) , \5:POS_DETECT_2p5  );
capacitor #(.c(1.637e-15)) (*
integer library_binding = "analogLib";

 *)
c5 ( \I_REXT_100(0) , \3:I_REXT_100(1)  );
capacitor #(.c(1.521e-17)) (*
integer library_binding = "analogLib";

 *)
c6 ( \I_REXT_100(0) , \I_REXT_100(2)  );
capacitor #(.c(4.329e-18)) (*
integer library_binding = "analogLib";

 *)
c7 ( \I_REXT_100(0) , \2:I_REXT_100(2)  );
capacitor #(.c(8.049e-18)) (*
integer library_binding = "analogLib";

 *)
c8 ( \I_REXT_100(0) , \4:NEG_DETECT_2p5  );
capacitor #(.c(5.892e-18)) (*
integer library_binding = "analogLib";

 *)
c9 ( \I_REXT_100(0) , NEG_DETECT_2p5 );
capacitor #(.c(2.56e-18)) (*
integer library_binding = "analogLib";

 *)
c10 ( \I_REXT_100(0) , POS_DETECT_2p5 );
capacitor #(.c(1.584e-15)) (*
integer library_binding = "analogLib";

 *)
c11 ( \I_REXT_100(0) , GND );
capacitor #(.c(1.741e-17)) (*
integer library_binding = "analogLib";

 *)
c12 ( \I_REXT_100(0) , \2:I_REXT_50(1)  );
capacitor #(.c(4.634e-16)) (*
integer library_binding = "analogLib";

 *)
c13 ( \2:I_REXT_100(0) , \4:GND  );
capacitor #(.c(3.823e-18)) (*
integer library_binding = "analogLib";

 *)
c14 ( \2:I_REXT_100(0) , SLICER_OUT_2p5 );
capacitor #(.c(3.796e-18)) (*
integer library_binding = "analogLib";

 *)
c15 ( \2:I_REXT_100(0) , \5:POS_DETECT_2p5  );
capacitor #(.c(4.491e-16)) (*
integer library_binding = "analogLib";

 *)
c16 ( \2:I_REXT_100(0) , \3:I_REXT_100(1)  );
capacitor #(.c(4.171e-18)) (*
integer library_binding = "analogLib";

 *)
c17 ( \2:I_REXT_100(0) , \I_REXT_100(2)  );
capacitor #(.c(1.187e-18)) (*
integer library_binding = "analogLib";

 *)
c18 ( \2:I_REXT_100(0) , \2:I_REXT_100(2)  );
capacitor #(.c(2.208e-18)) (*
integer library_binding = "analogLib";

 *)
c19 ( \2:I_REXT_100(0) , \4:NEG_DETECT_2p5  );
capacitor #(.c(1.616e-18)) (*
integer library_binding = "analogLib";

 *)
c20 ( \2:I_REXT_100(0) , NEG_DETECT_2p5 );
capacitor #(.c(7.02e-19)) (*
integer library_binding = "analogLib";

 *)
c21 ( \2:I_REXT_100(0) , POS_DETECT_2p5 );
capacitor #(.c(1.785e-17)) (*
integer library_binding = "analogLib";

 *)
c22 ( \2:I_REXT_100(0) , \2:I_REXT_50(1)  );
capacitor #(.c(3.778e-17)) (*
integer library_binding = "analogLib";

 *)
c23 ( \2:I_REXT_100(0) , \25:GND  );
capacitor #(.c(1.573e-14)) (*
integer library_binding = "analogLib";

 *)
c24 ( \2:I_REXT_100(0) , \2:I_REXT_100(1)  );
capacitor #(.c(7.155e-15)) (*
integer library_binding = "analogLib";

 *)
c25 ( \2:I_REXT_100(0) , GND );
capacitor #(.c(3.381e-16)) (*
integer library_binding = "analogLib";

 *)
c26 ( \4:I_REXT_100(0) , \4:GND  );
capacitor #(.c(1.047e-17)) (*
integer library_binding = "analogLib";

 *)
c27 ( \4:I_REXT_100(0) , \12:I_RPOLY_REF100  );
capacitor #(.c(5.542e-18)) (*
integer library_binding = "analogLib";

 *)
c28 ( \4:I_REXT_100(0) , \6:I_REXT_100_NC  );
capacitor #(.c(1.551e-17)) (*
integer library_binding = "analogLib";

 *)
c29 ( \4:I_REXT_100(0) , \8:I_REXT_REF100  );
capacitor #(.c(1.602e-17)) (*
integer library_binding = "analogLib";

 *)
c30 ( \4:I_REXT_100(0) , \7:I_REXT_50(0)  );
capacitor #(.c(1.736e-16)) (*
integer library_binding = "analogLib";

 *)
c31 ( \4:I_REXT_100(0) , \5:GNDRX  );
capacitor #(.c(1.736e-16)) (*
integer library_binding = "analogLib";

 *)
c32 ( \4:I_REXT_100(0) , \5:GND  );
capacitor #(.c(1.105e-17)) (*
integer library_binding = "analogLib";

 *)
c33 ( \4:I_REXT_100(0) , \I_REXT_50(1)  );
capacitor #(.c(1.547e-17)) (*
integer library_binding = "analogLib";

 *)
c34 ( \4:I_REXT_100(0) , \ADC_1p0(5)  );
capacitor #(.c(1.837e-17)) (*
integer library_binding = "analogLib";

 *)
c35 ( \4:I_REXT_100(0) , \25:GND  );
capacitor #(.c(5.955e-16)) (*
integer library_binding = "analogLib";

 *)
c36 ( \4:I_REXT_100(0) , \10:I_REXT_100_NC  );
capacitor #(.c(1.834e-17)) (*
integer library_binding = "analogLib";

 *)
c37 ( \4:I_REXT_100(0) , \3:ADC_1p0(4)  );
capacitor #(.c(1.097e-17)) (*
integer library_binding = "analogLib";

 *)
c38 ( \4:I_REXT_100(0) , \4:ADC_1p0(2)  );
capacitor #(.c(6.348e-17)) (*
integer library_binding = "analogLib";

 *)
c39 ( \4:I_REXT_100(0) , \2:I_REXT_100(1)  );
capacitor #(.c(1.07e-17)) (*
integer library_binding = "analogLib";

 *)
c40 ( \4:I_REXT_100(0) , \FLASH_1p0(2)  );
capacitor #(.c(1.736e-16)) (*
integer library_binding = "analogLib";

 *)
c41 ( \4:I_REXT_100(0) , \10:VDD  );
capacitor #(.c(1.197e-17)) (*
integer library_binding = "analogLib";

 *)
c42 ( \4:I_REXT_100(0) , \3:ADC_1p0(3)  );
capacitor #(.c(1.63e-17)) (*
integer library_binding = "analogLib";

 *)
c43 ( \4:I_REXT_100(0) , \4:ADC_1p0(1)  );
capacitor #(.c(5.227e-15)) (*
integer library_binding = "analogLib";

 *)
c44 ( \4:I_REXT_100(0) , GND );
capacitor #(.c(1.573e-17)) (*
integer library_binding = "analogLib";

 *)
c45 ( \4:I_REXT_100(0) , \4:FLASH_1p0(0)  );
capacitor #(.c(1.736e-16)) (*
integer library_binding = "analogLib";

 *)
c46 ( \4:I_REXT_100(0) , \3:VDDRX  );
capacitor #(.c(1.573e-17)) (*
integer library_binding = "analogLib";

 *)
c47 ( \4:I_REXT_100(0) , \ADC_1p0(0)  );
capacitor #(.c(1.315e-17)) (*
integer library_binding = "analogLib";

 *)
c48 ( \4:I_REXT_100(0) , \4:RCLK125_1p0  );
capacitor #(.c(1.264e-14)) (*
integer library_binding = "analogLib";

 *)
c49 ( \4:I_REXT_100(0) , \I_REXT_100(1)  );
capacitor #(.c(2.725e-15)) (*
integer library_binding = "analogLib";

 *)
c50 ( RXC, GND );
capacitor #(.c(3.651e-16)) (*
integer library_binding = "analogLib";

 *)
c51 ( RXC, \4:GND  );
capacitor #(.c(1.768e-16)) (*
integer library_binding = "analogLib";

 *)
c52 ( \1:RXC , \4:GND  );
capacitor #(.c(2.725e-15)) (*
integer library_binding = "analogLib";

 *)
c53 ( \1:RXC , GND );
capacitor #(.c(3.293e-16)) (*
integer library_binding = "analogLib";

 *)
c54 ( \1:RXC , \4:VDD  );
capacitor #(.c(1.248e-16)) (*
integer library_binding = "analogLib";

 *)
c55 ( TP_DISC_1p0, \4:GND  );
capacitor #(.c(2.466e-18)) (*
integer library_binding = "analogLib";

 *)
c56 ( TP_DISC_1p0, \TX_AMPTRIM_1p0(1)  );
capacitor #(.c(1.993e-17)) (*
integer library_binding = "analogLib";

 *)
c57 ( TP_DISC_1p0, \4:MLT3_TDATA_1p0(0)  );
capacitor #(.c(1.906e-17)) (*
integer library_binding = "analogLib";

 *)
c58 ( TP_DISC_1p0, \TEST_MODE(2)  );
capacitor #(.c(1.853e-17)) (*
integer library_binding = "analogLib";

 *)
c59 ( TP_DISC_1p0, \4:SLICER_OUT_1p0  );
capacitor #(.c(1.678e-17)) (*
integer library_binding = "analogLib";

 *)
c60 ( TP_DISC_1p0, \4:RX10_PRESENT_1p0  );
capacitor #(.c(1.962e-17)) (*
integer library_binding = "analogLib";

 *)
c61 ( TP_DISC_1p0, \4:X_125  );
capacitor #(.c(4.846e-18)) (*
integer library_binding = "analogLib";

 *)
c62 ( TP_DISC_1p0, \7:FLASH_1p0(2)  );
capacitor #(.c(1.397e-17)) (*
integer library_binding = "analogLib";

 *)
c63 ( TP_DISC_1p0, \3:FLASH_1p0(2)  );
capacitor #(.c(2.9e-18)) (*
integer library_binding = "analogLib";

 *)
c64 ( TP_DISC_1p0, \TEST_MODE(0)  );
capacitor #(.c(2.631e-18)) (*
integer library_binding = "analogLib";

 *)
c65 ( TP_DISC_1p0, \3:POS_DETECT_1p0  );
capacitor #(.c(7.111e-19)) (*
integer library_binding = "analogLib";

 *)
c66 ( TP_DISC_1p0, SLICER_OUT_1p0 );
capacitor #(.c(4.312e-19)) (*
integer library_binding = "analogLib";

 *)
c67 ( TP_DISC_1p0, X_125 );
capacitor #(.c(4.294e-19)) (*
integer library_binding = "analogLib";

 *)
c68 ( TP_DISC_1p0, \5:RESETN  );
capacitor #(.c(8.266e-19)) (*
integer library_binding = "analogLib";

 *)
c69 ( TP_DISC_1p0, \MLT3_TDATA_1p0(0)  );
capacitor #(.c(2.781e-18)) (*
integer library_binding = "analogLib";

 *)
c70 ( TP_DISC_1p0, \3:X_160  );
capacitor #(.c(4.312e-19)) (*
integer library_binding = "analogLib";

 *)
c71 ( TP_DISC_1p0, \3:TEST_MODE(2)  );
capacitor #(.c(4.31e-19)) (*
integer library_binding = "analogLib";

 *)
c72 ( TP_DISC_1p0, RX10_PRESENT_1p0 );
capacitor #(.c(2.743e-18)) (*
integer library_binding = "analogLib";

 *)
c73 ( TP_DISC_1p0, \3:XTAL25_1p0  );
capacitor #(.c(2.852e-18)) (*
integer library_binding = "analogLib";

 *)
c74 ( TP_DISC_1p0, \MR_SQUELCH_RANGE_1p0(1)  );
capacitor #(.c(1.031e-16)) (*
integer library_binding = "analogLib";

 *)
c75 ( TP_DISC_1p0, \3:MR_SQUELCH_RANGE_1p0(0)  );
capacitor #(.c(2.646e-16)) (*
integer library_binding = "analogLib";

 *)
c76 ( TP_DISC_1p0, \MR_SQUELCH_RANGE_1p0(0)  );
capacitor #(.c(1.693e-17)) (*
integer library_binding = "analogLib";

 *)
c77 ( TP_DISC_1p0, X_160 );
capacitor #(.c(1.615e-17)) (*
integer library_binding = "analogLib";

 *)
c78 ( TP_DISC_1p0, \4:MR_SQUELCH_RANGE_1p0(1)  );
capacitor #(.c(1.834e-15)) (*
integer library_binding = "analogLib";

 *)
c79 ( TP_DISC_1p0, \3:NEG_DETECT_1p0  );
capacitor #(.c(2.021e-16)) (*
integer library_binding = "analogLib";

 *)
c80 ( TP_DISC_1p0, MR_SQUELCH_DISB_1p0 );
capacitor #(.c(1.923e-15)) (*
integer library_binding = "analogLib";

 *)
c81 ( TP_DISC_1p0, GND );
capacitor #(.c(1.852e-15)) (*
integer library_binding = "analogLib";

 *)
c82 ( TP_DISC_1p0, NEG_DETECT_1p0 );
capacitor #(.c(4.771e-16)) (*
integer library_binding = "analogLib";

 *)
c83 ( TP_DISC_1p0, \4:MR_SQUELCH_DISB_1p0  );
capacitor #(.c(1.708e-17)) (*
integer library_binding = "analogLib";

 *)
c84 ( TP_DISC_1p0, POS_DETECT_1p0 );
capacitor #(.c(1.383e-16)) (*
integer library_binding = "analogLib";

 *)
c85 ( TP_DISC_1p0, \3:TEST_MODE(1)  );
capacitor #(.c(1.483e-17)) (*
integer library_binding = "analogLib";

 *)
c86 ( TP_DISC_1p0, XTAL25_1p0 );
capacitor #(.c(5.683e-16)) (*
integer library_binding = "analogLib";

 *)
c87 ( TP_DISC_1p0, \TEST_MODE(1)  );
capacitor #(.c(1.434e-17)) (*
integer library_binding = "analogLib";

 *)
c88 ( TP_DISC_1p0, \4:TX_AMPTRIM_1p0(1)  );
capacitor #(.c(1.681e-17)) (*
integer library_binding = "analogLib";

 *)
c89 ( TP_DISC_1p0, \4:TEST_MODE(0)  );
capacitor #(.c(1.681e-17)) (*
integer library_binding = "analogLib";

 *)
c90 ( TP_DISC_1p0, \5:TXER  );
capacitor #(.c(1.979e-17)) (*
integer library_binding = "analogLib";

 *)
c91 ( TP_DISC_1p0, \2:ADC_1p0(0)  );
capacitor #(.c(1.31e-17)) (*
integer library_binding = "analogLib";

 *)
c92 ( TP_DISC_1p0, \1:RCLK125_1p0  );
capacitor #(.c(1.778e-17)) (*
integer library_binding = "analogLib";

 *)
c93 ( TP_DISC_1p0, \2:ADC_1p0(3)  );
capacitor #(.c(1.614e-17)) (*
integer library_binding = "analogLib";

 *)
c94 ( TP_DISC_1p0, \ADC_1p0(2)  );
capacitor #(.c(1.5e-17)) (*
integer library_binding = "analogLib";

 *)
c95 ( TP_DISC_1p0, \1:ADC_1p0(1)  );
capacitor #(.c(1.835e-17)) (*
integer library_binding = "analogLib";

 *)
c96 ( TP_DISC_1p0, \FLASH_1p0(0)  );
capacitor #(.c(2.022e-17)) (*
integer library_binding = "analogLib";

 *)
c97 ( TP_DISC_1p0, \2:ADC_1p0(5)  );
capacitor #(.c(1.959e-17)) (*
integer library_binding = "analogLib";

 *)
c98 ( TP_DISC_1p0, \FLASH_1p0(1)  );
capacitor #(.c(1.959e-17)) (*
integer library_binding = "analogLib";

 *)
c99 ( TP_DISC_1p0, \1:ADC_1p0(4)  );
capacitor #(.c(1.996e-17)) (*
integer library_binding = "analogLib";

 *)
c100 ( TP_DISC_1p0, \2:RESETN  );
capacitor #(.c(9.391e-17)) (*
integer library_binding = "analogLib";

 *)
c101 ( \3:TP_DISC_1p0 , \4:GND  );
capacitor #(.c(2.175e-17)) (*
integer library_binding = "analogLib";

 *)
c102 ( \3:TP_DISC_1p0 , \TX_AMPTRIM_1p0(1)  );
capacitor #(.c(2.174e-17)) (*
integer library_binding = "analogLib";

 *)
c103 ( \3:TP_DISC_1p0 , \TEST_MODE(0)  );
capacitor #(.c(2.235e-17)) (*
integer library_binding = "analogLib";

 *)
c104 ( \3:TP_DISC_1p0 , \3:POS_DETECT_1p0  );
capacitor #(.c(2.199e-17)) (*
integer library_binding = "analogLib";

 *)
c105 ( \3:TP_DISC_1p0 , SLICER_OUT_1p0 );
capacitor #(.c(2.199e-17)) (*
integer library_binding = "analogLib";

 *)
c106 ( \3:TP_DISC_1p0 , X_125 );
capacitor #(.c(2.199e-17)) (*
integer library_binding = "analogLib";

 *)
c107 ( \3:TP_DISC_1p0 , \5:RESETN  );
capacitor #(.c(2.199e-17)) (*
integer library_binding = "analogLib";

 *)
c108 ( \3:TP_DISC_1p0 , \MLT3_TDATA_1p0(0)  );
capacitor #(.c(2.237e-17)) (*
integer library_binding = "analogLib";

 *)
c109 ( \3:TP_DISC_1p0 , \3:X_160  );
capacitor #(.c(2.199e-17)) (*
integer library_binding = "analogLib";

 *)
c110 ( \3:TP_DISC_1p0 , \3:TEST_MODE(2)  );
capacitor #(.c(2.199e-17)) (*
integer library_binding = "analogLib";

 *)
c111 ( \3:TP_DISC_1p0 , RX10_PRESENT_1p0 );
capacitor #(.c(2.741e-18)) (*
integer library_binding = "analogLib";

 *)
c112 ( \3:TP_DISC_1p0 , \5:TXER  );
capacitor #(.c(3.391e-18)) (*
integer library_binding = "analogLib";

 *)
c113 ( \3:TP_DISC_1p0 , \4:TEST_MODE(0)  );
capacitor #(.c(2.593e-18)) (*
integer library_binding = "analogLib";

 *)
c114 ( \3:TP_DISC_1p0 , \4:TX_AMPTRIM_1p0(1)  );
capacitor #(.c(1.121e-16)) (*
integer library_binding = "analogLib";

 *)
c115 ( \3:TP_DISC_1p0 , \TEST_MODE(1)  );
capacitor #(.c(2.971e-18)) (*
integer library_binding = "analogLib";

 *)
c116 ( \3:TP_DISC_1p0 , XTAL25_1p0 );
capacitor #(.c(9.549e-16)) (*
integer library_binding = "analogLib";

 *)
c117 ( \3:TP_DISC_1p0 , \3:TEST_MODE(1)  );
capacitor #(.c(2.785e-18)) (*
integer library_binding = "analogLib";

 *)
c118 ( \3:TP_DISC_1p0 , POS_DETECT_1p0 );
capacitor #(.c(8.991e-17)) (*
integer library_binding = "analogLib";

 *)
c119 ( \3:TP_DISC_1p0 , \4:MR_SQUELCH_DISB_1p0  );
capacitor #(.c(3.571e-16)) (*
integer library_binding = "analogLib";

 *)
c120 ( \3:TP_DISC_1p0 , NEG_DETECT_1p0 );
capacitor #(.c(6.76e-16)) (*
integer library_binding = "analogLib";

 *)
c121 ( \3:TP_DISC_1p0 , MR_SQUELCH_DISB_1p0 );
capacitor #(.c(2.65e-15)) (*
integer library_binding = "analogLib";

 *)
c122 ( \3:TP_DISC_1p0 , \3:NEG_DETECT_1p0  );
capacitor #(.c(3.236e-18)) (*
integer library_binding = "analogLib";

 *)
c123 ( \3:TP_DISC_1p0 , \4:MR_SQUELCH_RANGE_1p0(1)  );
capacitor #(.c(2.76e-18)) (*
integer library_binding = "analogLib";

 *)
c124 ( \3:TP_DISC_1p0 , X_160 );
capacitor #(.c(4.605e-17)) (*
integer library_binding = "analogLib";

 *)
c125 ( \3:TP_DISC_1p0 , \MR_SQUELCH_RANGE_1p0(0)  );
capacitor #(.c(3.849e-16)) (*
integer library_binding = "analogLib";

 *)
c126 ( \3:TP_DISC_1p0 , \3:MR_SQUELCH_RANGE_1p0(0)  );
capacitor #(.c(2.178e-17)) (*
integer library_binding = "analogLib";

 *)
c127 ( \3:TP_DISC_1p0 , \MR_SQUELCH_RANGE_1p0(1)  );
capacitor #(.c(2.289e-17)) (*
integer library_binding = "analogLib";

 *)
c128 ( \3:TP_DISC_1p0 , \3:XTAL25_1p0  );
capacitor #(.c(1.447e-15)) (*
integer library_binding = "analogLib";

 *)
c129 ( \3:TP_DISC_1p0 , GND );
capacitor #(.c(8.343e-17)) (*
integer library_binding = "analogLib";

 *)
c130 ( SLICER_OUT_2p5, \4:GND  );
capacitor #(.c(3.888e-18)) (*
integer library_binding = "analogLib";

 *)
c131 ( SLICER_OUT_2p5, \I_RPOLY_100(0)  );
capacitor #(.c(1.156e-18)) (*
integer library_binding = "analogLib";

 *)
c132 ( SLICER_OUT_2p5, \2:I_RPOLY_100(0)  );
capacitor #(.c(6.956e-18)) (*
integer library_binding = "analogLib";

 *)
c133 ( SLICER_OUT_2p5, \4:I_RPOLY_REF100  );
capacitor #(.c(8.633e-18)) (*
integer library_binding = "analogLib";

 *)
c134 ( SLICER_OUT_2p5, \I_REXT_50(0)  );
capacitor #(.c(8.633e-18)) (*
integer library_binding = "analogLib";

 *)
c135 ( SLICER_OUT_2p5, \6:I_REXT_100_NC  );
capacitor #(.c(6.956e-18)) (*
integer library_binding = "analogLib";

 *)
c136 ( SLICER_OUT_2p5, I_REXT_REF100 );
capacitor #(.c(3.881e-18)) (*
integer library_binding = "analogLib";

 *)
c137 ( SLICER_OUT_2p5, \I_RPOLY_100(1)  );
capacitor #(.c(1.163e-18)) (*
integer library_binding = "analogLib";

 *)
c138 ( SLICER_OUT_2p5, \2:I_RPOLY_100(1)  );
capacitor #(.c(1.104e-18)) (*
integer library_binding = "analogLib";

 *)
c139 ( SLICER_OUT_2p5, \2:I_REXT_100(1)  );
capacitor #(.c(3.986e-18)) (*
integer library_binding = "analogLib";

 *)
c140 ( SLICER_OUT_2p5, \3:I_REXT_100(1)  );
capacitor #(.c(1.17e-18)) (*
integer library_binding = "analogLib";

 *)
c141 ( SLICER_OUT_2p5, \I_RPOLY_100(2)  );
capacitor #(.c(3.874e-18)) (*
integer library_binding = "analogLib";

 *)
c142 ( SLICER_OUT_2p5, \3:I_RPOLY_100(2)  );
capacitor #(.c(3.926e-18)) (*
integer library_binding = "analogLib";

 *)
c143 ( SLICER_OUT_2p5, \I_REXT_100(2)  );
capacitor #(.c(1.118e-18)) (*
integer library_binding = "analogLib";

 *)
c144 ( SLICER_OUT_2p5, \2:I_REXT_100(2)  );
capacitor #(.c(1.177e-18)) (*
integer library_binding = "analogLib";

 *)
c145 ( SLICER_OUT_2p5, \2:I_RPOLY_100(3)  );
capacitor #(.c(3.866e-18)) (*
integer library_binding = "analogLib";

 *)
c146 ( SLICER_OUT_2p5, \I_RPOLY_100(3)  );
capacitor #(.c(1.126e-18)) (*
integer library_binding = "analogLib";

 *)
c147 ( SLICER_OUT_2p5, \2:I_REXT_100(3)  );
capacitor #(.c(3.918e-18)) (*
integer library_binding = "analogLib";

 *)
c148 ( SLICER_OUT_2p5, \I_REXT_100(3)  );
capacitor #(.c(1.849e-16)) (*
integer library_binding = "analogLib";

 *)
c149 ( SLICER_OUT_2p5, POS_DETECT_2p5 );
capacitor #(.c(3.485e-20)) (*
integer library_binding = "analogLib";

 *)
c150 ( SLICER_OUT_2p5, \25:GND  );
capacitor #(.c(1.195e-18)) (*
integer library_binding = "analogLib";

 *)
c151 ( SLICER_OUT_2p5, \2:I_RPOLY_100(4)  );
capacitor #(.c(3.895e-18)) (*
integer library_binding = "analogLib";

 *)
c152 ( SLICER_OUT_2p5, \3:I_RPOLY_100(4)  );
capacitor #(.c(1.133e-18)) (*
integer library_binding = "analogLib";

 *)
c153 ( SLICER_OUT_2p5, \2:I_REXT_100(4)  );
capacitor #(.c(3.91e-18)) (*
integer library_binding = "analogLib";

 *)
c154 ( SLICER_OUT_2p5, \I_REXT_100(4)  );
capacitor #(.c(5.448e-18)) (*
integer library_binding = "analogLib";

 *)
c155 ( SLICER_OUT_2p5, \I_RPOLY_100(5)  );
capacitor #(.c(1.684e-18)) (*
integer library_binding = "analogLib";

 *)
c156 ( SLICER_OUT_2p5, \2:I_RPOLY_100(5)  );
capacitor #(.c(3.903e-18)) (*
integer library_binding = "analogLib";

 *)
c157 ( SLICER_OUT_2p5, \3:I_REXT_100(5)  );
capacitor #(.c(1.141e-18)) (*
integer library_binding = "analogLib";

 *)
c158 ( SLICER_OUT_2p5, \I_REXT_100(5)  );
capacitor #(.c(1.288e-16)) (*
integer library_binding = "analogLib";

 *)
c159 ( SLICER_OUT_2p5, \5:POS_DETECT_2p5  );
capacitor #(.c(3.895e-18)) (*
integer library_binding = "analogLib";

 *)
c160 ( SLICER_OUT_2p5, \I_REXT_100(6)  );
capacitor #(.c(1.148e-18)) (*
integer library_binding = "analogLib";

 *)
c161 ( SLICER_OUT_2p5, \2:I_REXT_100(6)  );
capacitor #(.c(1.288e-15)) (*
integer library_binding = "analogLib";

 *)
c162 ( SLICER_OUT_2p5, GND );
capacitor #(.c(1.741e-17)) (*
integer library_binding = "analogLib";

 *)
c163 ( SLICER_OUT_2p5, \2:I_REXT_50(1)  );
capacitor #(.c(7.08e-17)) (*
integer library_binding = "analogLib";

 *)
c164 ( \4:SLICER_OUT_2p5 , \4:GND  );
capacitor #(.c(5.843e-18)) (*
integer library_binding = "analogLib";

 *)
c165 ( \4:SLICER_OUT_2p5 , \I_RPOLY_100(0)  );
capacitor #(.c(1.737e-18)) (*
integer library_binding = "analogLib";

 *)
c166 ( \4:SLICER_OUT_2p5 , \2:I_RPOLY_100(0)  );
capacitor #(.c(1.045e-17)) (*
integer library_binding = "analogLib";

 *)
c167 ( \4:SLICER_OUT_2p5 , \4:I_RPOLY_REF100  );
capacitor #(.c(1.297e-17)) (*
integer library_binding = "analogLib";

 *)
c168 ( \4:SLICER_OUT_2p5 , \I_REXT_50(0)  );
capacitor #(.c(1.297e-17)) (*
integer library_binding = "analogLib";

 *)
c169 ( \4:SLICER_OUT_2p5 , \6:I_REXT_100_NC  );
capacitor #(.c(1.045e-17)) (*
integer library_binding = "analogLib";

 *)
c170 ( \4:SLICER_OUT_2p5 , I_REXT_REF100 );
capacitor #(.c(5.832e-18)) (*
integer library_binding = "analogLib";

 *)
c171 ( \4:SLICER_OUT_2p5 , \I_RPOLY_100(1)  );
capacitor #(.c(1.748e-18)) (*
integer library_binding = "analogLib";

 *)
c172 ( \4:SLICER_OUT_2p5 , \2:I_RPOLY_100(1)  );
capacitor #(.c(1.659e-18)) (*
integer library_binding = "analogLib";

 *)
c173 ( \4:SLICER_OUT_2p5 , \2:I_REXT_100(1)  );
capacitor #(.c(5.99e-18)) (*
integer library_binding = "analogLib";

 *)
c174 ( \4:SLICER_OUT_2p5 , \3:I_REXT_100(1)  );
capacitor #(.c(1.758e-18)) (*
integer library_binding = "analogLib";

 *)
c175 ( \4:SLICER_OUT_2p5 , \I_RPOLY_100(2)  );
capacitor #(.c(5.821e-18)) (*
integer library_binding = "analogLib";

 *)
c176 ( \4:SLICER_OUT_2p5 , \3:I_RPOLY_100(2)  );
capacitor #(.c(5.9e-18)) (*
integer library_binding = "analogLib";

 *)
c177 ( \4:SLICER_OUT_2p5 , \I_REXT_100(2)  );
capacitor #(.c(1.68e-18)) (*
integer library_binding = "analogLib";

 *)
c178 ( \4:SLICER_OUT_2p5 , \2:I_REXT_100(2)  );
capacitor #(.c(1.769e-18)) (*
integer library_binding = "analogLib";

 *)
c179 ( \4:SLICER_OUT_2p5 , \2:I_RPOLY_100(3)  );
capacitor #(.c(5.81e-18)) (*
integer library_binding = "analogLib";

 *)
c180 ( \4:SLICER_OUT_2p5 , \I_RPOLY_100(3)  );
capacitor #(.c(1.692e-18)) (*
integer library_binding = "analogLib";

 *)
c181 ( \4:SLICER_OUT_2p5 , \2:I_REXT_100(3)  );
capacitor #(.c(5.888e-18)) (*
integer library_binding = "analogLib";

 *)
c182 ( \4:SLICER_OUT_2p5 , \I_REXT_100(3)  );
capacitor #(.c(1.796e-18)) (*
integer library_binding = "analogLib";

 *)
c183 ( \4:SLICER_OUT_2p5 , \2:I_RPOLY_100(4)  );
capacitor #(.c(5.853e-18)) (*
integer library_binding = "analogLib";

 *)
c184 ( \4:SLICER_OUT_2p5 , \3:I_RPOLY_100(4)  );
capacitor #(.c(1.703e-18)) (*
integer library_binding = "analogLib";

 *)
c185 ( \4:SLICER_OUT_2p5 , \2:I_REXT_100(4)  );
capacitor #(.c(5.877e-18)) (*
integer library_binding = "analogLib";

 *)
c186 ( \4:SLICER_OUT_2p5 , \I_REXT_100(4)  );
capacitor #(.c(8.187e-18)) (*
integer library_binding = "analogLib";

 *)
c187 ( \4:SLICER_OUT_2p5 , \I_RPOLY_100(5)  );
capacitor #(.c(2.531e-18)) (*
integer library_binding = "analogLib";

 *)
c188 ( \4:SLICER_OUT_2p5 , \2:I_RPOLY_100(5)  );
capacitor #(.c(5.865e-18)) (*
integer library_binding = "analogLib";

 *)
c189 ( \4:SLICER_OUT_2p5 , \3:I_REXT_100(5)  );
capacitor #(.c(1.714e-18)) (*
integer library_binding = "analogLib";

 *)
c190 ( \4:SLICER_OUT_2p5 , \I_REXT_100(5)  );
capacitor #(.c(5.854e-18)) (*
integer library_binding = "analogLib";

 *)
c191 ( \4:SLICER_OUT_2p5 , \I_REXT_100(6)  );
capacitor #(.c(1.726e-18)) (*
integer library_binding = "analogLib";

 *)
c192 ( \4:SLICER_OUT_2p5 , \2:I_REXT_100(6)  );
capacitor #(.c(2.675e-16)) (*
integer library_binding = "analogLib";

 *)
c193 ( \4:SLICER_OUT_2p5 , \5:POS_DETECT_2p5  );
capacitor #(.c(7.735e-16)) (*
integer library_binding = "analogLib";

 *)
c194 ( \4:SLICER_OUT_2p5 , POS_DETECT_2p5 );
capacitor #(.c(3.433e-17)) (*
integer library_binding = "analogLib";

 *)
c195 ( \4:SLICER_OUT_2p5 , \25:GND  );
capacitor #(.c(1.103e-15)) (*
integer library_binding = "analogLib";

 *)
c196 ( \4:SLICER_OUT_2p5 , GND );
capacitor #(.c(1.071e-16)) (*
integer library_binding = "analogLib";

 *)
c197 ( \2:RESETN , \4:GND  );
capacitor #(.c(2.344e-15)) (*
integer library_binding = "analogLib";

 *)
c198 ( \2:RESETN , \4:MLT3_TDATA_1p0(0)  );
capacitor #(.c(2.539e-18)) (*
integer library_binding = "analogLib";

 *)
c199 ( \2:RESETN , \7:FLASH_1p0(1)  );
capacitor #(.c(2.823e-19)) (*
integer library_binding = "analogLib";

 *)
c200 ( \2:RESETN , \FLASH_1p0(1)  );
capacitor #(.c(2.721e-19)) (*
integer library_binding = "analogLib";

 *)
c201 ( \2:RESETN , \1:ADC_1p0(4)  );
capacitor #(.c(2.55e-18)) (*
integer library_binding = "analogLib";

 *)
c202 ( \2:RESETN , \7:ADC_1p0(4)  );
capacitor #(.c(9.2e-17)) (*
integer library_binding = "analogLib";

 *)
c203 ( \2:RESETN , \7:ADC_1p0(5)  );
capacitor #(.c(4.634e-16)) (*
integer library_binding = "analogLib";

 *)
c204 ( \2:RESETN , \TX_SLOPETRIM_1p0(1)  );
capacitor #(.c(2.62e-16)) (*
integer library_binding = "analogLib";

 *)
c205 ( \2:RESETN , SLICER_OUT_1p0 );
capacitor #(.c(3.458e-15)) (*
integer library_binding = "analogLib";

 *)
c206 ( \2:RESETN , \4:TX_SLOPETRIM_1p0(1)  );
capacitor #(.c(7.989e-16)) (*
integer library_binding = "analogLib";

 *)
c207 ( \2:RESETN , \4:SLICER_OUT_1p0  );
capacitor #(.c(1.999e-17)) (*
integer library_binding = "analogLib";

 *)
c208 ( \2:RESETN , \4:X_125  );
capacitor #(.c(2.031e-18)) (*
integer library_binding = "analogLib";

 *)
c209 ( \2:RESETN , X_125 );
capacitor #(.c(1.756e-16)) (*
integer library_binding = "analogLib";

 *)
c210 ( \2:RESETN , \7:FLASH_1p0(2)  );
capacitor #(.c(5.063e-16)) (*
integer library_binding = "analogLib";

 *)
c211 ( \2:RESETN , \3:FLASH_1p0(2)  );
capacitor #(.c(5.574e-16)) (*
integer library_binding = "analogLib";

 *)
c212 ( \2:RESETN , \MLT3_TDATA_1p0(0)  );
capacitor #(.c(1.778e-17)) (*
integer library_binding = "analogLib";

 *)
c213 ( \2:RESETN , \2:ADC_1p0(3)  );
capacitor #(.c(2.224e-17)) (*
integer library_binding = "analogLib";

 *)
c214 ( \2:RESETN , \ADC_1p0(2)  );
capacitor #(.c(2.176e-17)) (*
integer library_binding = "analogLib";

 *)
c215 ( \2:RESETN , \1:ADC_1p0(1)  );
capacitor #(.c(4.326e-17)) (*
integer library_binding = "analogLib";

 *)
c216 ( \2:RESETN , \FLASH_1p0(0)  );
capacitor #(.c(1.996e-17)) (*
integer library_binding = "analogLib";

 *)
c217 ( \2:RESETN , \4:TEST_MODE(0)  );
capacitor #(.c(1.996e-17)) (*
integer library_binding = "analogLib";

 *)
c218 ( \2:RESETN , \4:TX_AMPTRIM_1p0(1)  );
capacitor #(.c(1.996e-17)) (*
integer library_binding = "analogLib";

 *)
c219 ( \2:RESETN , \TX_AMPTRIM_1p0(0)  );
capacitor #(.c(1.996e-17)) (*
integer library_binding = "analogLib";

 *)
c220 ( \2:RESETN , \5:TXER  );
capacitor #(.c(6.198e-16)) (*
integer library_binding = "analogLib";

 *)
c221 ( \2:RESETN , \2:ADC_1p0(5)  );
capacitor #(.c(1.769e-15)) (*
integer library_binding = "analogLib";

 *)
c222 ( \2:RESETN , GND );
capacitor #(.c(1.996e-17)) (*
integer library_binding = "analogLib";

 *)
c223 ( \2:RESETN , \TEST_MODE(1)  );
capacitor #(.c(1.996e-17)) (*
integer library_binding = "analogLib";

 *)
c224 ( \2:RESETN , \TX_SLOPETRIM_1p0(0)  );
capacitor #(.c(6.601e-17)) (*
integer library_binding = "analogLib";

 *)
c225 ( RESETN, \4:GND  );
capacitor #(.c(6.129e-19)) (*
integer library_binding = "analogLib";

 *)
c226 ( RESETN, \FLASH_1p0(0)  );
capacitor #(.c(5.507e-19)) (*
integer library_binding = "analogLib";

 *)
c227 ( RESETN, \4:SLICER_OUT_1p0  );
capacitor #(.c(1.32e-16)) (*
integer library_binding = "analogLib";

 *)
c228 ( RESETN, \7:VDD  );
capacitor #(.c(2.004e-16)) (*
integer library_binding = "analogLib";

 *)
c229 ( RESETN, \4:VDD  );
capacitor #(.c(3.679e-17)) (*
integer library_binding = "analogLib";

 *)
c230 ( RESETN, \7:FLASH_1p0(2)  );
capacitor #(.c(1.061e-16)) (*
integer library_binding = "analogLib";

 *)
c231 ( RESETN, \3:FLASH_1p0(2)  );
capacitor #(.c(1.032e-15)) (*
integer library_binding = "analogLib";

 *)
c232 ( RESETN, GND );
capacitor #(.c(1.287e-16)) (*
integer library_binding = "analogLib";

 *)
c233 ( \5:RESETN , \4:GND  );
capacitor #(.c(2.539e-19)) (*
integer library_binding = "analogLib";

 *)
c234 ( \5:RESETN , \4:TX_AMPTRIM_1p0(1)  );
capacitor #(.c(2.135e-17)) (*
integer library_binding = "analogLib";

 *)
c235 ( \5:RESETN , \TX_AMPTRIM_1p0(1)  );
capacitor #(.c(2.761e-16)) (*
integer library_binding = "analogLib";

 *)
c236 ( \5:RESETN , \4:MLT3_TDATA_1p0(0)  );
capacitor #(.c(1.509e-17)) (*
integer library_binding = "analogLib";

 *)
c237 ( \5:RESETN , \7:FLASH_1p0(1)  );
capacitor #(.c(1.677e-18)) (*
integer library_binding = "analogLib";

 *)
c238 ( \5:RESETN , \FLASH_1p0(1)  );
capacitor #(.c(2.108e-17)) (*
integer library_binding = "analogLib";

 *)
c239 ( \5:RESETN , \3:TX_AMPTRIM_1p0(0)  );
capacitor #(.c(5.262e-19)) (*
integer library_binding = "analogLib";

 *)
c240 ( \5:RESETN , \TX_AMPTRIM_1p0(0)  );
capacitor #(.c(1.091e-16)) (*
integer library_binding = "analogLib";

 *)
c241 ( \5:RESETN , \2:ADC_1p0(5)  );
capacitor #(.c(1.206e-17)) (*
integer library_binding = "analogLib";

 *)
c242 ( \5:RESETN , X_125 );
capacitor #(.c(1.617e-18)) (*
integer library_binding = "analogLib";

 *)
c243 ( \5:RESETN , \1:ADC_1p0(4)  );
capacitor #(.c(1.515e-17)) (*
integer library_binding = "analogLib";

 *)
c244 ( \5:RESETN , \7:ADC_1p0(4)  );
capacitor #(.c(1.709e-15)) (*
integer library_binding = "analogLib";

 *)
c245 ( \5:RESETN , \MLT3_TDATA_1p0(0)  );
capacitor #(.c(2.18e-18)) (*
integer library_binding = "analogLib";

 *)
c246 ( \5:RESETN , \4:X_125  );
capacitor #(.c(1.191e-15)) (*
integer library_binding = "analogLib";

 *)
c247 ( \5:RESETN , \4:TX_SLOPETRIM_1p0(1)  );
capacitor #(.c(8.346e-17)) (*
integer library_binding = "analogLib";

 *)
c248 ( \5:RESETN , \4:SLICER_OUT_1p0  );
capacitor #(.c(4.981e-16)) (*
integer library_binding = "analogLib";

 *)
c249 ( \5:RESETN , SLICER_OUT_1p0 );
capacitor #(.c(2.485e-15)) (*
integer library_binding = "analogLib";

 *)
c250 ( \5:RESETN , \TX_SLOPETRIM_1p0(1)  );
capacitor #(.c(5.466e-16)) (*
integer library_binding = "analogLib";

 *)
c251 ( \5:RESETN , \7:ADC_1p0(5)  );
capacitor #(.c(2.09e-17)) (*
integer library_binding = "analogLib";

 *)
c252 ( \5:RESETN , \3:TX_SLOPETRIM_1p0(0)  );
capacitor #(.c(7.066e-19)) (*
integer library_binding = "analogLib";

 *)
c253 ( \5:RESETN , \TX_SLOPETRIM_1p0(0)  );
capacitor #(.c(6.648e-19)) (*
integer library_binding = "analogLib";

 *)
c254 ( \5:RESETN , \4:TEST_MODE(0)  );
capacitor #(.c(2.176e-17)) (*
integer library_binding = "analogLib";

 *)
c255 ( \5:RESETN , \TEST_MODE(0)  );
capacitor #(.c(1.983e-15)) (*
integer library_binding = "analogLib";

 *)
c256 ( \5:RESETN , GND );
capacitor #(.c(4.419e-19)) (*
integer library_binding = "analogLib";

 *)
c257 ( \5:RESETN , \TEST_MODE(1)  );
capacitor #(.c(2.116e-17)) (*
integer library_binding = "analogLib";

 *)
c258 ( \5:RESETN , \3:TEST_MODE(1)  );
capacitor #(.c(4.168e-18)) (*
integer library_binding = "analogLib";

 *)
c259 ( \6:RESETN , \4:GND  );
capacitor #(.c(6.423e-17)) (*
integer library_binding = "analogLib";

 *)
c260 ( \6:RESETN , GND );
capacitor #(.c(2.2e-17)) (*
integer library_binding = "analogLib";

 *)
c261 ( \6:RESETN , \2:ADC_1p0(0)  );
capacitor #(.c(1.729e-17)) (*
integer library_binding = "analogLib";

 *)
c262 ( \6:RESETN , \1:RCLK125_1p0  );
capacitor #(.c(1.768e-16)) (*
integer library_binding = "analogLib";

 *)
c263 ( \1:LEDS , \4:GND  );
capacitor #(.c(2.725e-15)) (*
integer library_binding = "analogLib";

 *)
c264 ( \1:LEDS , GND );
capacitor #(.c(3.293e-16)) (*
integer library_binding = "analogLib";

 *)
c265 ( \1:LEDS , \4:VDD  );
capacitor #(.c(2.725e-15)) (*
integer library_binding = "analogLib";

 *)
c266 ( LEDS, GND );
capacitor #(.c(3.651e-16)) (*
integer library_binding = "analogLib";

 *)
c267 ( LEDS, \4:GND  );
capacitor #(.c(6.763e-16)) (*
integer library_binding = "analogLib";

 *)
c268 ( \PHASE_IN(4) , \4:GND  );
capacitor #(.c(5.852e-19)) (*
integer library_binding = "analogLib";

 *)
c269 ( \PHASE_IN(4) , \5:TENBT_FILTER_1p0(3)  );
capacitor #(.c(9.391e-18)) (*
integer library_binding = "analogLib";

 *)
c270 ( \PHASE_IN(4) , \6:TENBT_FILTER_1p0(4)  );
capacitor #(.c(5.074e-17)) (*
integer library_binding = "analogLib";

 *)
c271 ( \PHASE_IN(4) , \4:VDD  );
capacitor #(.c(2.434e-15)) (*
integer library_binding = "analogLib";

 *)
c272 ( \PHASE_IN(4) , \9:VDD  );
capacitor #(.c(1.012e-18)) (*
integer library_binding = "analogLib";

 *)
c273 ( \PHASE_IN(4) , \TENBT_FILTER_1p0(2)  );
capacitor #(.c(9.354e-18)) (*
integer library_binding = "analogLib";

 *)
c274 ( \PHASE_IN(4) , \TENBT_FILTER_1p0(3)  );
capacitor #(.c(2.223e-18)) (*
integer library_binding = "analogLib";

 *)
c275 ( \PHASE_IN(4) , \PHASE_IN(10)  );
capacitor #(.c(4.961e-18)) (*
integer library_binding = "analogLib";

 *)
c276 ( \PHASE_IN(4) , \6:PHASE_IN(10)  );
capacitor #(.c(5.793e-19)) (*
integer library_binding = "analogLib";

 *)
c277 ( \PHASE_IN(4) , \5:TENBT_FILTER_1p0(1)  );
capacitor #(.c(9.39e-18)) (*
integer library_binding = "analogLib";

 *)
c278 ( \PHASE_IN(4) , \6:TENBT_FILTER_1p0(2)  );
capacitor #(.c(1.12e-18)) (*
integer library_binding = "analogLib";

 *)
c279 ( \PHASE_IN(4) , \TENBT_FILTER_1p0(0)  );
capacitor #(.c(9.36e-18)) (*
integer library_binding = "analogLib";

 *)
c280 ( \PHASE_IN(4) , \TENBT_FILTER_1p0(1)  );
capacitor #(.c(1.009e-18)) (*
integer library_binding = "analogLib";

 *)
c281 ( \PHASE_IN(4) , TENBT_CLK160_1p0 );
capacitor #(.c(1.269e-17)) (*
integer library_binding = "analogLib";

 *)
c282 ( \PHASE_IN(4) , \6:TENBT_FILTER_1p0(0)  );
capacitor #(.c(1.318e-18)) (*
integer library_binding = "analogLib";

 *)
c283 ( \PHASE_IN(4) , \5:RESET_10BT  );
capacitor #(.c(9.393e-18)) (*
integer library_binding = "analogLib";

 *)
c284 ( \PHASE_IN(4) , \6:TENBT_CLK160_1p0  );
capacitor #(.c(1.011e-18)) (*
integer library_binding = "analogLib";

 *)
c285 ( \PHASE_IN(4) , \TENBT_FILTER_1p0(4)  );
capacitor #(.c(1.259e-17)) (*
integer library_binding = "analogLib";

 *)
c286 ( \PHASE_IN(4) , RESET_10BT );
capacitor #(.c(1.235e-16)) (*
integer library_binding = "analogLib";

 *)
c287 ( \PHASE_IN(4) , \2:PHASE_IN(1)  );
capacitor #(.c(1.382e-15)) (*
integer library_binding = "analogLib";

 *)
c288 ( \PHASE_IN(4) , \3:XTAL25  );
capacitor #(.c(9.209e-16)) (*
integer library_binding = "analogLib";

 *)
c289 ( \PHASE_IN(4) , \4:PHASE_IN(2)  );
capacitor #(.c(1.154e-15)) (*
integer library_binding = "analogLib";

 *)
c290 ( \PHASE_IN(4) , \1:PHASE_IN(1)  );
capacitor #(.c(1.044e-14)) (*
integer library_binding = "analogLib";

 *)
c291 ( \PHASE_IN(4) , GND );
capacitor #(.c(1.333e-15)) (*
integer library_binding = "analogLib";

 *)
c292 ( \PHASE_IN(4) , \4:PHASE_IN(3)  );
capacitor #(.c(1.772e-14)) (*
integer library_binding = "analogLib";

 *)
c293 ( \PHASE_IN(4) , \2:PHASE_IN(3)  );
capacitor #(.c(9.906e-15)) (*
integer library_binding = "analogLib";

 *)
c294 ( \PHASE_IN(4) , \2:PHASE_IN(2)  );
capacitor #(.c(5.609e-16)) (*
integer library_binding = "analogLib";

 *)
c295 ( \4:PHASE_IN(4) , \4:GND  );
capacitor #(.c(6.954e-18)) (*
integer library_binding = "analogLib";

 *)
c296 ( \4:PHASE_IN(4) , \5:ADC_TEST_2p5  );
capacitor #(.c(4.189e-17)) (*
integer library_binding = "analogLib";

 *)
c297 ( \4:PHASE_IN(4) , \5:PHASE_IN(5)  );
capacitor #(.c(2.421e-18)) (*
integer library_binding = "analogLib";

 *)
c298 ( \4:PHASE_IN(4) , \5:PHASE_IN(1)  );
capacitor #(.c(2.685e-18)) (*
integer library_binding = "analogLib";

 *)
c299 ( \4:PHASE_IN(4) , \PHASE_IN(2)  );
capacitor #(.c(1.942e-16)) (*
integer library_binding = "analogLib";

 *)
c300 ( \4:PHASE_IN(4) , \7:PHASE_IN(3)  );
capacitor #(.c(2.698e-18)) (*
integer library_binding = "analogLib";

 *)
c301 ( \4:PHASE_IN(4) , \7:PHASE_IN(0)  );
capacitor #(.c(1.999e-18)) (*
integer library_binding = "analogLib";

 *)
c302 ( \4:PHASE_IN(4) , \PHASE_IN(0)  );
capacitor #(.c(1.369e-17)) (*
integer library_binding = "analogLib";

 *)
c303 ( \4:PHASE_IN(4) , \2:PHASE_IN(5)  );
capacitor #(.c(4.545e-17)) (*
integer library_binding = "analogLib";

 *)
c304 ( \4:PHASE_IN(4) , \24:VDDTX  );
capacitor #(.c(2.386e-16)) (*
integer library_binding = "analogLib";

 *)
c305 ( \4:PHASE_IN(4) , \25:VDDTX  );
capacitor #(.c(1.25e-15)) (*
integer library_binding = "analogLib";

 *)
c306 ( \4:PHASE_IN(4) , \6:XTAL25  );
capacitor #(.c(2.147e-16)) (*
integer library_binding = "analogLib";

 *)
c307 ( \4:PHASE_IN(4) , \23:GNDTX  );
capacitor #(.c(7.18e-17)) (*
integer library_binding = "analogLib";

 *)
c308 ( \4:PHASE_IN(4) , \22:GNDTX  );
capacitor #(.c(3.948e-17)) (*
integer library_binding = "analogLib";

 *)
c309 ( \4:PHASE_IN(4) , ADC_TEST_2p5 );
capacitor #(.c(1.983e-14)) (*
integer library_binding = "analogLib";

 *)
c310 ( \4:PHASE_IN(4) , \4:PHASE_IN(3)  );
capacitor #(.c(1.865e-17)) (*
integer library_binding = "analogLib";

 *)
c311 ( \4:PHASE_IN(4) , \4:PHASE_IN(10)  );
capacitor #(.c(5.664e-17)) (*
integer library_binding = "analogLib";

 *)
c312 ( \4:PHASE_IN(4) , \3:XTAL25  );
capacitor #(.c(2.003e-17)) (*
integer library_binding = "analogLib";

 *)
c313 ( \4:PHASE_IN(4) , \5:BASEFX_DIS  );
capacitor #(.c(8.686e-15)) (*
integer library_binding = "analogLib";

 *)
c314 ( \4:PHASE_IN(4) , GND );
capacitor #(.c(1.173e-15)) (*
integer library_binding = "analogLib";

 *)
c315 ( \4:PHASE_IN(4) , \2:PHASE_IN(1)  );
capacitor #(.c(1.049e-14)) (*
integer library_binding = "analogLib";

 *)
c316 ( \4:PHASE_IN(4) , \4:PHASE_IN(2)  );
capacitor #(.c(1.234e-17)) (*
integer library_binding = "analogLib";

 *)
c317 ( \4:PHASE_IN(4) , \4:PHASE_IN(9)  );
capacitor #(.c(2.316e-17)) (*
integer library_binding = "analogLib";

 *)
c318 ( \4:PHASE_IN(4) , \4:PHASE_IN(8)  );
capacitor #(.c(6.531e-17)) (*
integer library_binding = "analogLib";

 *)
c319 ( \7:PHASE_IN(4) , \4:GND  );
capacitor #(.c(8.516e-17)) (*
integer library_binding = "analogLib";

 *)
c320 ( \7:PHASE_IN(4) , \23:GNDTX  );
capacitor #(.c(3.985e-18)) (*
integer library_binding = "analogLib";

 *)
c321 ( \7:PHASE_IN(4) , \2:PHASE_IN(1)  );
capacitor #(.c(4.911e-18)) (*
integer library_binding = "analogLib";

 *)
c322 ( \7:PHASE_IN(4) , \5:PHASE_IN(1)  );
capacitor #(.c(5.446e-18)) (*
integer library_binding = "analogLib";

 *)
c323 ( \7:PHASE_IN(4) , \PHASE_IN(2)  );
capacitor #(.c(4.08e-18)) (*
integer library_binding = "analogLib";

 *)
c324 ( \7:PHASE_IN(4) , \4:PHASE_IN(2)  );
capacitor #(.c(1.894e-16)) (*
integer library_binding = "analogLib";

 *)
c325 ( \7:PHASE_IN(4) , \4:PHASE_IN(3)  );
capacitor #(.c(5.471e-18)) (*
integer library_binding = "analogLib";

 *)
c326 ( \7:PHASE_IN(4) , \7:PHASE_IN(0)  );
capacitor #(.c(4.054e-18)) (*
integer library_binding = "analogLib";

 *)
c327 ( \7:PHASE_IN(4) , \PHASE_IN(0)  );
capacitor #(.c(7.153e-17)) (*
integer library_binding = "analogLib";

 *)
c328 ( \7:PHASE_IN(4) , \25:VDDTX  );
capacitor #(.c(1.362e-17)) (*
integer library_binding = "analogLib";

 *)
c329 ( \7:PHASE_IN(4) , \24:VDDTX  );
capacitor #(.c(2.776e-17)) (*
integer library_binding = "analogLib";

 *)
c330 ( \7:PHASE_IN(4) , \2:PHASE_IN(5)  );
capacitor #(.c(1.861e-18)) (*
integer library_binding = "analogLib";

 *)
c331 ( \7:PHASE_IN(4) , \5:PHASE_IN(7)  );
capacitor #(.c(9.052e-18)) (*
integer library_binding = "analogLib";

 *)
c332 ( \7:PHASE_IN(4) , \7:PHASE_IN(7)  );
capacitor #(.c(2.433e-16)) (*
integer library_binding = "analogLib";

 *)
c333 ( \7:PHASE_IN(4) , \5:PHASE_IN(5)  );
capacitor #(.c(1.044e-15)) (*
integer library_binding = "analogLib";

 *)
c334 ( \7:PHASE_IN(4) , GND );
capacitor #(.c(5.451e-16)) (*
integer library_binding = "analogLib";

 *)
c335 ( \7:PHASE_IN(4) , \7:PHASE_IN(3)  );
capacitor #(.c(2.091e-16)) (*
integer library_binding = "analogLib";

 *)
c336 ( \6:PHASE_IN(4) , \4:GND  );
capacitor #(.c(3.016e-17)) (*
integer library_binding = "analogLib";

 *)
c337 ( \6:PHASE_IN(4) , \4:VDD  );
capacitor #(.c(1.447e-15)) (*
integer library_binding = "analogLib";

 *)
c338 ( \6:PHASE_IN(4) , \9:VDD  );
capacitor #(.c(1.858e-17)) (*
integer library_binding = "analogLib";

 *)
c339 ( \6:PHASE_IN(4) , \6:PHASE_IN(2)  );
capacitor #(.c(9.581e-19)) (*
integer library_binding = "analogLib";

 *)
c340 ( \6:PHASE_IN(4) , \2:PHASE_IN(2)  );
capacitor #(.c(5.3e-18)) (*
integer library_binding = "analogLib";

 *)
c341 ( \6:PHASE_IN(4) , \PHASE_IN(10)  );
capacitor #(.c(1.183e-17)) (*
integer library_binding = "analogLib";

 *)
c342 ( \6:PHASE_IN(4) , \6:PHASE_IN(10)  );
capacitor #(.c(8.142e-18)) (*
integer library_binding = "analogLib";

 *)
c343 ( \6:PHASE_IN(4) , \2:PHASE_IN(3)  );
capacitor #(.c(2.01e-17)) (*
integer library_binding = "analogLib";

 *)
c344 ( \6:PHASE_IN(4) , \6:PHASE_IN(0)  );
capacitor #(.c(1.51e-18)) (*
integer library_binding = "analogLib";

 *)
c345 ( \6:PHASE_IN(4) , \2:PHASE_IN(0)  );
capacitor #(.c(3.222e-15)) (*
integer library_binding = "analogLib";

 *)
c346 ( \6:PHASE_IN(4) , GND );
capacitor #(.c(2.563e-17)) (*
integer library_binding = "analogLib";

 *)
c347 ( \6:PHASE_IN(4) , \PHASE_IN(5)  );
capacitor #(.c(2.582e-16)) (*
integer library_binding = "analogLib";

 *)
c348 ( \6:PHASE_IN(4) , \PHASE_IN(3)  );
capacitor #(.c(2.428e-17)) (*
integer library_binding = "analogLib";

 *)
c349 ( \6:PHASE_IN(4) , \PHASE_IN(1)  );
capacitor #(.c(1.878e-16)) (*
integer library_binding = "analogLib";

 *)
c350 ( \5:B100_DIS , \4:GND  );
capacitor #(.c(7.869e-18)) (*
integer library_binding = "analogLib";

 *)
c351 ( \5:B100_DIS , \7:VDD  );
capacitor #(.c(1.195e-17)) (*
integer library_binding = "analogLib";

 *)
c352 ( \5:B100_DIS , \4:VDD  );
capacitor #(.c(2.817e-19)) (*
integer library_binding = "analogLib";

 *)
c353 ( \5:B100_DIS , SLICER_OUT_1p0 );
capacitor #(.c(2.735e-18)) (*
integer library_binding = "analogLib";

 *)
c354 ( \5:B100_DIS , \3:X_160  );
capacitor #(.c(1.853e-17)) (*
integer library_binding = "analogLib";

 *)
c355 ( \5:B100_DIS , \4:SLICER_OUT_1p0  );
capacitor #(.c(2.56e-18)) (*
integer library_binding = "analogLib";

 *)
c356 ( \5:B100_DIS , \3:POS_DETECT_1p0  );
capacitor #(.c(1.962e-17)) (*
integer library_binding = "analogLib";

 *)
c357 ( \5:B100_DIS , \4:X_125  );
capacitor #(.c(4.385e-18)) (*
integer library_binding = "analogLib";

 *)
c358 ( \5:B100_DIS , \7:FLASH_1p0(2)  );
capacitor #(.c(3.635e-18)) (*
integer library_binding = "analogLib";

 *)
c359 ( \5:B100_DIS , \3:TXER  );
capacitor #(.c(8.765e-19)) (*
integer library_binding = "analogLib";

 *)
c360 ( \5:B100_DIS , \1:B10_DIS  );
capacitor #(.c(1.265e-17)) (*
integer library_binding = "analogLib";

 *)
c361 ( \5:B100_DIS , \3:FLASH_1p0(2)  );
capacitor #(.c(2.68e-18)) (*
integer library_binding = "analogLib";

 *)
c362 ( \5:B100_DIS , \3:XTAL25_1p0  );
capacitor #(.c(1.969e-17)) (*
integer library_binding = "analogLib";

 *)
c363 ( \5:B100_DIS , X_160 );
capacitor #(.c(2.676e-18)) (*
integer library_binding = "analogLib";

 *)
c364 ( \5:B100_DIS , \3:NEG_DETECT_1p0  );
capacitor #(.c(1.683e-17)) (*
integer library_binding = "analogLib";

 *)
c365 ( \5:B100_DIS , NEG_DETECT_1p0 );
capacitor #(.c(1.986e-17)) (*
integer library_binding = "analogLib";

 *)
c366 ( \5:B100_DIS , POS_DETECT_1p0 );
capacitor #(.c(1.724e-17)) (*
integer library_binding = "analogLib";

 *)
c367 ( \5:B100_DIS , XTAL25_1p0 );
capacitor #(.c(2.022e-17)) (*
integer library_binding = "analogLib";

 *)
c368 ( \5:B100_DIS , \2:ADC_1p0(5)  );
capacitor #(.c(1.959e-17)) (*
integer library_binding = "analogLib";

 *)
c369 ( \5:B100_DIS , \FLASH_1p0(1)  );
capacitor #(.c(1.959e-17)) (*
integer library_binding = "analogLib";

 *)
c370 ( \5:B100_DIS , \1:ADC_1p0(4)  );
capacitor #(.c(1.832e-17)) (*
integer library_binding = "analogLib";

 *)
c371 ( \5:B100_DIS , \2:ADC_1p0(0)  );
capacitor #(.c(1.729e-17)) (*
integer library_binding = "analogLib";

 *)
c372 ( \5:B100_DIS , \1:RCLK125_1p0  );
capacitor #(.c(1.778e-17)) (*
integer library_binding = "analogLib";

 *)
c373 ( \5:B100_DIS , \2:ADC_1p0(3)  );
capacitor #(.c(2.904e-15)) (*
integer library_binding = "analogLib";

 *)
c374 ( \5:B100_DIS , GND );
capacitor #(.c(1.614e-17)) (*
integer library_binding = "analogLib";

 *)
c375 ( \5:B100_DIS , \ADC_1p0(2)  );
capacitor #(.c(1.5e-17)) (*
integer library_binding = "analogLib";

 *)
c376 ( \5:B100_DIS , \1:ADC_1p0(1)  );
capacitor #(.c(1.835e-17)) (*
integer library_binding = "analogLib";

 *)
c377 ( \5:B100_DIS , \FLASH_1p0(0)  );
capacitor #(.c(2.738e-16)) (*
integer library_binding = "analogLib";

 *)
c378 ( \1:B100_DIS , \4:GND  );
capacitor #(.c(9.877e-17)) (*
integer library_binding = "analogLib";

 *)
c379 ( \1:B100_DIS , \7:VDD  );
capacitor #(.c(1.499e-16)) (*
integer library_binding = "analogLib";

 *)
c380 ( \1:B100_DIS , \4:VDD  );
capacitor #(.c(1.1e-17)) (*
integer library_binding = "analogLib";

 *)
c381 ( \1:B100_DIS , \1:B10_DIS  );
capacitor #(.c(2.745e-18)) (*
integer library_binding = "analogLib";

 *)
c382 ( \1:B100_DIS , \5:TXER  );
capacitor #(.c(4.219e-15)) (*
integer library_binding = "analogLib";

 *)
c383 ( \1:B100_DIS , GND );
capacitor #(.c(6.157e-16)) (*
integer library_binding = "analogLib";

 *)
c384 ( \1:B100_DIS , TXER );
capacitor #(.c(3.197e-15)) (*
integer library_binding = "analogLib";

 *)
c385 ( \1:B100_DIS , \3:TXER  );
capacitor #(.c(4.896e-16)) (*
integer library_binding = "analogLib";

 *)
c386 ( B100_DIS, GND );
capacitor #(.c(1.464e-16)) (*
integer library_binding = "analogLib";

 *)
c387 ( B100_DIS, \4:GND  );
capacitor #(.c(1.379e-15)) (*
integer library_binding = "analogLib";

 *)
c388 ( B100_DIS, TXER );
capacitor #(.c(5.789e-17)) (*
integer library_binding = "analogLib";

 *)
c389 ( \4:B100_DIS , \4:GND  );
capacitor #(.c(8.921e-16)) (*
integer library_binding = "analogLib";

 *)
c390 ( \4:B100_DIS , GND );
capacitor #(.c(2.55e-16)) (*
integer library_binding = "analogLib";

 *)
c391 ( \4:B100_DIS , \4:VDD  );
capacitor #(.c(6.157e-16)) (*
integer library_binding = "analogLib";

 *)
c392 ( \4:B100_DIS , \3:TXER  );
capacitor #(.c(1.731e-15)) (*
integer library_binding = "analogLib";

 *)
c393 ( \4:B100_DIS , \4:TXER  );
capacitor #(.c(2.18e-17)) (*
integer library_binding = "analogLib";

 *)
c394 ( \BGTRIM(1) , GND );
capacitor #(.c(2.725e-15)) (*
integer library_binding = "analogLib";

 *)
c395 ( \TXD(0) , GND );
capacitor #(.c(3.651e-16)) (*
integer library_binding = "analogLib";

 *)
c396 ( \TXD(0) , \4:GND  );
capacitor #(.c(1.768e-16)) (*
integer library_binding = "analogLib";

 *)
c397 ( \1:TXD(0) , \4:GND  );
capacitor #(.c(2.725e-15)) (*
integer library_binding = "analogLib";

 *)
c398 ( \1:TXD(0) , GND );
capacitor #(.c(3.293e-16)) (*
integer library_binding = "analogLib";

 *)
c399 ( \1:TXD(0) , \4:VDD  );
capacitor #(.c(9.585e-17)) (*
integer library_binding = "analogLib";

 *)
c400 ( \PHASE_250(0) , \4:GND  );
capacitor #(.c(1.682e-18)) (*
integer library_binding = "analogLib";

 *)
c401 ( \PHASE_250(0) , \3:MR_SQUELCH_DISB_2p5  );
capacitor #(.c(6.73e-20)) (*
integer library_binding = "analogLib";

 *)
c402 ( \PHASE_250(0) , \2:TX100_DIS_2p5  );
capacitor #(.c(1.723e-17)) (*
integer library_binding = "analogLib";

 *)
c403 ( \PHASE_250(0) , \6:I_REXT_50(1)  );
capacitor #(.c(1.83e-19)) (*
integer library_binding = "analogLib";

 *)
c404 ( \PHASE_250(0) , \2:I_REXT_50(1)  );
capacitor #(.c(1.837e-18)) (*
integer library_binding = "analogLib";

 *)
c405 ( \PHASE_250(0) , \9:TX100_DIS_2p5  );
capacitor #(.c(1.709e-18)) (*
integer library_binding = "analogLib";

 *)
c406 ( \PHASE_250(0) , \5:BLW_DIS_2p5  );
capacitor #(.c(2.222e-17)) (*
integer library_binding = "analogLib";

 *)
c407 ( \PHASE_250(0) , BLW_DIS_2p5 );
capacitor #(.c(1.232e-17)) (*
integer library_binding = "analogLib";

 *)
c408 ( \PHASE_250(0) , \3:I_REXT_100_NC  );
capacitor #(.c(1.555e-16)) (*
integer library_binding = "analogLib";

 *)
c409 ( \PHASE_250(0) , I_REXT_REF100 );
capacitor #(.c(7.421e-16)) (*
integer library_binding = "analogLib";

 *)
c410 ( \PHASE_250(0) , \4:PHASE_250(3)  );
capacitor #(.c(6.876e-16)) (*
integer library_binding = "analogLib";

 *)
c411 ( \PHASE_250(0) , \PHASE_250(3)  );
capacitor #(.c(2.379e-16)) (*
integer library_binding = "analogLib";

 *)
c412 ( \PHASE_250(0) , \6:RX10_PRESENT_2p5  );
capacitor #(.c(1.056e-17)) (*
integer library_binding = "analogLib";

 *)
c413 ( \PHASE_250(0) , \3:PHASE_250(9)  );
capacitor #(.c(6.221e-18)) (*
integer library_binding = "analogLib";

 *)
c414 ( \PHASE_250(0) , \PHASE_250(5)  );
capacitor #(.c(5.972e-18)) (*
integer library_binding = "analogLib";

 *)
c415 ( \PHASE_250(0) , \4:PHASE_250(5)  );
capacitor #(.c(2.16e-17)) (*
integer library_binding = "analogLib";

 *)
c416 ( \PHASE_250(0) , \6:AEQ_DIS_2p5  );
capacitor #(.c(1.189e-18)) (*
integer library_binding = "analogLib";

 *)
c417 ( \PHASE_250(0) , AEQ_DIS_2p5 );
capacitor #(.c(3.754e-17)) (*
integer library_binding = "analogLib";

 *)
c418 ( \PHASE_250(0) , \4:MR_SQUELCH_RANGE_2p5(0)  );
capacitor #(.c(1.059e-18)) (*
integer library_binding = "analogLib";

 *)
c419 ( \PHASE_250(0) , \MR_SQUELCH_RANGE_2p5(0)  );
capacitor #(.c(1.239e-20)) (*
integer library_binding = "analogLib";

 *)
c420 ( \PHASE_250(0) , \3:SIDDQ  );
capacitor #(.c(2.351e-18)) (*
integer library_binding = "analogLib";

 *)
c421 ( \PHASE_250(0) , \5:SIDDQ  );
capacitor #(.c(5.169e-18)) (*
integer library_binding = "analogLib";

 *)
c422 ( \PHASE_250(0) , \PHASE_250(9)  );
capacitor #(.c(2.914e-17)) (*
integer library_binding = "analogLib";

 *)
c423 ( \PHASE_250(0) , \2:I_REXT_50(0)  );
capacitor #(.c(1.904e-18)) (*
integer library_binding = "analogLib";

 *)
c424 ( \PHASE_250(0) , \4:I_RPOLY_REF100  );
capacitor #(.c(8.735e-18)) (*
integer library_binding = "analogLib";

 *)
c425 ( \PHASE_250(0) , RX10_PRESENT_2p5 );
capacitor #(.c(2.432e-17)) (*
integer library_binding = "analogLib";

 *)
c426 ( \PHASE_250(0) , MR_SQUELCH_DISB_2p5 );
capacitor #(.c(1.48e-15)) (*
integer library_binding = "analogLib";

 *)
c427 ( \PHASE_250(0) , GND );
capacitor #(.c(1.266e-17)) (*
integer library_binding = "analogLib";

 *)
c428 ( \PHASE_250(0) , \3:X10_DIS_2p5  );
capacitor #(.c(7.348e-17)) (*
integer library_binding = "analogLib";

 *)
c429 ( \4:PHASE_250(0) , \4:GND  );
capacitor #(.c(5.48e-19)) (*
integer library_binding = "analogLib";

 *)
c430 ( \4:PHASE_250(0) , \2:TX100_DIS_2p5  );
capacitor #(.c(1.496e-17)) (*
integer library_binding = "analogLib";

 *)
c431 ( \4:PHASE_250(0) , \9:TX100_DIS_2p5  );
capacitor #(.c(6.16e-18)) (*
integer library_binding = "analogLib";

 *)
c432 ( \4:PHASE_250(0) , MR_SQUELCH_DISB_2p5 );
capacitor #(.c(5.109e-18)) (*
integer library_binding = "analogLib";

 *)
c433 ( \4:PHASE_250(0) , BLW_DIS_2p5 );
capacitor #(.c(6.992e-18)) (*
integer library_binding = "analogLib";

 *)
c434 ( \4:PHASE_250(0) , \3:I_REXT_100_NC  );
capacitor #(.c(1.35e-16)) (*
integer library_binding = "analogLib";

 *)
c435 ( \4:PHASE_250(0) , \6:RX10_PRESENT_2p5  );
capacitor #(.c(5.992e-18)) (*
integer library_binding = "analogLib";

 *)
c436 ( \4:PHASE_250(0) , \3:PHASE_250(9)  );
capacitor #(.c(1.226e-17)) (*
integer library_binding = "analogLib";

 *)
c437 ( \4:PHASE_250(0) , \6:AEQ_DIS_2p5  );
capacitor #(.c(6.75e-19)) (*
integer library_binding = "analogLib";

 *)
c438 ( \4:PHASE_250(0) , AEQ_DIS_2p5 );
capacitor #(.c(2.13e-17)) (*
integer library_binding = "analogLib";

 *)
c439 ( \4:PHASE_250(0) , \4:MR_SQUELCH_RANGE_2p5(0)  );
capacitor #(.c(6.012e-19)) (*
integer library_binding = "analogLib";

 *)
c440 ( \4:PHASE_250(0) , \MR_SQUELCH_RANGE_2p5(0)  );
capacitor #(.c(4.957e-18)) (*
integer library_binding = "analogLib";

 *)
c441 ( \4:PHASE_250(0) , RX10_PRESENT_2p5 );
capacitor #(.c(1.55e-17)) (*
integer library_binding = "analogLib";

 *)
c442 ( \4:PHASE_250(0) , \4:I_RPOLY_REF100  );
capacitor #(.c(2.977e-16)) (*
integer library_binding = "analogLib";

 *)
c443 ( \4:PHASE_250(0) , I_REXT_REF100 );
capacitor #(.c(2.373e-16)) (*
integer library_binding = "analogLib";

 *)
c444 ( \4:PHASE_250(0) , \2:I_REXT_50(0)  );
capacitor #(.c(1.766e-17)) (*
integer library_binding = "analogLib";

 *)
c445 ( \4:PHASE_250(0) , \PHASE_250(9)  );
capacitor #(.c(1.473e-15)) (*
integer library_binding = "analogLib";

 *)
c446 ( \4:PHASE_250(0) , \4:PHASE_250(3)  );
capacitor #(.c(5.408e-16)) (*
integer library_binding = "analogLib";

 *)
c447 ( \4:PHASE_250(0) , \PHASE_250(3)  );
capacitor #(.c(2.412e-17)) (*
integer library_binding = "analogLib";

 *)
c448 ( \4:PHASE_250(0) , \4:PHASE_250(5)  );
capacitor #(.c(1.914e-17)) (*
integer library_binding = "analogLib";

 *)
c449 ( \4:PHASE_250(0) , \5:SIDDQ  );
capacitor #(.c(1.009e-19)) (*
integer library_binding = "analogLib";

 *)
c450 ( \4:PHASE_250(0) , \3:SIDDQ  );
capacitor #(.c(7.375e-18)) (*
integer library_binding = "analogLib";

 *)
c451 ( \4:PHASE_250(0) , \PHASE_250(5)  );
capacitor #(.c(8.962e-20)) (*
integer library_binding = "analogLib";

 *)
c452 ( \4:PHASE_250(0) , \3:XTAL25  );
capacitor #(.c(2.152e-17)) (*
integer library_binding = "analogLib";

 *)
c453 ( \4:PHASE_250(0) , \6:XTAL25  );
capacitor #(.c(1.134e-15)) (*
integer library_binding = "analogLib";

 *)
c454 ( \4:PHASE_250(0) , GND );
capacitor #(.c(1.163e-16)) (*
integer library_binding = "analogLib";

 *)
c455 ( \I_REXT_100(1) , \4:GND  );
capacitor #(.c(1.343e-19)) (*
integer library_binding = "analogLib";

 *)
c456 ( \I_REXT_100(1) , \6:I_REXT_100_NC  );
capacitor #(.c(1.002e-17)) (*
integer library_binding = "analogLib";

 *)
c457 ( \I_REXT_100(1) , \10:I_REXT_100_NC  );
capacitor #(.c(1.225e-17)) (*
integer library_binding = "analogLib";

 *)
c458 ( \I_REXT_100(1) , \8:I_REXT_REF100  );
capacitor #(.c(1.276e-17)) (*
integer library_binding = "analogLib";

 *)
c459 ( \I_REXT_100(1) , \7:I_REXT_50(0)  );
capacitor #(.c(1.22e-17)) (*
integer library_binding = "analogLib";

 *)
c460 ( \I_REXT_100(1) , \ADC_1p0(5)  );
capacitor #(.c(1.508e-17)) (*
integer library_binding = "analogLib";

 *)
c461 ( \I_REXT_100(1) , \3:ADC_1p0(4)  );
capacitor #(.c(1.996e-17)) (*
integer library_binding = "analogLib";

 *)
c462 ( \I_REXT_100(1) , \25:GND  );
capacitor #(.c(6.421e-17)) (*
integer library_binding = "analogLib";

 *)
c463 ( \I_REXT_100(1) , \2:I_REXT_100(2)  );
capacitor #(.c(9.746e-17)) (*
integer library_binding = "analogLib";

 *)
c464 ( \I_REXT_100(1) , \10:VDD  );
capacitor #(.c(1.303e-17)) (*
integer library_binding = "analogLib";

 *)
c465 ( \I_REXT_100(1) , \4:ADC_1p0(1)  );
capacitor #(.c(1.246e-17)) (*
integer library_binding = "analogLib";

 *)
c466 ( \I_REXT_100(1) , \4:FLASH_1p0(0)  );
capacitor #(.c(9.746e-17)) (*
integer library_binding = "analogLib";

 *)
c467 ( \I_REXT_100(1) , \3:VDDRX  );
capacitor #(.c(1.246e-17)) (*
integer library_binding = "analogLib";

 *)
c468 ( \I_REXT_100(1) , \ADC_1p0(0)  );
capacitor #(.c(1.854e-15)) (*
integer library_binding = "analogLib";

 *)
c469 ( \I_REXT_100(1) , GND );
capacitor #(.c(1.278e-14)) (*
integer library_binding = "analogLib";

 *)
c470 ( \I_REXT_100(1) , \4:I_REXT_100(2)  );
capacitor #(.c(9.746e-17)) (*
integer library_binding = "analogLib";

 *)
c471 ( \I_REXT_100(1) , \5:GNDRX  );
capacitor #(.c(9.746e-17)) (*
integer library_binding = "analogLib";

 *)
c472 ( \I_REXT_100(1) , \5:GND  );
capacitor #(.c(1.457e-16)) (*
integer library_binding = "analogLib";

 *)
c473 ( \2:I_REXT_100(1) , \4:GND  );
capacitor #(.c(1.627e-18)) (*
integer library_binding = "analogLib";

 *)
c474 ( \2:I_REXT_100(1) , POS_DETECT_2p5 );
capacitor #(.c(1.136e-18)) (*
integer library_binding = "analogLib";

 *)
c475 ( \2:I_REXT_100(1) , \5:POS_DETECT_2p5  );
capacitor #(.c(1.168e-18)) (*
integer library_binding = "analogLib";

 *)
c476 ( \2:I_REXT_100(1) , NEG_DETECT_2p5 );
capacitor #(.c(1.595e-18)) (*
integer library_binding = "analogLib";

 *)
c477 ( \2:I_REXT_100(1) , \4:NEG_DETECT_2p5  );
capacitor #(.c(4.843e-16)) (*
integer library_binding = "analogLib";

 *)
c478 ( \2:I_REXT_100(1) , \I_REXT_100(2)  );
capacitor #(.c(2.522e-17)) (*
integer library_binding = "analogLib";

 *)
c479 ( \2:I_REXT_100(1) , \25:GND  );
capacitor #(.c(1.274e-17)) (*
integer library_binding = "analogLib";

 *)
c480 ( \2:I_REXT_100(1) , \2:I_REXT_50(1)  );
capacitor #(.c(2.256e-15)) (*
integer library_binding = "analogLib";

 *)
c481 ( \2:I_REXT_100(1) , GND );
capacitor #(.c(1.6e-14)) (*
integer library_binding = "analogLib";

 *)
c482 ( \2:I_REXT_100(1) , \2:I_REXT_100(2)  );
capacitor #(.c(4.833e-17)) (*
integer library_binding = "analogLib";

 *)
c483 ( \3:I_REXT_100(1) , \4:GND  );
capacitor #(.c(5.873e-18)) (*
integer library_binding = "analogLib";

 *)
c484 ( \3:I_REXT_100(1) , POS_DETECT_2p5 );
capacitor #(.c(4.103e-18)) (*
integer library_binding = "analogLib";

 *)
c485 ( \3:I_REXT_100(1) , \5:POS_DETECT_2p5  );
capacitor #(.c(4.216e-18)) (*
integer library_binding = "analogLib";

 *)
c486 ( \3:I_REXT_100(1) , NEG_DETECT_2p5 );
capacitor #(.c(5.759e-18)) (*
integer library_binding = "analogLib";

 *)
c487 ( \3:I_REXT_100(1) , \4:NEG_DETECT_2p5  );
capacitor #(.c(5.364e-16)) (*
integer library_binding = "analogLib";

 *)
c488 ( \3:I_REXT_100(1) , \2:I_REXT_100(2)  );
capacitor #(.c(7.521e-16)) (*
integer library_binding = "analogLib";

 *)
c489 ( \3:I_REXT_100(1) , GND );
capacitor #(.c(1.983e-15)) (*
integer library_binding = "analogLib";

 *)
c490 ( \3:I_REXT_100(1) , \I_REXT_100(2)  );
capacitor #(.c(1.535e-17)) (*
integer library_binding = "analogLib";

 *)
c491 ( \3:I_REXT_100(1) , \2:I_REXT_50(1)  );
capacitor #(.c(2.052e-16)) (*
integer library_binding = "analogLib";

 *)
c492 ( \ADC_1p0(1) , \4:GND  );
capacitor #(.c(1.432e-16)) (*
integer library_binding = "analogLib";

 *)
c493 ( \ADC_1p0(1) , \7:ADC_1p0(3)  );
capacitor #(.c(1.829e-17)) (*
integer library_binding = "analogLib";

 *)
c494 ( \ADC_1p0(1) , \2:ADC_1p0(3)  );
capacitor #(.c(1.738e-17)) (*
integer library_binding = "analogLib";

 *)
c495 ( \ADC_1p0(1) , \7:FLASH_1p0(1)  );
capacitor #(.c(1.932e-18)) (*
integer library_binding = "analogLib";

 *)
c496 ( \ADC_1p0(1) , \FLASH_1p0(1)  );
capacitor #(.c(1.13e-17)) (*
integer library_binding = "analogLib";

 *)
c497 ( \ADC_1p0(1) , RX10_PRESENT_1p0 );
capacitor #(.c(2.115e-18)) (*
integer library_binding = "analogLib";

 *)
c498 ( \ADC_1p0(1) , \4:RX10_PRESENT_1p0  );
capacitor #(.c(1.603e-17)) (*
integer library_binding = "analogLib";

 *)
c499 ( \ADC_1p0(1) , \7:RCLK125_1p0  );
capacitor #(.c(2.024e-18)) (*
integer library_binding = "analogLib";

 *)
c500 ( \ADC_1p0(1) , \1:RCLK125_1p0  );
capacitor #(.c(1.733e-17)) (*
integer library_binding = "analogLib";

 *)
c501 ( \ADC_1p0(1) , \7:ADC_1p0(5)  );
capacitor #(.c(1.985e-18)) (*
integer library_binding = "analogLib";

 *)
c502 ( \ADC_1p0(1) , \2:ADC_1p0(5)  );
capacitor #(.c(2.144e-18)) (*
integer library_binding = "analogLib";

 *)
c503 ( \ADC_1p0(1) , \TEST_MODE(2)  );
capacitor #(.c(1.127e-17)) (*
integer library_binding = "analogLib";

 *)
c504 ( \ADC_1p0(1) , \3:TEST_MODE(2)  );
capacitor #(.c(1.589e-17)) (*
integer library_binding = "analogLib";

 *)
c505 ( \ADC_1p0(1) , \7:ADC_1p0(0)  );
capacitor #(.c(2.162e-18)) (*
integer library_binding = "analogLib";

 *)
c506 ( \ADC_1p0(1) , \2:ADC_1p0(0)  );
capacitor #(.c(3.374e-15)) (*
integer library_binding = "analogLib";

 *)
c507 ( \ADC_1p0(1) , \7:FLASH_1p0(0)  );
capacitor #(.c(4.296e-16)) (*
integer library_binding = "analogLib";

 *)
c508 ( \ADC_1p0(1) , \FLASH_1p0(0)  );
capacitor #(.c(2.49e-17)) (*
integer library_binding = "analogLib";

 *)
c509 ( \ADC_1p0(1) , \4:X_125  );
capacitor #(.c(7.737e-16)) (*
integer library_binding = "analogLib";

 *)
c510 ( \ADC_1p0(1) , \7:FLASH_1p0(2)  );
capacitor #(.c(7.143e-17)) (*
integer library_binding = "analogLib";

 *)
c511 ( \ADC_1p0(1) , \3:FLASH_1p0(2)  );
capacitor #(.c(1.377e-16)) (*
integer library_binding = "analogLib";

 *)
c512 ( \ADC_1p0(1) , X_125 );
capacitor #(.c(1.145e-15)) (*
integer library_binding = "analogLib";

 *)
c513 ( \ADC_1p0(1) , \ADC_1p0(2)  );
capacitor #(.c(9.314e-15)) (*
integer library_binding = "analogLib";

 *)
c514 ( \ADC_1p0(1) , \7:ADC_1p0(2)  );
capacitor #(.c(3.163e-15)) (*
integer library_binding = "analogLib";

 *)
c515 ( \ADC_1p0(1) , GND );
capacitor #(.c(1.699e-17)) (*
integer library_binding = "analogLib";

 *)
c516 ( \1:ADC_1p0(1) , \7:ADC_1p0(3)  );
capacitor #(.c(1.471e-17)) (*
integer library_binding = "analogLib";

 *)
c517 ( \1:ADC_1p0(1) , \4:MLT3_TDATA_1p0(0)  );
capacitor #(.c(2.931e-19)) (*
integer library_binding = "analogLib";

 *)
c518 ( \1:ADC_1p0(1) , \MLT3_TDATA_1p0(0)  );
capacitor #(.c(2.062e-18)) (*
integer library_binding = "analogLib";

 *)
c519 ( \1:ADC_1p0(1) , \7:FLASH_1p0(1)  );
capacitor #(.c(2.292e-19)) (*
integer library_binding = "analogLib";

 *)
c520 ( \1:ADC_1p0(1) , \FLASH_1p0(1)  );
capacitor #(.c(1.34e-18)) (*
integer library_binding = "analogLib";

 *)
c521 ( \1:ADC_1p0(1) , RX10_PRESENT_1p0 );
capacitor #(.c(2.509e-19)) (*
integer library_binding = "analogLib";

 *)
c522 ( \1:ADC_1p0(1) , \4:RX10_PRESENT_1p0  );
capacitor #(.c(1.902e-18)) (*
integer library_binding = "analogLib";

 *)
c523 ( \1:ADC_1p0(1) , \7:RCLK125_1p0  );
capacitor #(.c(2.056e-18)) (*
integer library_binding = "analogLib";

 *)
c524 ( \1:ADC_1p0(1) , \7:ADC_1p0(5)  );
capacitor #(.c(2.355e-19)) (*
integer library_binding = "analogLib";

 *)
c525 ( \1:ADC_1p0(1) , \2:ADC_1p0(5)  );
capacitor #(.c(2.544e-19)) (*
integer library_binding = "analogLib";

 *)
c526 ( \1:ADC_1p0(1) , \TEST_MODE(2)  );
capacitor #(.c(1.337e-18)) (*
integer library_binding = "analogLib";

 *)
c527 ( \1:ADC_1p0(1) , \3:TEST_MODE(2)  );
capacitor #(.c(1.886e-18)) (*
integer library_binding = "analogLib";

 *)
c528 ( \1:ADC_1p0(1) , \7:ADC_1p0(0)  );
capacitor #(.c(2.051e-19)) (*
integer library_binding = "analogLib";

 *)
c529 ( \1:ADC_1p0(1) , \TX_SLOPETRIM_1p0(1)  );
capacitor #(.c(2.247e-19)) (*
integer library_binding = "analogLib";

 *)
c530 ( \1:ADC_1p0(1) , SLICER_OUT_1p0 );
capacitor #(.c(1.48e-17)) (*
integer library_binding = "analogLib";

 *)
c531 ( \1:ADC_1p0(1) , \4:TX_SLOPETRIM_1p0(1)  );
capacitor #(.c(1.478e-17)) (*
integer library_binding = "analogLib";

 *)
c532 ( \1:ADC_1p0(1) , \4:SLICER_OUT_1p0  );
capacitor #(.c(5.774e-16)) (*
integer library_binding = "analogLib";

 *)
c533 ( \1:ADC_1p0(1) , \7:FLASH_1p0(0)  );
capacitor #(.c(2.227e-16)) (*
integer library_binding = "analogLib";

 *)
c534 ( \1:ADC_1p0(1) , \4:X_125  );
capacitor #(.c(7.846e-17)) (*
integer library_binding = "analogLib";

 *)
c535 ( \1:ADC_1p0(1) , \4:RCLK125_1p0  );
capacitor #(.c(3.662e-16)) (*
integer library_binding = "analogLib";

 *)
c536 ( \1:ADC_1p0(1) , \7:FLASH_1p0(2)  );
capacitor #(.c(6.484e-16)) (*
integer library_binding = "analogLib";

 *)
c537 ( \1:ADC_1p0(1) , \3:FLASH_1p0(2)  );
capacitor #(.c(1.418e-15)) (*
integer library_binding = "analogLib";

 *)
c538 ( \1:ADC_1p0(1) , \7:ADC_1p0(2)  );
capacitor #(.c(6.748e-17)) (*
integer library_binding = "analogLib";

 *)
c539 ( \1:ADC_1p0(1) , X_125 );
capacitor #(.c(3.877e-17)) (*
integer library_binding = "analogLib";

 *)
c540 ( \1:ADC_1p0(1) , \3:ADC_1p0(0)  );
capacitor #(.c(1.5e-17)) (*
integer library_binding = "analogLib";

 *)
c541 ( \1:ADC_1p0(1) , \MR_SQUELCH_RANGE_1p0(0)  );
capacitor #(.c(4.441e-15)) (*
integer library_binding = "analogLib";

 *)
c542 ( \1:ADC_1p0(1) , \FLASH_1p0(0)  );
capacitor #(.c(1.5e-17)) (*
integer library_binding = "analogLib";

 *)
c543 ( \1:ADC_1p0(1) , POS_DETECT_1p0 );
capacitor #(.c(1.5e-17)) (*
integer library_binding = "analogLib";

 *)
c544 ( \1:ADC_1p0(1) , X_160 );
capacitor #(.c(4.295e-16)) (*
integer library_binding = "analogLib";

 *)
c545 ( \1:ADC_1p0(1) , \4:GND  );
capacitor #(.c(1.5e-17)) (*
integer library_binding = "analogLib";

 *)
c546 ( \1:ADC_1p0(1) , \4:MR_SQUELCH_DISB_1p0  );
capacitor #(.c(4.367e-15)) (*
integer library_binding = "analogLib";

 *)
c547 ( \1:ADC_1p0(1) , \2:ADC_1p0(0)  );
capacitor #(.c(1.5e-17)) (*
integer library_binding = "analogLib";

 *)
c548 ( \1:ADC_1p0(1) , \TX_SLOPETRIM_1p0(0)  );
capacitor #(.c(1.5e-17)) (*
integer library_binding = "analogLib";

 *)
c549 ( \1:ADC_1p0(1) , NEG_DETECT_1p0 );
capacitor #(.c(3.188e-15)) (*
integer library_binding = "analogLib";

 *)
c550 ( \1:ADC_1p0(1) , GND );
capacitor #(.c(4.276e-15)) (*
integer library_binding = "analogLib";

 *)
c551 ( \1:ADC_1p0(1) , \1:RCLK125_1p0  );
capacitor #(.c(1.5e-17)) (*
integer library_binding = "analogLib";

 *)
c552 ( \1:ADC_1p0(1) , \4:TX_AMPTRIM_1p0(1)  );
capacitor #(.c(1.5e-17)) (*
integer library_binding = "analogLib";

 *)
c553 ( \1:ADC_1p0(1) , \TEST_MODE(1)  );
capacitor #(.c(6.053e-17)) (*
integer library_binding = "analogLib";

 *)
c554 ( \1:ADC_1p0(1) , \2:ADC_1p0(3)  );
capacitor #(.c(1.5e-17)) (*
integer library_binding = "analogLib";

 *)
c555 ( \1:ADC_1p0(1) , XTAL25_1p0 );
capacitor #(.c(1.5e-17)) (*
integer library_binding = "analogLib";

 *)
c556 ( \1:ADC_1p0(1) , \5:B10_DIS  );
capacitor #(.c(1.5e-17)) (*
integer library_binding = "analogLib";

 *)
c557 ( \1:ADC_1p0(1) , \TX_AMPTRIM_1p0(0)  );
capacitor #(.c(1.5e-17)) (*
integer library_binding = "analogLib";

 *)
c558 ( \1:ADC_1p0(1) , \4:TEST_MODE(0)  );
capacitor #(.c(1.5e-17)) (*
integer library_binding = "analogLib";

 *)
c559 ( \1:ADC_1p0(1) , \4:MLT3_TDATA_1p0(1)  );
capacitor #(.c(1.204e-14)) (*
integer library_binding = "analogLib";

 *)
c560 ( \1:ADC_1p0(1) , \ADC_1p0(2)  );
capacitor #(.c(1.5e-17)) (*
integer library_binding = "analogLib";

 *)
c561 ( \1:ADC_1p0(1) , \5:TXER  );
capacitor #(.c(1.5e-17)) (*
integer library_binding = "analogLib";

 *)
c562 ( \1:ADC_1p0(1) , \4:MR_SQUELCH_RANGE_1p0(1)  );
capacitor #(.c(2.096e-15)) (*
integer library_binding = "analogLib";

 *)
c563 ( \3:ADC_1p0(1) , \1:RCLK125_1p0  );
capacitor #(.c(1.939e-15)) (*
integer library_binding = "analogLib";

 *)
c564 ( \3:ADC_1p0(1) , \4:RCLK125_1p0  );
capacitor #(.c(1.063e-16)) (*
integer library_binding = "analogLib";

 *)
c565 ( \3:ADC_1p0(1) , \ADC_1p0(3)  );
capacitor #(.c(3.883e-17)) (*
integer library_binding = "analogLib";

 *)
c566 ( \3:ADC_1p0(1) , \7:VDD  );
capacitor #(.c(6.478e-15)) (*
integer library_binding = "analogLib";

 *)
c567 ( \3:ADC_1p0(1) , GND );
capacitor #(.c(1.111e-17)) (*
integer library_binding = "analogLib";

 *)
c568 ( \3:ADC_1p0(1) , \3:FLASH_1p0(1)  );
capacitor #(.c(7.003e-16)) (*
integer library_binding = "analogLib";

 *)
c569 ( \3:ADC_1p0(1) , \4:GND  );
capacitor #(.c(2.244e-17)) (*
integer library_binding = "analogLib";

 *)
c570 ( \3:ADC_1p0(1) , \3:FLASH_1p0(0)  );
capacitor #(.c(1.497e-17)) (*
integer library_binding = "analogLib";

 *)
c571 ( \3:ADC_1p0(1) , \3:ADC_1p0(5)  );
capacitor #(.c(4.317e-15)) (*
integer library_binding = "analogLib";

 *)
c572 ( \3:ADC_1p0(1) , \3:ADC_1p0(0)  );
capacitor #(.c(1.244e-17)) (*
integer library_binding = "analogLib";

 *)
c573 ( \3:ADC_1p0(1) , \3:ADC_1p0(2)  );
capacitor #(.c(9.789e-16)) (*
integer library_binding = "analogLib";

 *)
c574 ( \4:ADC_1p0(1) , \4:GND  );
capacitor #(.c(1.251e-17)) (*
integer library_binding = "analogLib";

 *)
c575 ( \4:ADC_1p0(1) , \12:I_RPOLY_REF100  );
capacitor #(.c(1.233e-18)) (*
integer library_binding = "analogLib";

 *)
c576 ( \4:ADC_1p0(1) , \4:I_RPOLY_REF100  );
capacitor #(.c(1.09e-19)) (*
integer library_binding = "analogLib";

 *)
c577 ( \4:ADC_1p0(1) , \6:FLASH_1p0(0)  );
capacitor #(.c(1.09e-19)) (*
integer library_binding = "analogLib";

 *)
c578 ( \4:ADC_1p0(1) , \6:FLASH_1p0(1)  );
capacitor #(.c(1.09e-19)) (*
integer library_binding = "analogLib";

 *)
c579 ( \4:ADC_1p0(1) , \6:FLASH_1p0(2)  );
capacitor #(.c(1.035e-19)) (*
integer library_binding = "analogLib";

 *)
c580 ( \4:ADC_1p0(1) , \6:ADC_1p0(2)  );
capacitor #(.c(1.27e-19)) (*
integer library_binding = "analogLib";

 *)
c581 ( \4:ADC_1p0(1) , \6:ADC_1p0(3)  );
capacitor #(.c(1.09e-19)) (*
integer library_binding = "analogLib";

 *)
c582 ( \4:ADC_1p0(1) , \6:ADC_1p0(4)  );
capacitor #(.c(1.09e-19)) (*
integer library_binding = "analogLib";

 *)
c583 ( \4:ADC_1p0(1) , \6:ADC_1p0(5)  );
capacitor #(.c(1.752e-18)) (*
integer library_binding = "analogLib";

 *)
c584 ( \4:ADC_1p0(1) , I_REXT_REF100 );
capacitor #(.c(1.703e-17)) (*
integer library_binding = "analogLib";

 *)
c585 ( \4:ADC_1p0(1) , \8:I_REXT_REF100  );
capacitor #(.c(6.631e-17)) (*
integer library_binding = "analogLib";

 *)
c586 ( \4:ADC_1p0(1) , RCLK125_1p0 );
capacitor #(.c(2.303e-19)) (*
integer library_binding = "analogLib";

 *)
c587 ( \4:ADC_1p0(1) , \6:I_REXT_100_NC  );
capacitor #(.c(1.718e-17)) (*
integer library_binding = "analogLib";

 *)
c588 ( \4:ADC_1p0(1) , \10:I_REXT_100_NC  );
capacitor #(.c(1.692e-17)) (*
integer library_binding = "analogLib";

 *)
c589 ( \4:ADC_1p0(1) , \7:I_REXT_50(0)  );
capacitor #(.c(2.374e-18)) (*
integer library_binding = "analogLib";

 *)
c590 ( \4:ADC_1p0(1) , \I_REXT_50(0)  );
capacitor #(.c(1.312e-17)) (*
integer library_binding = "analogLib";

 *)
c591 ( \4:ADC_1p0(1) , \I_REXT_50(1)  );
capacitor #(.c(1.191e-18)) (*
integer library_binding = "analogLib";

 *)
c592 ( \4:ADC_1p0(1) , \2:I_REXT_50(1)  );
capacitor #(.c(2.281e-16)) (*
integer library_binding = "analogLib";

 *)
c593 ( \4:ADC_1p0(1) , \2:VDDRX  );
capacitor #(.c(1.303e-17)) (*
integer library_binding = "analogLib";

 *)
c594 ( \4:ADC_1p0(1) , \4:I_REXT_100(6)  );
capacitor #(.c(1.303e-17)) (*
integer library_binding = "analogLib";

 *)
c595 ( \4:ADC_1p0(1) , \I_RPOLY_100(4)  );
capacitor #(.c(1.303e-17)) (*
integer library_binding = "analogLib";

 *)
c596 ( \4:ADC_1p0(1) , \4:I_REXT_100(5)  );
capacitor #(.c(1.303e-17)) (*
integer library_binding = "analogLib";

 *)
c597 ( \4:ADC_1p0(1) , \4:I_RPOLY_100(3)  );
capacitor #(.c(2.498e-16)) (*
integer library_binding = "analogLib";

 *)
c598 ( \4:ADC_1p0(1) , \6:GNDRX  );
capacitor #(.c(1.303e-17)) (*
integer library_binding = "analogLib";

 *)
c599 ( \4:ADC_1p0(1) , \4:I_REXT_100(4)  );
capacitor #(.c(1.303e-17)) (*
integer library_binding = "analogLib";

 *)
c600 ( \4:ADC_1p0(1) , \4:I_RPOLY_100(2)  );
capacitor #(.c(1.303e-17)) (*
integer library_binding = "analogLib";

 *)
c601 ( \4:ADC_1p0(1) , \4:I_REXT_100(3)  );
capacitor #(.c(1.702e-17)) (*
integer library_binding = "analogLib";

 *)
c602 ( \4:ADC_1p0(1) , \FLASH_1p0(2)  );
capacitor #(.c(1.303e-17)) (*
integer library_binding = "analogLib";

 *)
c603 ( \4:ADC_1p0(1) , \4:I_RPOLY_100(1)  );
capacitor #(.c(1.303e-17)) (*
integer library_binding = "analogLib";

 *)
c604 ( \4:ADC_1p0(1) , \4:I_REXT_100(2)  );
capacitor #(.c(1.303e-17)) (*
integer library_binding = "analogLib";

 *)
c605 ( \4:ADC_1p0(1) , \4:I_RPOLY_100(0)  );
capacitor #(.c(1.243e-17)) (*
integer library_binding = "analogLib";

 *)
c606 ( \4:ADC_1p0(1) , \4:FLASH_1p0(1)  );
capacitor #(.c(2.498e-16)) (*
integer library_binding = "analogLib";

 *)
c607 ( \4:ADC_1p0(1) , \3:VDDRX  );
capacitor #(.c(1.509e-14)) (*
integer library_binding = "analogLib";

 *)
c608 ( \4:ADC_1p0(1) , GND );
capacitor #(.c(2.326e-16)) (*
integer library_binding = "analogLib";

 *)
c609 ( \4:ADC_1p0(1) , \5:GNDRX  );
capacitor #(.c(2.161e-17)) (*
integer library_binding = "analogLib";

 *)
c610 ( \4:ADC_1p0(1) , \ADC_1p0(5)  );
capacitor #(.c(2.576e-17)) (*
integer library_binding = "analogLib";

 *)
c611 ( \4:ADC_1p0(1) , \4:FLASH_1p0(0)  );
capacitor #(.c(1.423e-17)) (*
integer library_binding = "analogLib";

 *)
c612 ( \4:ADC_1p0(1) , \4:ADC_1p0(2)  );
capacitor #(.c(1.899e-17)) (*
integer library_binding = "analogLib";

 *)
c613 ( \4:ADC_1p0(1) , \ADC_1p0(0)  );
capacitor #(.c(1.63e-17)) (*
integer library_binding = "analogLib";

 *)
c614 ( \4:ADC_1p0(1) , \4:I_RPOLY_100(5)  );
capacitor #(.c(8.276e-15)) (*
integer library_binding = "analogLib";

 *)
c615 ( \4:ADC_1p0(1) , \4:RCLK125_1p0  );
capacitor #(.c(1.481e-17)) (*
integer library_binding = "analogLib";

 *)
c616 ( \4:ADC_1p0(1) , \25:GND  );
capacitor #(.c(6.713e-16)) (*
integer library_binding = "analogLib";

 *)
c617 ( \6:ADC_1p0(1) , \4:GND  );
capacitor #(.c(1.945e-17)) (*
integer library_binding = "analogLib";

 *)
c618 ( \6:ADC_1p0(1) , \6:FLASH_1p0(0)  );
capacitor #(.c(1.945e-17)) (*
integer library_binding = "analogLib";

 *)
c619 ( \6:ADC_1p0(1) , \6:FLASH_1p0(1)  );
capacitor #(.c(1.945e-17)) (*
integer library_binding = "analogLib";

 *)
c620 ( \6:ADC_1p0(1) , \6:FLASH_1p0(2)  );
capacitor #(.c(1.846e-17)) (*
integer library_binding = "analogLib";

 *)
c621 ( \6:ADC_1p0(1) , \6:ADC_1p0(2)  );
capacitor #(.c(2.266e-17)) (*
integer library_binding = "analogLib";

 *)
c622 ( \6:ADC_1p0(1) , \6:ADC_1p0(3)  );
capacitor #(.c(1.945e-17)) (*
integer library_binding = "analogLib";

 *)
c623 ( \6:ADC_1p0(1) , \6:ADC_1p0(4)  );
capacitor #(.c(1.945e-17)) (*
integer library_binding = "analogLib";

 *)
c624 ( \6:ADC_1p0(1) , \6:ADC_1p0(5)  );
capacitor #(.c(5.713e-17)) (*
integer library_binding = "analogLib";

 *)
c625 ( \6:ADC_1p0(1) , \4:RCLK125_1p0  );
capacitor #(.c(8.261e-15)) (*
integer library_binding = "analogLib";

 *)
c626 ( \6:ADC_1p0(1) , RCLK125_1p0 );
capacitor #(.c(1.035e-14)) (*
integer library_binding = "analogLib";

 *)
c627 ( \6:ADC_1p0(1) , GND );
capacitor #(.c(1.109e-15)) (*
integer library_binding = "analogLib";

 *)
c628 ( \3:SIDDQ , \4:GND  );
capacitor #(.c(5.526e-20)) (*
integer library_binding = "analogLib";

 *)
c629 ( \3:SIDDQ , \PHASE_250(2)  );
capacitor #(.c(4.022e-20)) (*
integer library_binding = "analogLib";

 *)
c630 ( \3:SIDDQ , \4:PHASE_250(2)  );
capacitor #(.c(5.087e-20)) (*
integer library_binding = "analogLib";

 *)
c631 ( \3:SIDDQ , \4:PHASE_250(8)  );
capacitor #(.c(4.465e-20)) (*
integer library_binding = "analogLib";

 *)
c632 ( \3:SIDDQ , \PHASE_250(8)  );
capacitor #(.c(9.158e-17)) (*
integer library_binding = "analogLib";

 *)
c633 ( \3:SIDDQ , \MLT3_TDATA_2p5(1)  );
capacitor #(.c(1.24e-18)) (*
integer library_binding = "analogLib";

 *)
c634 ( \3:SIDDQ , \5:TENBT_FILTER_1p0(3)  );
capacitor #(.c(1.405e-17)) (*
integer library_binding = "analogLib";

 *)
c635 ( \3:SIDDQ , \TENBT_FILTER_1p0(3)  );
capacitor #(.c(1.423e-17)) (*
integer library_binding = "analogLib";

 *)
c636 ( \3:SIDDQ , \6:TENBT_FILTER_1p0(4)  );
capacitor #(.c(1.464e-17)) (*
integer library_binding = "analogLib";

 *)
c637 ( \3:SIDDQ , RESET_10BT );
capacitor #(.c(7.26e-20)) (*
integer library_binding = "analogLib";

 *)
c638 ( \3:SIDDQ , \5:WANDER_CNT(2)  );
capacitor #(.c(2.83e-18)) (*
integer library_binding = "analogLib";

 *)
c639 ( \3:SIDDQ , TP_DISC_2p5 );
capacitor #(.c(1.014e-20)) (*
integer library_binding = "analogLib";

 *)
c640 ( \3:SIDDQ , \3:PHASE_250(1)  );
capacitor #(.c(4.04e-18)) (*
integer library_binding = "analogLib";

 *)
c641 ( \3:SIDDQ , \4:VDD  );
capacitor #(.c(1.938e-16)) (*
integer library_binding = "analogLib";

 *)
c642 ( \3:SIDDQ , \9:VDD  );
capacitor #(.c(6.686e-19)) (*
integer library_binding = "analogLib";

 *)
c643 ( \3:SIDDQ , \2:TX100_DIS_2p5  );
capacitor #(.c(4.177e-20)) (*
integer library_binding = "analogLib";

 *)
c644 ( \3:SIDDQ , \4:PHASE_250(7)  );
capacitor #(.c(5.374e-20)) (*
integer library_binding = "analogLib";

 *)
c645 ( \3:SIDDQ , \PHASE_250(7)  );
capacitor #(.c(1.031e-19)) (*
integer library_binding = "analogLib";

 *)
c646 ( \3:SIDDQ , \PHASE_250(1)  );
capacitor #(.c(6.86e-20)) (*
integer library_binding = "analogLib";

 *)
c647 ( \3:SIDDQ , \AEQ_CNT_ANLG(2)  );
capacitor #(.c(2.366e-18)) (*
integer library_binding = "analogLib";

 *)
c648 ( \3:SIDDQ , \9:TX100_DIS_2p5  );
capacitor #(.c(2.384e-18)) (*
integer library_binding = "analogLib";

 *)
c649 ( \3:SIDDQ , \TENBT_FILTER_1p0(2)  );
capacitor #(.c(1.291e-17)) (*
integer library_binding = "analogLib";

 *)
c650 ( \3:SIDDQ , \6:TENBT_FILTER_1p0(2)  );
capacitor #(.c(5.711e-20)) (*
integer library_binding = "analogLib";

 *)
c651 ( \3:SIDDQ , \WANDER_CNT(0)  );
capacitor #(.c(3.824e-19)) (*
integer library_binding = "analogLib";

 *)
c652 ( \3:SIDDQ , \24:VDDTX  );
capacitor #(.c(2.008e-18)) (*
integer library_binding = "analogLib";

 *)
c653 ( \3:SIDDQ , \25:VDDTX  );
capacitor #(.c(1.848e-19)) (*
integer library_binding = "analogLib";

 *)
c654 ( \3:SIDDQ , \PHASE_250(6)  );
capacitor #(.c(1.661e-19)) (*
integer library_binding = "analogLib";

 *)
c655 ( \3:SIDDQ , \4:PHASE_250(6)  );
capacitor #(.c(1.407e-17)) (*
integer library_binding = "analogLib";

 *)
c656 ( \3:SIDDQ , \TENBT_FILTER_1p0(1)  );
capacitor #(.c(1.221e-18)) (*
integer library_binding = "analogLib";

 *)
c657 ( \3:SIDDQ , \5:TENBT_FILTER_1p0(1)  );
capacitor #(.c(7.1e-20)) (*
integer library_binding = "analogLib";

 *)
c658 ( \3:SIDDQ , \AEQ_CNT_ANLG(0)  );
capacitor #(.c(9.795e-20)) (*
integer library_binding = "analogLib";

 *)
c659 ( \3:SIDDQ , ADC_DIS_2p5 );
capacitor #(.c(7.792e-20)) (*
integer library_binding = "analogLib";

 *)
c660 ( \3:SIDDQ , \5:WANDER_CNT(6)  );
capacitor #(.c(2.862e-18)) (*
integer library_binding = "analogLib";

 *)
c661 ( \3:SIDDQ , \3:TP_DISC_2p5  );
capacitor #(.c(1.695e-18)) (*
integer library_binding = "analogLib";

 *)
c662 ( \3:SIDDQ , \TENBT_FILTER_1p0(0)  );
capacitor #(.c(1.36e-17)) (*
integer library_binding = "analogLib";

 *)
c663 ( \3:SIDDQ , \6:TENBT_FILTER_1p0(0)  );
capacitor #(.c(4.962e-20)) (*
integer library_binding = "analogLib";

 *)
c664 ( \3:SIDDQ , \5:WANDER_CNT(1)  );
capacitor #(.c(7.53e-20)) (*
integer library_binding = "analogLib";

 *)
c665 ( \3:SIDDQ , \5:AEQ_CNT_ANLG(3)  );
capacitor #(.c(5.15e-19)) (*
integer library_binding = "analogLib";

 *)
c666 ( \3:SIDDQ , RCLK125_TST );
capacitor #(.c(1.028e-20)) (*
integer library_binding = "analogLib";

 *)
c667 ( \3:SIDDQ , \PHASE_250(5)  );
capacitor #(.c(1.132e-19)) (*
integer library_binding = "analogLib";

 *)
c668 ( \3:SIDDQ , \PHASE_250(9)  );
capacitor #(.c(1.008e-19)) (*
integer library_binding = "analogLib";

 *)
c669 ( \3:SIDDQ , \6:AEQ_DIS_2p5  );
capacitor #(.c(8.791e-20)) (*
integer library_binding = "analogLib";

 *)
c670 ( \3:SIDDQ , \5:BASEFX_DIS  );
capacitor #(.c(1.172e-19)) (*
integer library_binding = "analogLib";

 *)
c671 ( \3:SIDDQ , MR_SQUELCH_DISB_2p5 );
capacitor #(.c(1.008e-19)) (*
integer library_binding = "analogLib";

 *)
c672 ( \3:SIDDQ , BLW_DIS_2p5 );
capacitor #(.c(9.741e-20)) (*
integer library_binding = "analogLib";

 *)
c673 ( \3:SIDDQ , \5:TIMING_DN_ANLG  );
capacitor #(.c(5.521e-20)) (*
integer library_binding = "analogLib";

 *)
c674 ( \3:SIDDQ , \25:GND  );
capacitor #(.c(1.149e-19)) (*
integer library_binding = "analogLib";

 *)
c675 ( \3:SIDDQ , \4:MR_SQUELCH_RANGE_2p5(0)  );
capacitor #(.c(9.422e-20)) (*
integer library_binding = "analogLib";

 *)
c676 ( \3:SIDDQ , TIMING_UP_ANLG );
capacitor #(.c(1.132e-19)) (*
integer library_binding = "analogLib";

 *)
c677 ( \3:SIDDQ , \7:X10_DIS_2p5  );
capacitor #(.c(2.504e-19)) (*
integer library_binding = "analogLib";

 *)
c678 ( \3:SIDDQ , \4:PHASE_250(5)  );
capacitor #(.c(1.079e-19)) (*
integer library_binding = "analogLib";

 *)
c679 ( \3:SIDDQ , RESET_DSP );
capacitor #(.c(8.672e-18)) (*
integer library_binding = "analogLib";

 *)
c680 ( \3:SIDDQ , \4:MLT3_TDATA_2p5(1)  );
capacitor #(.c(6.058e-20)) (*
integer library_binding = "analogLib";

 *)
c681 ( \3:SIDDQ , \5:AEQ_CNT_ANLG(4)  );
capacitor #(.c(4.393e-18)) (*
integer library_binding = "analogLib";

 *)
c682 ( \3:SIDDQ , \4:PHASE_250(10)  );
capacitor #(.c(1.273e-18)) (*
integer library_binding = "analogLib";

 *)
c683 ( \3:SIDDQ , \4:RCLK125_TST  );
capacitor #(.c(6.878e-20)) (*
integer library_binding = "analogLib";

 *)
c684 ( \3:SIDDQ , \WANDER_CNT(3)  );
capacitor #(.c(2.025e-19)) (*
integer library_binding = "analogLib";

 *)
c685 ( \3:SIDDQ , \4:PHASE_250(3)  );
capacitor #(.c(7.083e-20)) (*
integer library_binding = "analogLib";

 *)
c686 ( \3:SIDDQ , \5:WANDER_CNT(4)  );
capacitor #(.c(2.9e-20)) (*
integer library_binding = "analogLib";

 *)
c687 ( \3:SIDDQ , \PHASE_250(3)  );
capacitor #(.c(9.725e-20)) (*
integer library_binding = "analogLib";

 *)
c688 ( \3:SIDDQ , \6:RX10_PRESENT_2p5  );
capacitor #(.c(1.778e-19)) (*
integer library_binding = "analogLib";

 *)
c689 ( \3:SIDDQ , \PHASE_250(4)  );
capacitor #(.c(1.489e-19)) (*
integer library_binding = "analogLib";

 *)
c690 ( \3:SIDDQ , \4:PHASE_250(4)  );
capacitor #(.c(5.038e-20)) (*
integer library_binding = "analogLib";

 *)
c691 ( \3:SIDDQ , ADC_TEST_2p5 );
capacitor #(.c(9.857e-20)) (*
integer library_binding = "analogLib";

 *)
c692 ( \3:SIDDQ , \MR_SQUELCH_RANGE_2p5(1)  );
capacitor #(.c(6.637e-20)) (*
integer library_binding = "analogLib";

 *)
c693 ( \3:SIDDQ , \5:AEQ_CNT_ANLG(1)  );
capacitor #(.c(1.604e-18)) (*
integer library_binding = "analogLib";

 *)
c694 ( \3:SIDDQ , \PHASE_250(10)  );
capacitor #(.c(7.238e-19)) (*
integer library_binding = "analogLib";

 *)
c695 ( \3:SIDDQ , \22:GNDTX  );
capacitor #(.c(1.741e-18)) (*
integer library_binding = "analogLib";

 *)
c696 ( \3:SIDDQ , \23:GNDTX  );
capacitor #(.c(3.844e-20)) (*
integer library_binding = "analogLib";

 *)
c697 ( \3:SIDDQ , RCLK125_TST_SEL );
capacitor #(.c(6.373e-20)) (*
integer library_binding = "analogLib";

 *)
c698 ( \3:SIDDQ , \3:RCLK125_TST_SEL  );
capacitor #(.c(2.619e-18)) (*
integer library_binding = "analogLib";

 *)
c699 ( \3:SIDDQ , TENBT_CLK160_1p0 );
capacitor #(.c(1.424e-17)) (*
integer library_binding = "analogLib";

 *)
c700 ( \3:SIDDQ , \6:TENBT_CLK160_1p0  );
capacitor #(.c(2.223e-18)) (*
integer library_binding = "analogLib";

 *)
c701 ( \3:SIDDQ , \5:RESET_10BT  );
capacitor #(.c(1.592e-17)) (*
integer library_binding = "analogLib";

 *)
c702 ( \3:SIDDQ , \MLT3_TDATA_2p5(0)  );
capacitor #(.c(1.696e-16)) (*
integer library_binding = "analogLib";

 *)
c703 ( \3:SIDDQ , \3:MLT3_TDATA_2p5(0)  );
capacitor #(.c(2.626e-18)) (*
integer library_binding = "analogLib";

 *)
c704 ( \3:SIDDQ , \TENBT_FILTER_1p0(4)  );
capacitor #(.c(2.934e-15)) (*
integer library_binding = "analogLib";

 *)
c705 ( \3:SIDDQ , \3:PHASE_IN(6)  );
capacitor #(.c(1.969e-16)) (*
integer library_binding = "analogLib";

 *)
c706 ( \3:SIDDQ , \26:GND  );
capacitor #(.c(2.579e-14)) (*
integer library_binding = "analogLib";

 *)
c707 ( \3:SIDDQ , \2:PHASE_IN(0)  );
capacitor #(.c(1.741e-17)) (*
integer library_binding = "analogLib";

 *)
c708 ( \3:SIDDQ , \2:I_REXT_REF100  );
capacitor #(.c(1.709e-14)) (*
integer library_binding = "analogLib";

 *)
c709 ( \3:SIDDQ , GND );
capacitor #(.c(1.741e-17)) (*
integer library_binding = "analogLib";

 *)
c710 ( \3:SIDDQ , I_RPOLY_REF100 );
capacitor #(.c(3.517e-16)) (*
integer library_binding = "analogLib";

 *)
c711 ( \3:SIDDQ , \4:PHASE_IN(6)  );
capacitor #(.c(4.564e-15)) (*
integer library_binding = "analogLib";

 *)
c712 ( \3:SIDDQ , \PHASE_IN(0)  );
capacitor #(.c(4.533e-16)) (*
integer library_binding = "analogLib";

 *)
c713 ( \2:SIDDQ , \4:GND  );
capacitor #(.c(4.817e-18)) (*
integer library_binding = "analogLib";

 *)
c714 ( \2:SIDDQ , \1:PLL_160_IN  );
capacitor #(.c(6.985e-15)) (*
integer library_binding = "analogLib";

 *)
c715 ( \2:SIDDQ , GND );
capacitor #(.c(2.004e-17)) (*
integer library_binding = "analogLib";

 *)
c716 ( \2:SIDDQ , \2:I_REXT_REF100  );
capacitor #(.c(2.004e-17)) (*
integer library_binding = "analogLib";

 *)
c717 ( \2:SIDDQ , I_RPOLY_REF100 );
capacitor #(.c(1.446e-18)) (*
integer library_binding = "analogLib";

 *)
c718 ( \8:SIDDQ , \4:GND  );
capacitor #(.c(2.229e-17)) (*
integer library_binding = "analogLib";

 *)
c719 ( \8:SIDDQ , GND );
capacitor #(.c(4.842e-17)) (*
integer library_binding = "analogLib";

 *)
c720 ( \7:SIDDQ , \4:GND  );
capacitor #(.c(1.679e-17)) (*
integer library_binding = "analogLib";

 *)
c721 ( \7:SIDDQ , \1:PLL_160_IN  );
capacitor #(.c(7.462e-16)) (*
integer library_binding = "analogLib";

 *)
c722 ( \7:SIDDQ , GND );
capacitor #(.c(5.809e-16)) (*
integer library_binding = "analogLib";

 *)
c723 ( \5:SIDDQ , \4:GND  );
capacitor #(.c(1.049e-17)) (*
integer library_binding = "analogLib";

 *)
c724 ( \5:SIDDQ , \PHASE_250(2)  );
capacitor #(.c(7.633e-18)) (*
integer library_binding = "analogLib";

 *)
c725 ( \5:SIDDQ , \4:PHASE_250(2)  );
capacitor #(.c(1.143e-18)) (*
integer library_binding = "analogLib";

 *)
c726 ( \5:SIDDQ , \WANDER_CNT(4)  );
capacitor #(.c(9.655e-18)) (*
integer library_binding = "analogLib";

 *)
c727 ( \5:SIDDQ , \4:PHASE_250(8)  );
capacitor #(.c(8.473e-18)) (*
integer library_binding = "analogLib";

 *)
c728 ( \5:SIDDQ , \PHASE_250(8)  );
capacitor #(.c(1.109e-18)) (*
integer library_binding = "analogLib";

 *)
c729 ( \5:SIDDQ , \AEQ_CNT_ANLG(1)  );
capacitor #(.c(2.947e-16)) (*
integer library_binding = "analogLib";

 *)
c730 ( \5:SIDDQ , \MLT3_TDATA_2p5(1)  );
capacitor #(.c(1.684e-18)) (*
integer library_binding = "analogLib";

 *)
c731 ( \5:SIDDQ , \5:ADC_TEST_2p5  );
capacitor #(.c(6.792e-19)) (*
integer library_binding = "analogLib";

 *)
c732 ( \5:SIDDQ , \WANDER_CNT(2)  );
capacitor #(.c(1.378e-17)) (*
integer library_binding = "analogLib";

 *)
c733 ( \5:SIDDQ , \5:WANDER_CNT(2)  );
capacitor #(.c(1.235e-18)) (*
integer library_binding = "analogLib";

 *)
c734 ( \5:SIDDQ , \AEQ_CNT_ANLG(4)  );
capacitor #(.c(5.371e-16)) (*
integer library_binding = "analogLib";

 *)
c735 ( \5:SIDDQ , TP_DISC_2p5 );
capacitor #(.c(1.924e-18)) (*
integer library_binding = "analogLib";

 *)
c736 ( \5:SIDDQ , \3:PHASE_250(1)  );
capacitor #(.c(1.269e-16)) (*
integer library_binding = "analogLib";

 *)
c737 ( \5:SIDDQ , \2:TX100_DIS_2p5  );
capacitor #(.c(7.928e-18)) (*
integer library_binding = "analogLib";

 *)
c738 ( \5:SIDDQ , \4:PHASE_250(7)  );
capacitor #(.c(1.02e-17)) (*
integer library_binding = "analogLib";

 *)
c739 ( \5:SIDDQ , \PHASE_250(7)  );
capacitor #(.c(1.957e-17)) (*
integer library_binding = "analogLib";

 *)
c740 ( \5:SIDDQ , \PHASE_250(1)  );
capacitor #(.c(1.187e-18)) (*
integer library_binding = "analogLib";

 *)
c741 ( \5:SIDDQ , \4:AEQ_CNT_ANLG(2)  );
capacitor #(.c(1.302e-17)) (*
integer library_binding = "analogLib";

 *)
c742 ( \5:SIDDQ , \AEQ_CNT_ANLG(2)  );
capacitor #(.c(4.913e-19)) (*
integer library_binding = "analogLib";

 *)
c743 ( \5:SIDDQ , \5:ADC_DIS_2p5  );
capacitor #(.c(4.49e-16)) (*
integer library_binding = "analogLib";

 *)
c744 ( \5:SIDDQ , \9:TX100_DIS_2p5  );
capacitor #(.c(1.084e-17)) (*
integer library_binding = "analogLib";

 *)
c745 ( \5:SIDDQ , \WANDER_CNT(0)  );
capacitor #(.c(8.281e-19)) (*
integer library_binding = "analogLib";

 *)
c746 ( \5:SIDDQ , \4:WANDER_CNT(0)  );
capacitor #(.c(7.257e-17)) (*
integer library_binding = "analogLib";

 *)
c747 ( \5:SIDDQ , \24:VDDTX  );
capacitor #(.c(3.81e-16)) (*
integer library_binding = "analogLib";

 *)
c748 ( \5:SIDDQ , \25:VDDTX  );
capacitor #(.c(6.778e-19)) (*
integer library_binding = "analogLib";

 *)
c749 ( \5:SIDDQ , RX10_PRESENT_2p5 );
capacitor #(.c(3.506e-17)) (*
integer library_binding = "analogLib";

 *)
c750 ( \5:SIDDQ , \PHASE_250(6)  );
capacitor #(.c(3.153e-17)) (*
integer library_binding = "analogLib";

 *)
c751 ( \5:SIDDQ , \4:PHASE_250(6)  );
capacitor #(.c(1.347e-17)) (*
integer library_binding = "analogLib";

 *)
c752 ( \5:SIDDQ , \AEQ_CNT_ANLG(0)  );
capacitor #(.c(9.835e-19)) (*
integer library_binding = "analogLib";

 *)
c753 ( \5:SIDDQ , \4:AEQ_CNT_ANLG(0)  );
capacitor #(.c(7.253e-19)) (*
integer library_binding = "analogLib";

 *)
c754 ( \5:SIDDQ , \WANDER_CNT(1)  );
capacitor #(.c(3.292e-19)) (*
integer library_binding = "analogLib";

 *)
c755 ( \5:SIDDQ , \MR_SQUELCH_RANGE_2p5(0)  );
capacitor #(.c(1.859e-17)) (*
integer library_binding = "analogLib";

 *)
c756 ( \5:SIDDQ , ADC_DIS_2p5 );
capacitor #(.c(1.479e-17)) (*
integer library_binding = "analogLib";

 *)
c757 ( \5:SIDDQ , \5:WANDER_CNT(6)  );
capacitor #(.c(9.97e-19)) (*
integer library_binding = "analogLib";

 *)
c758 ( \5:SIDDQ , \WANDER_CNT(6)  );
capacitor #(.c(5.432e-16)) (*
integer library_binding = "analogLib";

 *)
c759 ( \5:SIDDQ , \3:TP_DISC_2p5  );
capacitor #(.c(9.417e-18)) (*
integer library_binding = "analogLib";

 *)
c760 ( \5:SIDDQ , \5:WANDER_CNT(1)  );
capacitor #(.c(1.429e-17)) (*
integer library_binding = "analogLib";

 *)
c761 ( \5:SIDDQ , \5:AEQ_CNT_ANLG(3)  );
capacitor #(.c(1.487e-18)) (*
integer library_binding = "analogLib";

 *)
c762 ( \5:SIDDQ , \AEQ_CNT_ANLG(3)  );
capacitor #(.c(9.773e-17)) (*
integer library_binding = "analogLib";

 *)
c763 ( \5:SIDDQ , RCLK125_TST );
capacitor #(.c(1.952e-18)) (*
integer library_binding = "analogLib";

 *)
c764 ( \5:SIDDQ , \PHASE_250(5)  );
capacitor #(.c(2.149e-17)) (*
integer library_binding = "analogLib";

 *)
c765 ( \5:SIDDQ , \PHASE_250(9)  );
capacitor #(.c(1.913e-17)) (*
integer library_binding = "analogLib";

 *)
c766 ( \5:SIDDQ , \6:AEQ_DIS_2p5  );
capacitor #(.c(1.668e-17)) (*
integer library_binding = "analogLib";

 *)
c767 ( \5:SIDDQ , \5:BASEFX_DIS  );
capacitor #(.c(1.368e-15)) (*
integer library_binding = "analogLib";

 *)
c768 ( \5:SIDDQ , \4:PHASE_IN(6)  );
capacitor #(.c(2.224e-17)) (*
integer library_binding = "analogLib";

 *)
c769 ( \5:SIDDQ , MR_SQUELCH_DISB_2p5 );
capacitor #(.c(1.913e-17)) (*
integer library_binding = "analogLib";

 *)
c770 ( \5:SIDDQ , BLW_DIS_2p5 );
capacitor #(.c(1.849e-17)) (*
integer library_binding = "analogLib";

 *)
c771 ( \5:SIDDQ , \5:TIMING_DN_ANLG  );
capacitor #(.c(2.181e-17)) (*
integer library_binding = "analogLib";

 *)
c772 ( \5:SIDDQ , \4:MR_SQUELCH_RANGE_2p5(0)  );
capacitor #(.c(1.788e-17)) (*
integer library_binding = "analogLib";

 *)
c773 ( \5:SIDDQ , TIMING_UP_ANLG );
capacitor #(.c(2.149e-17)) (*
integer library_binding = "analogLib";

 *)
c774 ( \5:SIDDQ , \7:X10_DIS_2p5  );
capacitor #(.c(4.753e-17)) (*
integer library_binding = "analogLib";

 *)
c775 ( \5:SIDDQ , \4:PHASE_250(5)  );
capacitor #(.c(2.261e-14)) (*
integer library_binding = "analogLib";

 *)
c776 ( \5:SIDDQ , \PHASE_IN(0)  );
capacitor #(.c(2.049e-17)) (*
integer library_binding = "analogLib";

 *)
c777 ( \5:SIDDQ , RESET_DSP );
capacitor #(.c(3.625e-16)) (*
integer library_binding = "analogLib";

 *)
c778 ( \5:SIDDQ , \4:MLT3_TDATA_2p5(1)  );
capacitor #(.c(1.15e-17)) (*
integer library_binding = "analogLib";

 *)
c779 ( \5:SIDDQ , \5:AEQ_CNT_ANLG(4)  );
capacitor #(.c(8.338e-16)) (*
integer library_binding = "analogLib";

 *)
c780 ( \5:SIDDQ , \4:PHASE_250(10)  );
capacitor #(.c(2.415e-16)) (*
integer library_binding = "analogLib";

 *)
c781 ( \5:SIDDQ , \4:RCLK125_TST  );
capacitor #(.c(5.338e-16)) (*
integer library_binding = "analogLib";

 *)
c782 ( \5:SIDDQ , \3:MLT3_TDATA_2p5(0)  );
capacitor #(.c(1.305e-17)) (*
integer library_binding = "analogLib";

 *)
c783 ( \5:SIDDQ , \WANDER_CNT(3)  );
capacitor #(.c(3.844e-17)) (*
integer library_binding = "analogLib";

 *)
c784 ( \5:SIDDQ , \4:PHASE_250(3)  );
capacitor #(.c(1.344e-17)) (*
integer library_binding = "analogLib";

 *)
c785 ( \5:SIDDQ , \5:WANDER_CNT(4)  );
capacitor #(.c(5.504e-18)) (*
integer library_binding = "analogLib";

 *)
c786 ( \5:SIDDQ , \PHASE_250(3)  );
capacitor #(.c(6.59e-16)) (*
integer library_binding = "analogLib";

 *)
c787 ( \5:SIDDQ , \MLT3_TDATA_2p5(0)  );
capacitor #(.c(1.846e-17)) (*
integer library_binding = "analogLib";

 *)
c788 ( \5:SIDDQ , \6:RX10_PRESENT_2p5  );
capacitor #(.c(1.05e-18)) (*
integer library_binding = "analogLib";

 *)
c789 ( \5:SIDDQ , \4:WANDER_CNT(3)  );
capacitor #(.c(3.374e-17)) (*
integer library_binding = "analogLib";

 *)
c790 ( \5:SIDDQ , \PHASE_250(4)  );
capacitor #(.c(2.826e-17)) (*
integer library_binding = "analogLib";

 *)
c791 ( \5:SIDDQ , \4:PHASE_250(4)  );
capacitor #(.c(9.562e-18)) (*
integer library_binding = "analogLib";

 *)
c792 ( \5:SIDDQ , ADC_TEST_2p5 );
capacitor #(.c(1.871e-17)) (*
integer library_binding = "analogLib";

 *)
c793 ( \5:SIDDQ , \MR_SQUELCH_RANGE_2p5(1)  );
capacitor #(.c(3.404e-19)) (*
integer library_binding = "analogLib";

 *)
c794 ( \5:SIDDQ , \3:MR_SQUELCH_RANGE_2p5(1)  );
capacitor #(.c(1.26e-17)) (*
integer library_binding = "analogLib";

 *)
c795 ( \5:SIDDQ , \5:AEQ_CNT_ANLG(1)  );
capacitor #(.c(3.044e-16)) (*
integer library_binding = "analogLib";

 *)
c796 ( \5:SIDDQ , \PHASE_250(10)  );
capacitor #(.c(1.374e-16)) (*
integer library_binding = "analogLib";

 *)
c797 ( \5:SIDDQ , \22:GNDTX  );
capacitor #(.c(3.305e-16)) (*
integer library_binding = "analogLib";

 *)
c798 ( \5:SIDDQ , \23:GNDTX  );
capacitor #(.c(7.295e-18)) (*
integer library_binding = "analogLib";

 *)
c799 ( \5:SIDDQ , RCLK125_TST_SEL );
capacitor #(.c(1.21e-17)) (*
integer library_binding = "analogLib";

 *)
c800 ( \5:SIDDQ , \3:RCLK125_TST_SEL  );
capacitor #(.c(9.759e-20)) (*
integer library_binding = "analogLib";

 *)
c801 ( \5:SIDDQ , \5:GND  );
capacitor #(.c(1.047e-19)) (*
integer library_binding = "analogLib";

 *)
c802 ( \5:SIDDQ , \5:GNDRX  );
capacitor #(.c(1.047e-19)) (*
integer library_binding = "analogLib";

 *)
c803 ( \5:SIDDQ , \10:VDD  );
capacitor #(.c(1.047e-19)) (*
integer library_binding = "analogLib";

 *)
c804 ( \5:SIDDQ , \3:VDDRX  );
capacitor #(.c(1.216e-17)) (*
integer library_binding = "analogLib";

 *)
c805 ( \5:SIDDQ , \6:I_REXT_100_NC  );
capacitor #(.c(5.503e-14)) (*
integer library_binding = "analogLib";

 *)
c806 ( \5:SIDDQ , \25:GND  );
capacitor #(.c(9.001e-15)) (*
integer library_binding = "analogLib";

 *)
c807 ( \5:SIDDQ , GND );
capacitor #(.c(1.586e-18)) (*
integer library_binding = "analogLib";

 *)
c808 ( \9:SIDDQ , \4:GND  );
capacitor #(.c(2.444e-17)) (*
integer library_binding = "analogLib";

 *)
c809 ( \9:SIDDQ , GND );
capacitor #(.c(4.265e-16)) (*
integer library_binding = "analogLib";

 *)
c810 ( \10:SIDDQ , \4:GND  );
capacitor #(.c(2.844e-17)) (*
integer library_binding = "analogLib";

 *)
c811 ( \10:SIDDQ , \5:GND  );
capacitor #(.c(3.052e-17)) (*
integer library_binding = "analogLib";

 *)
c812 ( \10:SIDDQ , \5:GNDRX  );
capacitor #(.c(3.052e-17)) (*
integer library_binding = "analogLib";

 *)
c813 ( \10:SIDDQ , \10:VDD  );
capacitor #(.c(3.052e-17)) (*
integer library_binding = "analogLib";

 *)
c814 ( \10:SIDDQ , \3:VDDRX  );
capacitor #(.c(6.829e-15)) (*
integer library_binding = "analogLib";

 *)
c815 ( \10:SIDDQ , GND );
capacitor #(.c(1.079e-17)) (*
integer library_binding = "analogLib";

 *)
c816 ( \10:SIDDQ , \4:I_RPOLY_100(5)  );
capacitor #(.c(5.541e-14)) (*
integer library_binding = "analogLib";

 *)
c817 ( \10:SIDDQ , \25:GND  );
capacitor #(.c(1.768e-16)) (*
integer library_binding = "analogLib";

 *)
c818 ( \1:PHY(4) , \4:GND  );
capacitor #(.c(2.725e-15)) (*
integer library_binding = "analogLib";

 *)
c819 ( \1:PHY(4) , GND );
capacitor #(.c(3.293e-16)) (*
integer library_binding = "analogLib";

 *)
c820 ( \1:PHY(4) , \4:VDD  );
capacitor #(.c(2.725e-15)) (*
integer library_binding = "analogLib";

 *)
c821 ( \PHY(4) , GND );
capacitor #(.c(3.651e-16)) (*
integer library_binding = "analogLib";

 *)
c822 ( \PHY(4) , \4:GND  );
capacitor #(.c(1.768e-16)) (*
integer library_binding = "analogLib";

 *)
c823 ( \1:TXD(2) , \4:GND  );
capacitor #(.c(2.725e-15)) (*
integer library_binding = "analogLib";

 *)
c824 ( \1:TXD(2) , GND );
capacitor #(.c(3.293e-16)) (*
integer library_binding = "analogLib";

 *)
c825 ( \1:TXD(2) , \4:VDD  );
capacitor #(.c(2.725e-15)) (*
integer library_binding = "analogLib";

 *)
c826 ( \TXD(2) , GND );
capacitor #(.c(3.651e-16)) (*
integer library_binding = "analogLib";

 *)
c827 ( \TXD(2) , \4:GND  );
capacitor #(.c(3.109e-16)) (*
integer library_binding = "analogLib";

 *)
c828 ( \FLASH_1p0(2) , \4:GND  );
capacitor #(.c(1.02e-16)) (*
integer library_binding = "analogLib";

 *)
c829 ( \FLASH_1p0(2) , \6:ADC_1p0(3)  );
capacitor #(.c(1.013e-17)) (*
integer library_binding = "analogLib";

 *)
c830 ( \FLASH_1p0(2) , \12:I_RPOLY_REF100  );
capacitor #(.c(9.988e-19)) (*
integer library_binding = "analogLib";

 *)
c831 ( \FLASH_1p0(2) , \4:I_RPOLY_REF100  );
capacitor #(.c(1.633e-19)) (*
integer library_binding = "analogLib";

 *)
c832 ( \FLASH_1p0(2) , \6:ADC_1p0(2)  );
capacitor #(.c(1.505e-19)) (*
integer library_binding = "analogLib";

 *)
c833 ( \FLASH_1p0(2) , RCLK125_1p0 );
capacitor #(.c(2.478e-16)) (*
integer library_binding = "analogLib";

 *)
c834 ( \FLASH_1p0(2) , \6:FLASH_1p0(1)  );
capacitor #(.c(1.134e-18)) (*
integer library_binding = "analogLib";

 *)
c835 ( \FLASH_1p0(2) , I_REXT_REF100 );
capacitor #(.c(1.101e-17)) (*
integer library_binding = "analogLib";

 *)
c836 ( \FLASH_1p0(2) , \8:I_REXT_REF100  );
capacitor #(.c(1.908e-17)) (*
integer library_binding = "analogLib";

 *)
c837 ( \FLASH_1p0(2) , \7:I_REXT_50(0)  );
capacitor #(.c(2.678e-18)) (*
integer library_binding = "analogLib";

 *)
c838 ( \FLASH_1p0(2) , \I_REXT_50(0)  );
capacitor #(.c(1.265e-17)) (*
integer library_binding = "analogLib";

 *)
c839 ( \FLASH_1p0(2) , \I_REXT_50(1)  );
capacitor #(.c(1.148e-18)) (*
integer library_binding = "analogLib";

 *)
c840 ( \FLASH_1p0(2) , \2:I_REXT_50(1)  );
capacitor #(.c(5.057e-16)) (*
integer library_binding = "analogLib";

 *)
c841 ( \FLASH_1p0(2) , \6:VDD  );
capacitor #(.c(3.227e-16)) (*
integer library_binding = "analogLib";

 *)
c842 ( \FLASH_1p0(2) , \6:GNDRX  );
capacitor #(.c(1.108e-14)) (*
integer library_binding = "analogLib";

 *)
c843 ( \FLASH_1p0(2) , \3:ADC_1p0(3)  );
capacitor #(.c(1.314e-16)) (*
integer library_binding = "analogLib";

 *)
c844 ( \FLASH_1p0(2) , \5:GNDRX  );
capacitor #(.c(1.07e-17)) (*
integer library_binding = "analogLib";

 *)
c845 ( \FLASH_1p0(2) , \4:I_RPOLY_100(5)  );
capacitor #(.c(1.314e-16)) (*
integer library_binding = "analogLib";

 *)
c846 ( \FLASH_1p0(2) , \2:VDDRX  );
capacitor #(.c(4.051e-17)) (*
integer library_binding = "analogLib";

 *)
c847 ( \FLASH_1p0(2) , \3:FLASH_1p0(1)  );
capacitor #(.c(4.888e-15)) (*
integer library_binding = "analogLib";

 *)
c848 ( \FLASH_1p0(2) , GND );
capacitor #(.c(2.848e-14)) (*
integer library_binding = "analogLib";

 *)
c849 ( \FLASH_1p0(2) , \4:FLASH_1p0(1)  );
capacitor #(.c(3.215e-17)) (*
integer library_binding = "analogLib";

 *)
c850 ( \FLASH_1p0(2) , \3:ADC_1p0(5)  );
capacitor #(.c(1.521e-15)) (*
integer library_binding = "analogLib";

 *)
c851 ( \FLASH_1p0(2) , \ADC_1p0(5)  );
capacitor #(.c(1.482e-17)) (*
integer library_binding = "analogLib";

 *)
c852 ( \FLASH_1p0(2) , \4:RCLK125_1p0  );
capacitor #(.c(3.227e-16)) (*
integer library_binding = "analogLib";

 *)
c853 ( \FLASH_1p0(2) , \3:VDDRX  );
capacitor #(.c(3.494e-17)) (*
integer library_binding = "analogLib";

 *)
c854 ( \FLASH_1p0(2) , \4:ADC_1p0(2)  );
capacitor #(.c(2.209e-16)) (*
integer library_binding = "analogLib";

 *)
c855 ( \6:FLASH_1p0(2) , \4:GND  );
capacitor #(.c(1.094e-14)) (*
integer library_binding = "analogLib";

 *)
c856 ( \6:FLASH_1p0(2) , \6:ADC_1p0(3)  );
capacitor #(.c(1.752e-17)) (*
integer library_binding = "analogLib";

 *)
c857 ( \6:FLASH_1p0(2) , \6:ADC_1p0(2)  );
capacitor #(.c(1.416e-19)) (*
integer library_binding = "analogLib";

 *)
c858 ( \6:FLASH_1p0(2) , \4:ADC_1p0(2)  );
capacitor #(.c(4.997e-16)) (*
integer library_binding = "analogLib";

 *)
c859 ( \6:FLASH_1p0(2) , \3:ADC_1p0(3)  );
capacitor #(.c(3.55e-16)) (*
integer library_binding = "analogLib";

 *)
c860 ( \6:FLASH_1p0(2) , \4:FLASH_1p0(1)  );
capacitor #(.c(1.117e-19)) (*
integer library_binding = "analogLib";

 *)
c861 ( \6:FLASH_1p0(2) , \4:RCLK125_1p0  );
capacitor #(.c(1.615e-17)) (*
integer library_binding = "analogLib";

 *)
c862 ( \6:FLASH_1p0(2) , RCLK125_1p0 );
capacitor #(.c(2.659e-14)) (*
integer library_binding = "analogLib";

 *)
c863 ( \6:FLASH_1p0(2) , \6:FLASH_1p0(1)  );
capacitor #(.c(3.404e-15)) (*
integer library_binding = "analogLib";

 *)
c864 ( \6:FLASH_1p0(2) , GND );
capacitor #(.c(1.24e-17)) (*
integer library_binding = "analogLib";

 *)
c865 ( \3:FLASH_1p0(2) , \4:MLT3_TDATA_1p0(0)  );
capacitor #(.c(2.471e-19)) (*
integer library_binding = "analogLib";

 *)
c866 ( \3:FLASH_1p0(2) , \MLT3_TDATA_1p0(0)  );
capacitor #(.c(1.49e-18)) (*
integer library_binding = "analogLib";

 *)
c867 ( \3:FLASH_1p0(2) , \7:FLASH_1p0(1)  );
capacitor #(.c(1.656e-19)) (*
integer library_binding = "analogLib";

 *)
c868 ( \3:FLASH_1p0(2) , \FLASH_1p0(1)  );
capacitor #(.c(1.539e-18)) (*
integer library_binding = "analogLib";

 *)
c869 ( \3:FLASH_1p0(2) , RX10_PRESENT_1p0 );
capacitor #(.c(2.881e-19)) (*
integer library_binding = "analogLib";

 *)
c870 ( \3:FLASH_1p0(2) , \4:RX10_PRESENT_1p0  );
capacitor #(.c(1.638e-18)) (*
integer library_binding = "analogLib";

 *)
c871 ( \3:FLASH_1p0(2) , \7:ADC_1p0(5)  );
capacitor #(.c(1.877e-19)) (*
integer library_binding = "analogLib";

 *)
c872 ( \3:FLASH_1p0(2) , \2:ADC_1p0(5)  );
capacitor #(.c(2.921e-19)) (*
integer library_binding = "analogLib";

 *)
c873 ( \3:FLASH_1p0(2) , \TEST_MODE(2)  );
capacitor #(.c(1.535e-18)) (*
integer library_binding = "analogLib";

 *)
c874 ( \3:FLASH_1p0(2) , \3:TEST_MODE(2)  );
capacitor #(.c(9.588e-17)) (*
integer library_binding = "analogLib";

 *)
c875 ( \3:FLASH_1p0(2) , \4:VDD  );
capacitor #(.c(2.054e-19)) (*
integer library_binding = "analogLib";

 *)
c876 ( \3:FLASH_1p0(2) , \TX_SLOPETRIM_1p0(1)  );
capacitor #(.c(2.204e-19)) (*
integer library_binding = "analogLib";

 *)
c877 ( \3:FLASH_1p0(2) , SLICER_OUT_1p0 );
capacitor #(.c(1.482e-17)) (*
integer library_binding = "analogLib";

 *)
c878 ( \3:FLASH_1p0(2) , \4:TX_SLOPETRIM_1p0(1)  );
capacitor #(.c(1.45e-17)) (*
integer library_binding = "analogLib";

 *)
c879 ( \3:FLASH_1p0(2) , \4:SLICER_OUT_1p0  );
capacitor #(.c(1.201e-16)) (*
integer library_binding = "analogLib";

 *)
c880 ( \3:FLASH_1p0(2) , \7:FLASH_1p0(0)  );
capacitor #(.c(2.259e-15)) (*
integer library_binding = "analogLib";

 *)
c881 ( \3:FLASH_1p0(2) , \4:X_125  );
capacitor #(.c(1.596e-19)) (*
integer library_binding = "analogLib";

 *)
c882 ( \3:FLASH_1p0(2) , \1:ADC_1p0(4)  );
capacitor #(.c(1.496e-18)) (*
integer library_binding = "analogLib";

 *)
c883 ( \3:FLASH_1p0(2) , \7:ADC_1p0(4)  );
capacitor #(.c(3.644e-17)) (*
integer library_binding = "analogLib";

 *)
c884 ( \3:FLASH_1p0(2) , \7:ADC_1p0(2)  );
capacitor #(.c(1.397e-17)) (*
integer library_binding = "analogLib";

 *)
c885 ( \3:FLASH_1p0(2) , \4:TX_AMPTRIM_1p0(1)  );
capacitor #(.c(1.397e-17)) (*
integer library_binding = "analogLib";

 *)
c886 ( \3:FLASH_1p0(2) , \TEST_MODE(1)  );
capacitor #(.c(2.825e-16)) (*
integer library_binding = "analogLib";

 *)
c887 ( \3:FLASH_1p0(2) , \ADC_1p0(2)  );
capacitor #(.c(1.397e-17)) (*
integer library_binding = "analogLib";

 *)
c888 ( \3:FLASH_1p0(2) , \TX_SLOPETRIM_1p0(0)  );
capacitor #(.c(1.265e-17)) (*
integer library_binding = "analogLib";

 *)
c889 ( \3:FLASH_1p0(2) , X_160 );
capacitor #(.c(1.265e-17)) (*
integer library_binding = "analogLib";

 *)
c890 ( \3:FLASH_1p0(2) , \MR_SQUELCH_RANGE_1p0(0)  );
capacitor #(.c(1.265e-17)) (*
integer library_binding = "analogLib";

 *)
c891 ( \3:FLASH_1p0(2) , \4:MR_SQUELCH_RANGE_1p0(1)  );
capacitor #(.c(1.265e-17)) (*
integer library_binding = "analogLib";

 *)
c892 ( \3:FLASH_1p0(2) , \4:MLT3_TDATA_1p0(1)  );
capacitor #(.c(1.472e-17)) (*
integer library_binding = "analogLib";

 *)
c893 ( \3:FLASH_1p0(2) , POS_DETECT_1p0 );
capacitor #(.c(1.397e-17)) (*
integer library_binding = "analogLib";

 *)
c894 ( \3:FLASH_1p0(2) , \5:TXER  );
capacitor #(.c(1.265e-17)) (*
integer library_binding = "analogLib";

 *)
c895 ( \3:FLASH_1p0(2) , \5:B10_DIS  );
capacitor #(.c(1.472e-17)) (*
integer library_binding = "analogLib";

 *)
c896 ( \3:FLASH_1p0(2) , NEG_DETECT_1p0 );
capacitor #(.c(1.472e-17)) (*
integer library_binding = "analogLib";

 *)
c897 ( \3:FLASH_1p0(2) , XTAL25_1p0 );
capacitor #(.c(1.049e-15)) (*
integer library_binding = "analogLib";

 *)
c898 ( \3:FLASH_1p0(2) , \FLASH_1p0(0)  );
capacitor #(.c(1.397e-17)) (*
integer library_binding = "analogLib";

 *)
c899 ( \3:FLASH_1p0(2) , \TX_AMPTRIM_1p0(0)  );
capacitor #(.c(1.397e-17)) (*
integer library_binding = "analogLib";

 *)
c900 ( \3:FLASH_1p0(2) , \4:TEST_MODE(0)  );
capacitor #(.c(1.265e-17)) (*
integer library_binding = "analogLib";

 *)
c901 ( \3:FLASH_1p0(2) , \4:MR_SQUELCH_DISB_1p0  );
capacitor #(.c(5.03e-16)) (*
integer library_binding = "analogLib";

 *)
c902 ( \3:FLASH_1p0(2) , X_125 );
capacitor #(.c(2.774e-16)) (*
integer library_binding = "analogLib";

 *)
c903 ( \3:FLASH_1p0(2) , \7:VDD  );
capacitor #(.c(8.133e-16)) (*
integer library_binding = "analogLib";

 *)
c904 ( \3:FLASH_1p0(2) , \4:GND  );
capacitor #(.c(6.931e-15)) (*
integer library_binding = "analogLib";

 *)
c905 ( \3:FLASH_1p0(2) , GND );
capacitor #(.c(1.601e-15)) (*
integer library_binding = "analogLib";

 *)
c906 ( \3:FLASH_1p0(2) , \3:FLASH_1p0(1)  );
capacitor #(.c(1.692e-15)) (*
integer library_binding = "analogLib";

 *)
c907 ( \3:FLASH_1p0(2) , \3:ADC_1p0(5)  );
capacitor #(.c(4.3e-18)) (*
integer library_binding = "analogLib";

 *)
c908 ( \7:FLASH_1p0(2) , \4:MLT3_TDATA_1p0(0)  );
capacitor #(.c(8.568e-20)) (*
integer library_binding = "analogLib";

 *)
c909 ( \7:FLASH_1p0(2) , \MLT3_TDATA_1p0(0)  );
capacitor #(.c(1.614e-17)) (*
integer library_binding = "analogLib";

 *)
c910 ( \7:FLASH_1p0(2) , \7:FLASH_1p0(1)  );
capacitor #(.c(1.794e-18)) (*
integer library_binding = "analogLib";

 *)
c911 ( \7:FLASH_1p0(2) , \FLASH_1p0(1)  );
capacitor #(.c(1.667e-17)) (*
integer library_binding = "analogLib";

 *)
c912 ( \7:FLASH_1p0(2) , RX10_PRESENT_1p0 );
capacitor #(.c(3.121e-18)) (*
integer library_binding = "analogLib";

 *)
c913 ( \7:FLASH_1p0(2) , \4:RX10_PRESENT_1p0  );
capacitor #(.c(1.775e-17)) (*
integer library_binding = "analogLib";

 *)
c914 ( \7:FLASH_1p0(2) , \7:ADC_1p0(5)  );
capacitor #(.c(2.033e-18)) (*
integer library_binding = "analogLib";

 *)
c915 ( \7:FLASH_1p0(2) , \2:ADC_1p0(5)  );
capacitor #(.c(3.164e-18)) (*
integer library_binding = "analogLib";

 *)
c916 ( \7:FLASH_1p0(2) , \TEST_MODE(2)  );
capacitor #(.c(1.663e-17)) (*
integer library_binding = "analogLib";

 *)
c917 ( \7:FLASH_1p0(2) , \3:TEST_MODE(2)  );
capacitor #(.c(2.191e-17)) (*
integer library_binding = "analogLib";

 *)
c918 ( \7:FLASH_1p0(2) , \7:VDD  );
capacitor #(.c(3.325e-17)) (*
integer library_binding = "analogLib";

 *)
c919 ( \7:FLASH_1p0(2) , \4:VDD  );
capacitor #(.c(7.124e-20)) (*
integer library_binding = "analogLib";

 *)
c920 ( \7:FLASH_1p0(2) , \TX_SLOPETRIM_1p0(1)  );
capacitor #(.c(7.645e-20)) (*
integer library_binding = "analogLib";

 *)
c921 ( \7:FLASH_1p0(2) , SLICER_OUT_1p0 );
capacitor #(.c(5.14e-18)) (*
integer library_binding = "analogLib";

 *)
c922 ( \7:FLASH_1p0(2) , \4:TX_SLOPETRIM_1p0(1)  );
capacitor #(.c(5.029e-18)) (*
integer library_binding = "analogLib";

 *)
c923 ( \7:FLASH_1p0(2) , \4:SLICER_OUT_1p0  );
capacitor #(.c(1.301e-15)) (*
integer library_binding = "analogLib";

 *)
c924 ( \7:FLASH_1p0(2) , \7:FLASH_1p0(0)  );
capacitor #(.c(1.119e-15)) (*
integer library_binding = "analogLib";

 *)
c925 ( \7:FLASH_1p0(2) , \4:X_125  );
capacitor #(.c(5.547e-16)) (*
integer library_binding = "analogLib";

 *)
c926 ( \7:FLASH_1p0(2) , \FLASH_1p0(0)  );
capacitor #(.c(1.567e-16)) (*
integer library_binding = "analogLib";

 *)
c927 ( \7:FLASH_1p0(2) , \ADC_1p0(2)  );
capacitor #(.c(2.027e-15)) (*
integer library_binding = "analogLib";

 *)
c928 ( \7:FLASH_1p0(2) , X_125 );
capacitor #(.c(1.729e-18)) (*
integer library_binding = "analogLib";

 *)
c929 ( \7:FLASH_1p0(2) , \1:ADC_1p0(4)  );
capacitor #(.c(1.62e-17)) (*
integer library_binding = "analogLib";

 *)
c930 ( \7:FLASH_1p0(2) , \7:ADC_1p0(4)  );
capacitor #(.c(3.947e-16)) (*
integer library_binding = "analogLib";

 *)
c931 ( \7:FLASH_1p0(2) , \7:ADC_1p0(2)  );
capacitor #(.c(4.385e-18)) (*
integer library_binding = "analogLib";

 *)
c932 ( \7:FLASH_1p0(2) , \4:MR_SQUELCH_DISB_1p0  );
capacitor #(.c(4.846e-18)) (*
integer library_binding = "analogLib";

 *)
c933 ( \7:FLASH_1p0(2) , \4:TEST_MODE(0)  );
capacitor #(.c(2.752e-16)) (*
integer library_binding = "analogLib";

 *)
c934 ( \7:FLASH_1p0(2) , \4:GND  );
capacitor #(.c(4.846e-18)) (*
integer library_binding = "analogLib";

 *)
c935 ( \7:FLASH_1p0(2) , \TX_AMPTRIM_1p0(0)  );
capacitor #(.c(5.106e-18)) (*
integer library_binding = "analogLib";

 *)
c936 ( \7:FLASH_1p0(2) , XTAL25_1p0 );
capacitor #(.c(5.106e-18)) (*
integer library_binding = "analogLib";

 *)
c937 ( \7:FLASH_1p0(2) , NEG_DETECT_1p0 );
capacitor #(.c(4.385e-18)) (*
integer library_binding = "analogLib";

 *)
c938 ( \7:FLASH_1p0(2) , \5:B10_DIS  );
capacitor #(.c(4.846e-18)) (*
integer library_binding = "analogLib";

 *)
c939 ( \7:FLASH_1p0(2) , \5:TXER  );
capacitor #(.c(5.106e-18)) (*
integer library_binding = "analogLib";

 *)
c940 ( \7:FLASH_1p0(2) , POS_DETECT_1p0 );
capacitor #(.c(4.385e-18)) (*
integer library_binding = "analogLib";

 *)
c941 ( \7:FLASH_1p0(2) , \4:MLT3_TDATA_1p0(1)  );
capacitor #(.c(4.385e-18)) (*
integer library_binding = "analogLib";

 *)
c942 ( \7:FLASH_1p0(2) , \4:MR_SQUELCH_RANGE_1p0(1)  );
capacitor #(.c(4.385e-18)) (*
integer library_binding = "analogLib";

 *)
c943 ( \7:FLASH_1p0(2) , \MR_SQUELCH_RANGE_1p0(0)  );
capacitor #(.c(4.385e-18)) (*
integer library_binding = "analogLib";

 *)
c944 ( \7:FLASH_1p0(2) , X_160 );
capacitor #(.c(4.846e-18)) (*
integer library_binding = "analogLib";

 *)
c945 ( \7:FLASH_1p0(2) , \TX_SLOPETRIM_1p0(0)  );
capacitor #(.c(4.846e-18)) (*
integer library_binding = "analogLib";

 *)
c946 ( \7:FLASH_1p0(2) , \TEST_MODE(1)  );
capacitor #(.c(4.846e-18)) (*
integer library_binding = "analogLib";

 *)
c947 ( \7:FLASH_1p0(2) , \4:TX_AMPTRIM_1p0(1)  );
capacitor #(.c(3.404e-15)) (*
integer library_binding = "analogLib";

 *)
c948 ( \7:FLASH_1p0(2) , GND );
capacitor #(.c(1.408e-16)) (*
integer library_binding = "analogLib";

 *)
c949 ( \PHASE_IN(6) , \4:GND  );
capacitor #(.c(1.432e-17)) (*
integer library_binding = "analogLib";

 *)
c950 ( \PHASE_IN(6) , \PHASE_IN(9)  );
capacitor #(.c(1.061e-16)) (*
integer library_binding = "analogLib";

 *)
c951 ( \PHASE_IN(6) , \3:PHASE_IN(7)  );
capacitor #(.c(1.717e-17)) (*
integer library_binding = "analogLib";

 *)
c952 ( \PHASE_IN(6) , \6:PHASE_IN(10)  );
capacitor #(.c(4.955e-19)) (*
integer library_binding = "analogLib";

 *)
c953 ( \PHASE_IN(6) , \PHASE_IN(8)  );
capacitor #(.c(1.383e-17)) (*
integer library_binding = "analogLib";

 *)
c954 ( \PHASE_IN(6) , \6:PHASE_IN(8)  );
capacitor #(.c(2.17e-15)) (*
integer library_binding = "analogLib";

 *)
c955 ( \PHASE_IN(6) , GND );
capacitor #(.c(2.314e-15)) (*
integer library_binding = "analogLib";

 *)
c956 ( \PHASE_IN(6) , \PHASE_IN(7)  );
capacitor #(.c(5.654e-17)) (*
integer library_binding = "analogLib";

 *)
c957 ( \PHASE_IN(6) , \PHASE_IN(5)  );
capacitor #(.c(1.665e-17)) (*
integer library_binding = "analogLib";

 *)
c958 ( \PHASE_IN(6) , \PHASE_IN(1)  );
capacitor #(.c(1.158e-15)) (*
integer library_binding = "analogLib";

 *)
c959 ( \3:PHASE_IN(6) , \4:GND  );
capacitor #(.c(1.142e-18)) (*
integer library_binding = "analogLib";

 *)
c960 ( \3:PHASE_IN(6) , \5:TENBT_FILTER_1p0(3)  );
capacitor #(.c(1.294e-17)) (*
integer library_binding = "analogLib";

 *)
c961 ( \3:PHASE_IN(6) , \TENBT_FILTER_1p0(3)  );
capacitor #(.c(1.317e-17)) (*
integer library_binding = "analogLib";

 *)
c962 ( \3:PHASE_IN(6) , \6:TENBT_FILTER_1p0(4)  );
capacitor #(.c(1.355e-17)) (*
integer library_binding = "analogLib";

 *)
c963 ( \3:PHASE_IN(6) , RESET_10BT );
capacitor #(.c(2.059e-19)) (*
integer library_binding = "analogLib";

 *)
c964 ( \3:PHASE_IN(6) , \4:VDD  );
capacitor #(.c(9.874e-18)) (*
integer library_binding = "analogLib";

 *)
c965 ( \3:PHASE_IN(6) , \9:VDD  );
capacitor #(.c(2.196e-18)) (*
integer library_binding = "analogLib";

 *)
c966 ( \3:PHASE_IN(6) , \TENBT_FILTER_1p0(2)  );
capacitor #(.c(1.189e-17)) (*
integer library_binding = "analogLib";

 *)
c967 ( \3:PHASE_IN(6) , \6:TENBT_FILTER_1p0(2)  );
capacitor #(.c(1.296e-17)) (*
integer library_binding = "analogLib";

 *)
c968 ( \3:PHASE_IN(6) , \TENBT_FILTER_1p0(1)  );
capacitor #(.c(1.124e-18)) (*
integer library_binding = "analogLib";

 *)
c969 ( \3:PHASE_IN(6) , \5:TENBT_FILTER_1p0(1)  );
capacitor #(.c(5.002e-19)) (*
integer library_binding = "analogLib";

 *)
c970 ( \3:PHASE_IN(6) , \PHASE_IN(9)  );
capacitor #(.c(5.995e-19)) (*
integer library_binding = "analogLib";

 *)
c971 ( \3:PHASE_IN(6) , \6:PHASE_IN(10)  );
capacitor #(.c(7.899e-17)) (*
integer library_binding = "analogLib";

 *)
c972 ( \3:PHASE_IN(6) , \PHASE_IN(7)  );
capacitor #(.c(1.73e-20)) (*
integer library_binding = "analogLib";

 *)
c973 ( \3:PHASE_IN(6) , \PHASE_IN(8)  );
capacitor #(.c(4.829e-19)) (*
integer library_binding = "analogLib";

 *)
c974 ( \3:PHASE_IN(6) , \6:PHASE_IN(8)  );
capacitor #(.c(1.561e-18)) (*
integer library_binding = "analogLib";

 *)
c975 ( \3:PHASE_IN(6) , \TENBT_FILTER_1p0(0)  );
capacitor #(.c(1.253e-17)) (*
integer library_binding = "analogLib";

 *)
c976 ( \3:PHASE_IN(6) , \6:TENBT_FILTER_1p0(0)  );
capacitor #(.c(2.424e-18)) (*
integer library_binding = "analogLib";

 *)
c977 ( \3:PHASE_IN(6) , TENBT_CLK160_1p0 );
capacitor #(.c(1.318e-17)) (*
integer library_binding = "analogLib";

 *)
c978 ( \3:PHASE_IN(6) , \6:TENBT_CLK160_1p0  );
capacitor #(.c(2.057e-18)) (*
integer library_binding = "analogLib";

 *)
c979 ( \3:PHASE_IN(6) , \5:RESET_10BT  );
capacitor #(.c(2.43e-18)) (*
integer library_binding = "analogLib";

 *)
c980 ( \3:PHASE_IN(6) , \TENBT_FILTER_1p0(4)  );
capacitor #(.c(1.984e-17)) (*
integer library_binding = "analogLib";

 *)
c981 ( \3:PHASE_IN(6) , \1:PLL_160_IN  );
capacitor #(.c(1.094e-17)) (*
integer library_binding = "analogLib";

 *)
c982 ( \3:PHASE_IN(6) , \3:XTAL25  );
capacitor #(.c(1.984e-17)) (*
integer library_binding = "analogLib";

 *)
c983 ( \3:PHASE_IN(6) , \1:PHASE_IN(1)  );
capacitor #(.c(2.363e-15)) (*
integer library_binding = "analogLib";

 *)
c984 ( \3:PHASE_IN(6) , \3:PHASE_IN(7)  );
capacitor #(.c(1.498e-17)) (*
integer library_binding = "analogLib";

 *)
c985 ( \3:PHASE_IN(6) , \1:PHASE_IN(5)  );
capacitor #(.c(4.508e-17)) (*
integer library_binding = "analogLib";

 *)
c986 ( \3:PHASE_IN(6) , \PHASE_IN(0)  );
capacitor #(.c(1.785e-14)) (*
integer library_binding = "analogLib";

 *)
c987 ( \3:PHASE_IN(6) , GND );
capacitor #(.c(3.093e-15)) (*
integer library_binding = "analogLib";

 *)
c988 ( \3:PHASE_IN(6) , \2:PHASE_IN(0)  );
capacitor #(.c(8.534e-16)) (*
integer library_binding = "analogLib";

 *)
c989 ( \4:PHASE_IN(6) , \4:GND  );
capacitor #(.c(1.376e-17)) (*
integer library_binding = "analogLib";

 *)
c990 ( \4:PHASE_IN(6) , \MLT3_TDATA_2p5(1)  );
capacitor #(.c(2.244e-18)) (*
integer library_binding = "analogLib";

 *)
c991 ( \4:PHASE_IN(6) , \5:ADC_TEST_2p5  );
capacitor #(.c(9.528e-15)) (*
integer library_binding = "analogLib";

 *)
c992 ( \4:PHASE_IN(6) , TP_DISC_2p5 );
capacitor #(.c(1.459e-16)) (*
integer library_binding = "analogLib";

 *)
c993 ( \4:PHASE_IN(6) , \9:TX100_DIS_2p5  );
capacitor #(.c(5.633e-16)) (*
integer library_binding = "analogLib";

 *)
c994 ( \4:PHASE_IN(6) , \2:TX100_DIS_2p5  );
capacitor #(.c(1.187e-17)) (*
integer library_binding = "analogLib";

 *)
c995 ( \4:PHASE_IN(6) , \5:PHASE_IN(5)  );
capacitor #(.c(9.523e-18)) (*
integer library_binding = "analogLib";

 *)
c996 ( \4:PHASE_IN(6) , \7:PHASE_IN(7)  );
capacitor #(.c(1.586e-18)) (*
integer library_binding = "analogLib";

 *)
c997 ( \4:PHASE_IN(6) , \5:PHASE_IN(7)  );
capacitor #(.c(9.352e-17)) (*
integer library_binding = "analogLib";

 *)
c998 ( \4:PHASE_IN(6) , \7:PHASE_IN(10)  );
capacitor #(.c(6.683e-18)) (*
integer library_binding = "analogLib";

 *)
c999 ( \4:PHASE_IN(6) , \5:ADC_DIS_2p5  );
capacitor #(.c(4.998e-17)) (*
integer library_binding = "analogLib";

 *)
c1000 ( \4:PHASE_IN(6) , \24:VDDTX  );
capacitor #(.c(2.813e-16)) (*
integer library_binding = "analogLib";

 *)
c1001 ( \4:PHASE_IN(6) , \25:VDDTX  );
capacitor #(.c(4.002e-17)) (*
integer library_binding = "analogLib";

 *)
c1002 ( \4:PHASE_IN(6) , ADC_DIS_2p5 );
capacitor #(.c(1.065e-19)) (*
integer library_binding = "analogLib";

 *)
c1003 ( \4:PHASE_IN(6) , \1:PLL_160_IN  );
capacitor #(.c(1.678e-17)) (*
integer library_binding = "analogLib";

 *)
c1004 ( \4:PHASE_IN(6) , \4:PLL_160_IN  );
capacitor #(.c(7.003e-20)) (*
integer library_binding = "analogLib";

 *)
c1005 ( \4:PHASE_IN(6) , \3:XTAL25  );
capacitor #(.c(1.681e-17)) (*
integer library_binding = "analogLib";

 *)
c1006 ( \4:PHASE_IN(6) , \6:XTAL25  );
capacitor #(.c(9.252e-15)) (*
integer library_binding = "analogLib";

 *)
c1007 ( \4:PHASE_IN(6) , \3:TP_DISC_2p5  );
capacitor #(.c(6.358e-16)) (*
integer library_binding = "analogLib";

 *)
c1008 ( \4:PHASE_IN(6) , \6:TIMING_UP_ANLG  );
capacitor #(.c(4.259e-18)) (*
integer library_binding = "analogLib";

 *)
c1009 ( \4:PHASE_IN(6) , \4:RCLK125_TST  );
capacitor #(.c(8.071e-18)) (*
integer library_binding = "analogLib";

 *)
c1010 ( \4:PHASE_IN(6) , RCLK125_TST );
capacitor #(.c(1.47e-17)) (*
integer library_binding = "analogLib";

 *)
c1011 ( \4:PHASE_IN(6) , \3:RCLK125_TST_SEL  );
capacitor #(.c(8.864e-18)) (*
integer library_binding = "analogLib";

 *)
c1012 ( \4:PHASE_IN(6) , RCLK125_TST_SEL );
capacitor #(.c(2.362e-16)) (*
integer library_binding = "analogLib";

 *)
c1013 ( \4:PHASE_IN(6) , \23:GNDTX  );
capacitor #(.c(9.212e-17)) (*
integer library_binding = "analogLib";

 *)
c1014 ( \4:PHASE_IN(6) , \22:GNDTX  );
capacitor #(.c(1.274e-17)) (*
integer library_binding = "analogLib";

 *)
c1015 ( \4:PHASE_IN(6) , ADC_TEST_2p5 );
capacitor #(.c(9.019e-18)) (*
integer library_binding = "analogLib";

 *)
c1016 ( \4:PHASE_IN(6) , \9:BASEFX_DIS  );
capacitor #(.c(1.128e-16)) (*
integer library_binding = "analogLib";

 *)
c1017 ( \4:PHASE_IN(6) , \MLT3_TDATA_2p5(0)  );
capacitor #(.c(8.823e-18)) (*
integer library_binding = "analogLib";

 *)
c1018 ( \4:PHASE_IN(6) , \5:BASEFX_DIS  );
capacitor #(.c(1.299e-15)) (*
integer library_binding = "analogLib";

 *)
c1019 ( \4:PHASE_IN(6) , \3:MLT3_TDATA_2p5(0)  );
capacitor #(.c(1.354e-17)) (*
integer library_binding = "analogLib";

 *)
c1020 ( \4:PHASE_IN(6) , \4:MLT3_TDATA_2p5(1)  );
capacitor #(.c(6.808e-16)) (*
integer library_binding = "analogLib";

 *)
c1021 ( \4:PHASE_IN(6) , \4:PHASE_IN(10)  );
capacitor #(.c(5.262e-16)) (*
integer library_binding = "analogLib";

 *)
c1022 ( \4:PHASE_IN(6) , TIMING_UP_ANLG );
capacitor #(.c(1.319e-14)) (*
integer library_binding = "analogLib";

 *)
c1023 ( \4:PHASE_IN(6) , GND );
capacitor #(.c(2.806e-15)) (*
integer library_binding = "analogLib";

 *)
c1024 ( \4:PHASE_IN(6) , \PHASE_IN(0)  );
capacitor #(.c(3.479e-17)) (*
integer library_binding = "analogLib";

 *)
c1025 ( \7:PHASE_IN(6) , \4:GND  );
capacitor #(.c(1.577e-16)) (*
integer library_binding = "analogLib";

 *)
c1026 ( \7:PHASE_IN(6) , \4:PHASE_IN(10)  );
capacitor #(.c(1.083e-16)) (*
integer library_binding = "analogLib";

 *)
c1027 ( \7:PHASE_IN(6) , \25:VDDTX  );
capacitor #(.c(8.337e-17)) (*
integer library_binding = "analogLib";

 *)
c1028 ( \7:PHASE_IN(6) , \23:GNDTX  );
capacitor #(.c(9.078e-18)) (*
integer library_binding = "analogLib";

 *)
c1029 ( \7:PHASE_IN(6) , \5:PHASE_IN(7)  );
capacitor #(.c(2.481e-16)) (*
integer library_binding = "analogLib";

 *)
c1030 ( \7:PHASE_IN(6) , \6:TIMING_UP_ANLG  );
capacitor #(.c(1.541e-16)) (*
integer library_binding = "analogLib";

 *)
c1031 ( \7:PHASE_IN(6) , TIMING_UP_ANLG );
capacitor #(.c(5.351e-16)) (*
integer library_binding = "analogLib";

 *)
c1032 ( \7:PHASE_IN(6) , \7:PHASE_IN(10)  );
capacitor #(.c(5.806e-16)) (*
integer library_binding = "analogLib";

 *)
c1033 ( \7:PHASE_IN(6) , GND );
capacitor #(.c(1.181e-16)) (*
integer library_binding = "analogLib";

 *)
c1034 ( \7:PHASE_IN(6) , \7:PHASE_IN(7)  );
capacitor #(.c(1.315e-16)) (*
integer library_binding = "analogLib";

 *)
c1035 ( \7:PHASE_IN(6) , \5:PHASE_IN(5)  );
capacitor #(.c(2.725e-15)) (*
integer library_binding = "analogLib";

 *)
c1036 ( MDIO_OE, GND );
capacitor #(.c(3.651e-16)) (*
integer library_binding = "analogLib";

 *)
c1037 ( MDIO_OE, \4:GND  );
capacitor #(.c(1.768e-16)) (*
integer library_binding = "analogLib";

 *)
c1038 ( \1:MDIO_OE , \4:GND  );
capacitor #(.c(2.725e-15)) (*
integer library_binding = "analogLib";

 *)
c1039 ( \1:MDIO_OE , GND );
capacitor #(.c(3.293e-16)) (*
integer library_binding = "analogLib";

 *)
c1040 ( \1:MDIO_OE , \4:VDD  );
capacitor #(.c(8.74e-17)) (*
integer library_binding = "analogLib";

 *)
c1041 ( \AEQ_CNT_ANLG(3) , \4:GND  );
capacitor #(.c(1.963e-17)) (*
integer library_binding = "analogLib";

 *)
c1042 ( \AEQ_CNT_ANLG(3) , \WANDER_CNT(4)  );
capacitor #(.c(1.442e-17)) (*
integer library_binding = "analogLib";

 *)
c1043 ( \AEQ_CNT_ANLG(3) , \AEQ_CNT_ANLG(1)  );
capacitor #(.c(1.795e-18)) (*
integer library_binding = "analogLib";

 *)
c1044 ( \AEQ_CNT_ANLG(3) , \WANDER_CNT(5)  );
capacitor #(.c(1.421e-17)) (*
integer library_binding = "analogLib";

 *)
c1045 ( \AEQ_CNT_ANLG(3) , \5:ADC_TEST_2p5  );
capacitor #(.c(3.602e-15)) (*
integer library_binding = "analogLib";

 *)
c1046 ( \AEQ_CNT_ANLG(3) , \AEQ_CNT_ANLG(4)  );
capacitor #(.c(7.097e-15)) (*
integer library_binding = "analogLib";

 *)
c1047 ( \AEQ_CNT_ANLG(3) , \6:I_REXT_50(0)  );
capacitor #(.c(1.88e-18)) (*
integer library_binding = "analogLib";

 *)
c1048 ( \AEQ_CNT_ANLG(3) , \AEQ_CNT_ANLG(2)  );
capacitor #(.c(1.446e-17)) (*
integer library_binding = "analogLib";

 *)
c1049 ( \AEQ_CNT_ANLG(3) , \5:ADC_DIS_2p5  );
capacitor #(.c(1.444e-19)) (*
integer library_binding = "analogLib";

 *)
c1050 ( \AEQ_CNT_ANLG(3) , ADC_DIS_2p5 );
capacitor #(.c(1.856e-18)) (*
integer library_binding = "analogLib";

 *)
c1051 ( \AEQ_CNT_ANLG(3) , \WANDER_CNT(0)  );
capacitor #(.c(1.901e-16)) (*
integer library_binding = "analogLib";

 *)
c1052 ( \AEQ_CNT_ANLG(3) , BLW_DIS_2p5 );
capacitor #(.c(1.067e-17)) (*
integer library_binding = "analogLib";

 *)
c1053 ( \AEQ_CNT_ANLG(3) , \24:VDDTX  );
capacitor #(.c(5.603e-17)) (*
integer library_binding = "analogLib";

 *)
c1054 ( \AEQ_CNT_ANLG(3) , \25:VDDTX  );
capacitor #(.c(1.857e-17)) (*
integer library_binding = "analogLib";

 *)
c1055 ( \AEQ_CNT_ANLG(3) , RX10_PRESENT_2p5 );
capacitor #(.c(1.448e-17)) (*
integer library_binding = "analogLib";

 *)
c1056 ( \AEQ_CNT_ANLG(3) , \4:AEQ_CNT_ANLG(2)  );
capacitor #(.c(1.764e-18)) (*
integer library_binding = "analogLib";

 *)
c1057 ( \AEQ_CNT_ANLG(3) , \AEQ_CNT_ANLG(0)  );
capacitor #(.c(1.456e-17)) (*
integer library_binding = "analogLib";

 *)
c1058 ( \AEQ_CNT_ANLG(3) , \WANDER_CNT(1)  );
capacitor #(.c(1.773e-18)) (*
integer library_binding = "analogLib";

 *)
c1059 ( \AEQ_CNT_ANLG(3) , \6:RX10_PRESENT_2p5  );
capacitor #(.c(1.348e-18)) (*
integer library_binding = "analogLib";

 *)
c1060 ( \AEQ_CNT_ANLG(3) , \4:PLL_160_IN  );
capacitor #(.c(1.236e-18)) (*
integer library_binding = "analogLib";

 *)
c1061 ( \AEQ_CNT_ANLG(3) , \6:XTAL25  );
capacitor #(.c(1.309e-17)) (*
integer library_binding = "analogLib";

 *)
c1062 ( \AEQ_CNT_ANLG(3) , \4:WANDER_CNT(5)  );
capacitor #(.c(1.889e-18)) (*
integer library_binding = "analogLib";

 *)
c1063 ( \AEQ_CNT_ANLG(3) , \5:WANDER_CNT(1)  );
capacitor #(.c(7.914e-16)) (*
integer library_binding = "analogLib";

 *)
c1064 ( \AEQ_CNT_ANLG(3) , \5:BLW_DIS_2p5  );
capacitor #(.c(1.21e-18)) (*
integer library_binding = "analogLib";

 *)
c1065 ( \AEQ_CNT_ANLG(3) , \6:AEQ_DIS_2p5  );
capacitor #(.c(1.366e-18)) (*
integer library_binding = "analogLib";

 *)
c1066 ( \AEQ_CNT_ANLG(3) , \4:PHASE_IN(9)  );
capacitor #(.c(1.333e-18)) (*
integer library_binding = "analogLib";

 *)
c1067 ( \AEQ_CNT_ANLG(3) , \2:PHASE_IN(1)  );
capacitor #(.c(2.424e-18)) (*
integer library_binding = "analogLib";

 *)
c1068 ( \AEQ_CNT_ANLG(3) , \5:BASEFX_DIS  );
capacitor #(.c(1.52e-18)) (*
integer library_binding = "analogLib";

 *)
c1069 ( \AEQ_CNT_ANLG(3) , \PHASE_IN(0)  );
capacitor #(.c(1.503e-18)) (*
integer library_binding = "analogLib";

 *)
c1070 ( \AEQ_CNT_ANLG(3) , \3:I_REXT_100_NC  );
capacitor #(.c(1.783e-18)) (*
integer library_binding = "analogLib";

 *)
c1071 ( \AEQ_CNT_ANLG(3) , \5:WANDER_CNT(4)  );
capacitor #(.c(2.93e-19)) (*
integer library_binding = "analogLib";

 *)
c1072 ( \AEQ_CNT_ANLG(3) , AEQ_DIS_2p5 );
capacitor #(.c(1.901e-18)) (*
integer library_binding = "analogLib";

 *)
c1073 ( \AEQ_CNT_ANLG(3) , \5:AEQ_CNT_ANLG(1)  );
capacitor #(.c(2.999e-19)) (*
integer library_binding = "analogLib";

 *)
c1074 ( \AEQ_CNT_ANLG(3) , ADC_TEST_2p5 );
capacitor #(.c(1.381e-17)) (*
integer library_binding = "analogLib";

 *)
c1075 ( \AEQ_CNT_ANLG(3) , \4:WANDER_CNT(0)  );
capacitor #(.c(1.537e-17)) (*
integer library_binding = "analogLib";

 *)
c1076 ( \AEQ_CNT_ANLG(3) , \4:WANDER_CNT(3)  );
capacitor #(.c(1.86e-18)) (*
integer library_binding = "analogLib";

 *)
c1077 ( \AEQ_CNT_ANLG(3) , \WANDER_CNT(3)  );
capacitor #(.c(4.14e-15)) (*
integer library_binding = "analogLib";

 *)
c1078 ( \AEQ_CNT_ANLG(3) , \2:I_REXT_50(0)  );
capacitor #(.c(1.491e-17)) (*
integer library_binding = "analogLib";

 *)
c1079 ( \AEQ_CNT_ANLG(3) , \4:AEQ_CNT_ANLG(0)  );
capacitor #(.c(1.905e-17)) (*
integer library_binding = "analogLib";

 *)
c1080 ( \AEQ_CNT_ANLG(3) , \6:X10_DIS_2p5  );
capacitor #(.c(3.937e-16)) (*
integer library_binding = "analogLib";

 *)
c1081 ( \AEQ_CNT_ANLG(3) , \5:AEQ_CNT_ANLG(4)  );
capacitor #(.c(3.229e-19)) (*
integer library_binding = "analogLib";

 *)
c1082 ( \AEQ_CNT_ANLG(3) , \2:TX100_DIS_2p5  );
capacitor #(.c(1.873e-17)) (*
integer library_binding = "analogLib";

 *)
c1083 ( \AEQ_CNT_ANLG(3) , \8:TX100_DIS_2p5  );
capacitor #(.c(1.354e-15)) (*
integer library_binding = "analogLib";

 *)
c1084 ( \AEQ_CNT_ANLG(3) , GND );
capacitor #(.c(1.428e-16)) (*
integer library_binding = "analogLib";

 *)
c1085 ( \5:AEQ_CNT_ANLG(3) , \4:GND  );
capacitor #(.c(1.405e-18)) (*
integer library_binding = "analogLib";

 *)
c1086 ( \5:AEQ_CNT_ANLG(3) , \WANDER_CNT(4)  );
capacitor #(.c(1.461e-18)) (*
integer library_binding = "analogLib";

 *)
c1087 ( \5:AEQ_CNT_ANLG(3) , \AEQ_CNT_ANLG(1)  );
capacitor #(.c(1.372e-18)) (*
integer library_binding = "analogLib";

 *)
c1088 ( \5:AEQ_CNT_ANLG(3) , \4:WANDER_CNT(5)  );
capacitor #(.c(1.655e-17)) (*
integer library_binding = "analogLib";

 *)
c1089 ( \5:AEQ_CNT_ANLG(3) , \WANDER_CNT(5)  );
capacitor #(.c(3.864e-16)) (*
integer library_binding = "analogLib";

 *)
c1090 ( \5:AEQ_CNT_ANLG(3) , \AEQ_CNT_ANLG(4)  );
capacitor #(.c(1.334e-16)) (*
integer library_binding = "analogLib";

 *)
c1091 ( \5:AEQ_CNT_ANLG(3) , \6:I_REXT_50(0)  );
capacitor #(.c(1.394e-17)) (*
integer library_binding = "analogLib";

 *)
c1092 ( \5:AEQ_CNT_ANLG(3) , \AEQ_CNT_ANLG(2)  );
capacitor #(.c(2.718e-19)) (*
integer library_binding = "analogLib";

 *)
c1093 ( \5:AEQ_CNT_ANLG(3) , \5:ADC_DIS_2p5  );
capacitor #(.c(1.665e-17)) (*
integer library_binding = "analogLib";

 *)
c1094 ( \5:AEQ_CNT_ANLG(3) , \WANDER_CNT(0)  );
capacitor #(.c(3.688e-16)) (*
integer library_binding = "analogLib";

 *)
c1095 ( \5:AEQ_CNT_ANLG(3) , BLW_DIS_2p5 );
capacitor #(.c(1.025e-16)) (*
integer library_binding = "analogLib";

 *)
c1096 ( \5:AEQ_CNT_ANLG(3) , \24:VDDTX  );
capacitor #(.c(5.384e-16)) (*
integer library_binding = "analogLib";

 *)
c1097 ( \5:AEQ_CNT_ANLG(3) , \25:VDDTX  );
capacitor #(.c(3.541e-18)) (*
integer library_binding = "analogLib";

 *)
c1098 ( \5:AEQ_CNT_ANLG(3) , RX10_PRESENT_2p5 );
capacitor #(.c(1.54e-18)) (*
integer library_binding = "analogLib";

 *)
c1099 ( \5:AEQ_CNT_ANLG(3) , \4:AEQ_CNT_ANLG(2)  );
capacitor #(.c(1.695e-17)) (*
integer library_binding = "analogLib";

 *)
c1100 ( \5:AEQ_CNT_ANLG(3) , \AEQ_CNT_ANLG(0)  );
capacitor #(.c(1.553e-18)) (*
integer library_binding = "analogLib";

 *)
c1101 ( \5:AEQ_CNT_ANLG(3) , \WANDER_CNT(1)  );
capacitor #(.c(1.314e-17)) (*
integer library_binding = "analogLib";

 *)
c1102 ( \5:AEQ_CNT_ANLG(3) , \6:RX10_PRESENT_2p5  );
capacitor #(.c(8.22e-20)) (*
integer library_binding = "analogLib";

 *)
c1103 ( \5:AEQ_CNT_ANLG(3) , \1:PLL_160_IN  );
capacitor #(.c(1.295e-17)) (*
integer library_binding = "analogLib";

 *)
c1104 ( \5:AEQ_CNT_ANLG(3) , \4:PLL_160_IN  );
capacitor #(.c(4.948e-20)) (*
integer library_binding = "analogLib";

 *)
c1105 ( \5:AEQ_CNT_ANLG(3) , \3:XTAL25  );
capacitor #(.c(1.188e-17)) (*
integer library_binding = "analogLib";

 *)
c1106 ( \5:AEQ_CNT_ANLG(3) , \6:XTAL25  );
capacitor #(.c(1.665e-17)) (*
integer library_binding = "analogLib";

 *)
c1107 ( \5:AEQ_CNT_ANLG(3) , \5:WANDER_CNT(1)  );
capacitor #(.c(1.886e-16)) (*
integer library_binding = "analogLib";

 *)
c1108 ( \5:AEQ_CNT_ANLG(3) , \5:BLW_DIS_2p5  );
capacitor #(.c(1.163e-17)) (*
integer library_binding = "analogLib";

 *)
c1109 ( \5:AEQ_CNT_ANLG(3) , \6:AEQ_DIS_2p5  );
capacitor #(.c(1.313e-17)) (*
integer library_binding = "analogLib";

 *)
c1110 ( \5:AEQ_CNT_ANLG(3) , \4:PHASE_IN(9)  );
capacitor #(.c(7.959e-15)) (*
integer library_binding = "analogLib";

 *)
c1111 ( \5:AEQ_CNT_ANLG(3) , \2:I_REXT_50(0)  );
capacitor #(.c(1.281e-17)) (*
integer library_binding = "analogLib";

 *)
c1112 ( \5:AEQ_CNT_ANLG(3) , \2:PHASE_IN(1)  );
capacitor #(.c(2.329e-17)) (*
integer library_binding = "analogLib";

 *)
c1113 ( \5:AEQ_CNT_ANLG(3) , \5:BASEFX_DIS  );
capacitor #(.c(1.46e-17)) (*
integer library_binding = "analogLib";

 *)
c1114 ( \5:AEQ_CNT_ANLG(3) , \PHASE_IN(0)  );
capacitor #(.c(1.445e-17)) (*
integer library_binding = "analogLib";

 *)
c1115 ( \5:AEQ_CNT_ANLG(3) , \3:I_REXT_100_NC  );
capacitor #(.c(2.975e-15)) (*
integer library_binding = "analogLib";

 *)
c1116 ( \5:AEQ_CNT_ANLG(3) , \5:AEQ_CNT_ANLG(4)  );
capacitor #(.c(1.659e-17)) (*
integer library_binding = "analogLib";

 *)
c1117 ( \5:AEQ_CNT_ANLG(3) , \WANDER_CNT(3)  );
capacitor #(.c(1.652e-17)) (*
integer library_binding = "analogLib";

 *)
c1118 ( \5:AEQ_CNT_ANLG(3) , \5:WANDER_CNT(4)  );
capacitor #(.c(3.52e-19)) (*
integer library_binding = "analogLib";

 *)
c1119 ( \5:AEQ_CNT_ANLG(3) , \8:TX100_DIS_2p5  );
capacitor #(.c(3.58e-19)) (*
integer library_binding = "analogLib";

 *)
c1120 ( \5:AEQ_CNT_ANLG(3) , \6:X10_DIS_2p5  );
capacitor #(.c(1.515e-18)) (*
integer library_binding = "analogLib";

 *)
c1121 ( \5:AEQ_CNT_ANLG(3) , \4:AEQ_CNT_ANLG(0)  );
capacitor #(.c(1.621e-18)) (*
integer library_binding = "analogLib";

 *)
c1122 ( \5:AEQ_CNT_ANLG(3) , \4:WANDER_CNT(3)  );
capacitor #(.c(2.816e-18)) (*
integer library_binding = "analogLib";

 *)
c1123 ( \5:AEQ_CNT_ANLG(3) , AEQ_DIS_2p5 );
capacitor #(.c(1.529e-18)) (*
integer library_binding = "analogLib";

 *)
c1124 ( \5:AEQ_CNT_ANLG(3) , \4:WANDER_CNT(0)  );
capacitor #(.c(1.356e-17)) (*
integer library_binding = "analogLib";

 *)
c1125 ( \5:AEQ_CNT_ANLG(3) , \5:AEQ_CNT_ANLG(1)  );
capacitor #(.c(5.143e-16)) (*
integer library_binding = "analogLib";

 *)
c1126 ( \5:AEQ_CNT_ANLG(3) , \23:GNDTX  );
capacitor #(.c(2.138e-16)) (*
integer library_binding = "analogLib";

 *)
c1127 ( \5:AEQ_CNT_ANLG(3) , \22:GNDTX  );
capacitor #(.c(2.265e-15)) (*
integer library_binding = "analogLib";

 *)
c1128 ( \5:AEQ_CNT_ANLG(3) , GND );
capacitor #(.c(2.783e-15)) (*
integer library_binding = "analogLib";

 *)
c1129 ( I_REXT_REF100, \4:GND  );
capacitor #(.c(9.202e-18)) (*
integer library_binding = "analogLib";

 *)
c1130 ( I_REXT_REF100, \PHASE_250(2)  );
capacitor #(.c(6.696e-18)) (*
integer library_binding = "analogLib";

 *)
c1131 ( I_REXT_REF100, \4:PHASE_250(2)  );
capacitor #(.c(8.467e-18)) (*
integer library_binding = "analogLib";

 *)
c1132 ( I_REXT_REF100, \4:PHASE_250(8)  );
capacitor #(.c(7.431e-18)) (*
integer library_binding = "analogLib";

 *)
c1133 ( I_REXT_REF100, \PHASE_250(8)  );
capacitor #(.c(9.752e-18)) (*
integer library_binding = "analogLib";

 *)
c1134 ( I_REXT_REF100, \3:PHASE_250(1)  );
capacitor #(.c(6.146e-18)) (*
integer library_binding = "analogLib";

 *)
c1135 ( I_REXT_REF100, \PHASE_250(1)  );
capacitor #(.c(2.351e-18)) (*
integer library_binding = "analogLib";

 *)
c1136 ( I_REXT_REF100, \9:TX100_DIS_2p5  );
capacitor #(.c(9.073e-18)) (*
integer library_binding = "analogLib";

 *)
c1137 ( I_REXT_REF100, \2:TX100_DIS_2p5  );
capacitor #(.c(6.043e-18)) (*
integer library_binding = "analogLib";

 *)
c1138 ( I_REXT_REF100, \4:PHASE_250(7)  );
capacitor #(.c(7.774e-18)) (*
integer library_binding = "analogLib";

 *)
c1139 ( I_REXT_REF100, \PHASE_250(7)  );
capacitor #(.c(7.146e-17)) (*
integer library_binding = "analogLib";

 *)
c1140 ( I_REXT_REF100, \24:VDDTX  );
capacitor #(.c(3.752e-16)) (*
integer library_binding = "analogLib";

 *)
c1141 ( I_REXT_REF100, \25:VDDTX  );
capacitor #(.c(4.465e-17)) (*
integer library_binding = "analogLib";

 *)
c1142 ( I_REXT_REF100, RX10_PRESENT_2p5 );
capacitor #(.c(7.269e-18)) (*
integer library_binding = "analogLib";

 *)
c1143 ( I_REXT_REF100, \PHASE_250(6)  );
capacitor #(.c(6.536e-18)) (*
integer library_binding = "analogLib";

 *)
c1144 ( I_REXT_REF100, \4:PHASE_250(6)  );
capacitor #(.c(1.025e-17)) (*
integer library_binding = "analogLib";

 *)
c1145 ( I_REXT_REF100, POS_DETECT_2p5 );
capacitor #(.c(7.16e-18)) (*
integer library_binding = "analogLib";

 *)
c1146 ( I_REXT_REF100, \5:POS_DETECT_2p5  );
capacitor #(.c(2.331e-16)) (*
integer library_binding = "analogLib";

 *)
c1147 ( I_REXT_REF100, \MR_SQUELCH_RANGE_2p5(0)  );
capacitor #(.c(7.358e-18)) (*
integer library_binding = "analogLib";

 *)
c1148 ( I_REXT_REF100, NEG_DETECT_2p5 );
capacitor #(.c(1.005e-17)) (*
integer library_binding = "analogLib";

 *)
c1149 ( I_REXT_REF100, \4:NEG_DETECT_2p5  );
capacitor #(.c(1.448e-18)) (*
integer library_binding = "analogLib";

 *)
c1150 ( I_REXT_REF100, \3:ADC_1p0(3)  );
capacitor #(.c(1.271e-17)) (*
integer library_binding = "analogLib";

 *)
c1151 ( I_REXT_REF100, \3:VDDRX  );
capacitor #(.c(1.448e-18)) (*
integer library_binding = "analogLib";

 *)
c1152 ( I_REXT_REF100, \3:ADC_1p0(4)  );
capacitor #(.c(3.212e-17)) (*
integer library_binding = "analogLib";

 *)
c1153 ( I_REXT_REF100, \6:VDD  );
capacitor #(.c(1.75e-17)) (*
integer library_binding = "analogLib";

 *)
c1154 ( I_REXT_REF100, \5:GND  );
capacitor #(.c(1.271e-17)) (*
integer library_binding = "analogLib";

 *)
c1155 ( I_REXT_REF100, \6:GNDRX  );
capacitor #(.c(1.279e-16)) (*
integer library_binding = "analogLib";

 *)
c1156 ( I_REXT_REF100, \4:RCLK125_1p0  );
capacitor #(.c(1.143e-18)) (*
integer library_binding = "analogLib";

 *)
c1157 ( I_REXT_REF100, \I_RPOLY_100(4)  );
capacitor #(.c(1.433e-18)) (*
integer library_binding = "analogLib";

 *)
c1158 ( I_REXT_REF100, \ADC_1p0(0)  );
capacitor #(.c(1.134e-18)) (*
integer library_binding = "analogLib";

 *)
c1159 ( I_REXT_REF100, \4:ADC_1p0(2)  );
capacitor #(.c(1.448e-18)) (*
integer library_binding = "analogLib";

 *)
c1160 ( I_REXT_REF100, \4:I_RPOLY_100(5)  );
capacitor #(.c(1.752e-18)) (*
integer library_binding = "analogLib";

 *)
c1161 ( I_REXT_REF100, \4:FLASH_1p0(0)  );
capacitor #(.c(1.562e-18)) (*
integer library_binding = "analogLib";

 *)
c1162 ( I_REXT_REF100, \ADC_1p0(5)  );
capacitor #(.c(8.624e-19)) (*
integer library_binding = "analogLib";

 *)
c1163 ( I_REXT_REF100, \I_REXT_50(1)  );
capacitor #(.c(6.886e-16)) (*
integer library_binding = "analogLib";

 *)
c1164 ( I_REXT_REF100, \12:I_RPOLY_REF100  );
capacitor #(.c(1.303e-15)) (*
integer library_binding = "analogLib";

 *)
c1165 ( I_REXT_REF100, \4:MR_SQUELCH_RANGE_2p5(0)  );
capacitor #(.c(8.299e-19)) (*
integer library_binding = "analogLib";

 *)
c1166 ( I_REXT_REF100, AEQ_DIS_2p5 );
capacitor #(.c(1.507e-17)) (*
integer library_binding = "analogLib";

 *)
c1167 ( I_REXT_REF100, \6:AEQ_DIS_2p5  );
capacitor #(.c(4.719e-18)) (*
integer library_binding = "analogLib";

 *)
c1168 ( I_REXT_REF100, \4:RCLK125_TST  );
capacitor #(.c(8.942e-18)) (*
integer library_binding = "analogLib";

 *)
c1169 ( I_REXT_REF100, RCLK125_TST );
capacitor #(.c(7.979e-17)) (*
integer library_binding = "analogLib";

 *)
c1170 ( I_REXT_REF100, \PHASE_250(5)  );
capacitor #(.c(8.521e-18)) (*
integer library_binding = "analogLib";

 *)
c1171 ( I_REXT_REF100, \3:RCLK125_TST_SEL  );
capacitor #(.c(5.139e-18)) (*
integer library_binding = "analogLib";

 *)
c1172 ( I_REXT_REF100, RCLK125_TST_SEL );
capacitor #(.c(3.172e-16)) (*
integer library_binding = "analogLib";

 *)
c1173 ( I_REXT_REF100, \23:GNDTX  );
capacitor #(.c(1.319e-16)) (*
integer library_binding = "analogLib";

 *)
c1174 ( I_REXT_REF100, \22:GNDTX  );
capacitor #(.c(8.308e-18)) (*
integer library_binding = "analogLib";

 *)
c1175 ( I_REXT_REF100, \4:PHASE_250(10)  );
capacitor #(.c(7.59e-18)) (*
integer library_binding = "analogLib";

 *)
c1176 ( I_REXT_REF100, \PHASE_250(10)  );
capacitor #(.c(2.618e-16)) (*
integer library_binding = "analogLib";

 *)
c1177 ( I_REXT_REF100, \4:PHASE_250(5)  );
capacitor #(.c(8.157e-18)) (*
integer library_binding = "analogLib";

 *)
c1178 ( I_REXT_REF100, \MR_SQUELCH_RANGE_2p5(1)  );
capacitor #(.c(7.246e-18)) (*
integer library_binding = "analogLib";

 *)
c1179 ( I_REXT_REF100, \4:PHASE_250(4)  );
capacitor #(.c(8.652e-18)) (*
integer library_binding = "analogLib";

 *)
c1180 ( I_REXT_REF100, \PHASE_250(4)  );
capacitor #(.c(3.141e-18)) (*
integer library_binding = "analogLib";

 *)
c1181 ( I_REXT_REF100, \3:MR_SQUELCH_RANGE_2p5(1)  );
capacitor #(.c(2.897e-16)) (*
integer library_binding = "analogLib";

 *)
c1182 ( I_REXT_REF100, \6:RX10_PRESENT_2p5  );
capacitor #(.c(6.864e-17)) (*
integer library_binding = "analogLib";

 *)
c1183 ( I_REXT_REF100, \PHASE_250(3)  );
capacitor #(.c(9.602e-17)) (*
integer library_binding = "analogLib";

 *)
c1184 ( I_REXT_REF100, \4:PHASE_250(3)  );
capacitor #(.c(1.741e-17)) (*
integer library_binding = "analogLib";

 *)
c1185 ( I_REXT_REF100, \7:X10_DIS_2p5  );
capacitor #(.c(9.509e-17)) (*
integer library_binding = "analogLib";

 *)
c1186 ( I_REXT_REF100, \2:I_REXT_50(1)  );
capacitor #(.c(1.741e-17)) (*
integer library_binding = "analogLib";

 *)
c1187 ( I_REXT_REF100, \PHASE_250(9)  );
capacitor #(.c(1.59e-17)) (*
integer library_binding = "analogLib";

 *)
c1188 ( I_REXT_REF100, MR_SQUELCH_DISB_2p5 );
capacitor #(.c(4.294e-14)) (*
integer library_binding = "analogLib";

 *)
c1189 ( I_REXT_REF100, GND );
capacitor #(.c(1.741e-17)) (*
integer library_binding = "analogLib";

 *)
c1190 ( I_REXT_REF100, \6:I_REXT_100_NC  );
capacitor #(.c(1.59e-17)) (*
integer library_binding = "analogLib";

 *)
c1191 ( I_REXT_REF100, BLW_DIS_2p5 );
capacitor #(.c(1.425e-17)) (*
integer library_binding = "analogLib";

 *)
c1192 ( I_REXT_REF100, TIMING_UP_ANLG );
capacitor #(.c(1.366e-17)) (*
integer library_binding = "analogLib";

 *)
c1193 ( I_REXT_REF100, RESET_DSP );
capacitor #(.c(3.902e-17)) (*
integer library_binding = "analogLib";

 *)
c1194 ( I_REXT_REF100, \25:GND  );
capacitor #(.c(7.69e-15)) (*
integer library_binding = "analogLib";

 *)
c1195 ( I_REXT_REF100, \4:I_RPOLY_REF100  );
capacitor #(.c(1.172e-17)) (*
integer library_binding = "analogLib";

 *)
c1196 ( I_REXT_REF100, \5:TIMING_DN_ANLG  );
capacitor #(.c(3.746e-15)) (*
integer library_binding = "analogLib";

 *)
c1197 ( \2:I_REXT_REF100 , \4:GND  );
capacitor #(.c(1.619e-17)) (*
integer library_binding = "analogLib";

 *)
c1198 ( \2:I_REXT_REF100 , \MLT3_TDATA_2p5(1)  );
capacitor #(.c(1.216e-18)) (*
integer library_binding = "analogLib";

 *)
c1199 ( \2:I_REXT_REF100 , \4:MLT3_TDATA_2p5(1)  );
capacitor #(.c(1.23e-18)) (*
integer library_binding = "analogLib";

 *)
c1200 ( \2:I_REXT_REF100 , \5:TENBT_FILTER_1p0(3)  );
capacitor #(.c(1.394e-17)) (*
integer library_binding = "analogLib";

 *)
c1201 ( \2:I_REXT_REF100 , \TENBT_FILTER_1p0(3)  );
capacitor #(.c(1.47e-17)) (*
integer library_binding = "analogLib";

 *)
c1202 ( \2:I_REXT_REF100 , \6:TENBT_FILTER_1p0(4)  );
capacitor #(.c(1.511e-17)) (*
integer library_binding = "analogLib";

 *)
c1203 ( \2:I_REXT_REF100 , RESET_10BT );
capacitor #(.c(1.482e-18)) (*
integer library_binding = "analogLib";

 *)
c1204 ( \2:I_REXT_REF100 , TP_DISC_2p5 );
capacitor #(.c(1.39e-18)) (*
integer library_binding = "analogLib";

 *)
c1205 ( \2:I_REXT_REF100 , \4:VDD  );
capacitor #(.c(6.665e-17)) (*
integer library_binding = "analogLib";

 *)
c1206 ( \2:I_REXT_REF100 , \9:VDD  );
capacitor #(.c(2.365e-18)) (*
integer library_binding = "analogLib";

 *)
c1207 ( \2:I_REXT_REF100 , \TENBT_FILTER_1p0(2)  );
capacitor #(.c(1.281e-17)) (*
integer library_binding = "analogLib";

 *)
c1208 ( \2:I_REXT_REF100 , \6:TENBT_FILTER_1p0(2)  );
capacitor #(.c(1.662e-20)) (*
integer library_binding = "analogLib";

 *)
c1209 ( \2:I_REXT_REF100 , \8:I_REXT_400_TX  );
capacitor #(.c(4.519e-19)) (*
integer library_binding = "analogLib";

 *)
c1210 ( \2:I_REXT_REF100 , \7:I_REXT_400_TX  );
capacitor #(.c(1.396e-17)) (*
integer library_binding = "analogLib";

 *)
c1211 ( \2:I_REXT_REF100 , \TENBT_FILTER_1p0(1)  );
capacitor #(.c(1.211e-18)) (*
integer library_binding = "analogLib";

 *)
c1212 ( \2:I_REXT_REF100 , \5:TENBT_FILTER_1p0(1)  );
capacitor #(.c(1.593e-17)) (*
integer library_binding = "analogLib";

 *)
c1213 ( \2:I_REXT_REF100 , \3:TP_DISC_2p5  );
capacitor #(.c(1.681e-18)) (*
integer library_binding = "analogLib";

 *)
c1214 ( \2:I_REXT_REF100 , \TENBT_FILTER_1p0(0)  );
capacitor #(.c(1.349e-17)) (*
integer library_binding = "analogLib";

 *)
c1215 ( \2:I_REXT_REF100 , \6:TENBT_FILTER_1p0(0)  );
capacitor #(.c(2.705e-18)) (*
integer library_binding = "analogLib";

 *)
c1216 ( \2:I_REXT_REF100 , TENBT_CLK160_1p0 );
capacitor #(.c(1.47e-17)) (*
integer library_binding = "analogLib";

 *)
c1217 ( \2:I_REXT_REF100 , \6:TENBT_CLK160_1p0  );
capacitor #(.c(2.49e-15)) (*
integer library_binding = "analogLib";

 *)
c1218 ( \2:I_REXT_REF100 , \11:I_RPOLY_REF100  );
capacitor #(.c(2.295e-18)) (*
integer library_binding = "analogLib";

 *)
c1219 ( \2:I_REXT_REF100 , \5:RESET_10BT  );
capacitor #(.c(1.209e-18)) (*
integer library_binding = "analogLib";

 *)
c1220 ( \2:I_REXT_REF100 , \MLT3_TDATA_2p5(0)  );
capacitor #(.c(1.62e-17)) (*
integer library_binding = "analogLib";

 *)
c1221 ( \2:I_REXT_REF100 , \3:MLT3_TDATA_2p5(0)  );
capacitor #(.c(2.711e-18)) (*
integer library_binding = "analogLib";

 *)
c1222 ( \2:I_REXT_REF100 , \TENBT_FILTER_1p0(4)  );
capacitor #(.c(6.739e-17)) (*
integer library_binding = "analogLib";

 *)
c1223 ( \2:I_REXT_REF100 , \26:GND  );
capacitor #(.c(5.772e-14)) (*
integer library_binding = "analogLib";

 *)
c1224 ( \2:I_REXT_REF100 , GND );
capacitor #(.c(1.484e-14)) (*
integer library_binding = "analogLib";

 *)
c1225 ( \2:I_REXT_REF100 , I_RPOLY_REF100 );
capacitor #(.c(1.327e-15)) (*
integer library_binding = "analogLib";

 *)
c1226 ( \7:I_REXT_REF100 , \4:GND  );
capacitor #(.c(7.497e-19)) (*
integer library_binding = "analogLib";

 *)
c1227 ( \7:I_REXT_REF100 , \8:I_REXT_400_TX  );
capacitor #(.c(2.039e-17)) (*
integer library_binding = "analogLib";

 *)
c1228 ( \7:I_REXT_REF100 , \7:I_REXT_400_TX  );
capacitor #(.c(1.196e-14)) (*
integer library_binding = "analogLib";

 *)
c1229 ( \7:I_REXT_REF100 , \11:I_RPOLY_REF100  );
capacitor #(.c(3.209e-16)) (*
integer library_binding = "analogLib";

 *)
c1230 ( \7:I_REXT_REF100 , I_RPOLY_REF100 );
capacitor #(.c(2.045e-14)) (*
integer library_binding = "analogLib";

 *)
c1231 ( \7:I_REXT_REF100 , GND );
capacitor #(.c(3.133e-16)) (*
integer library_binding = "analogLib";

 *)
c1232 ( \8:I_REXT_REF100 , \4:GND  );
capacitor #(.c(1.407e-17)) (*
integer library_binding = "analogLib";

 *)
c1233 ( \8:I_REXT_REF100 , \3:ADC_1p0(3)  );
capacitor #(.c(1.235e-16)) (*
integer library_binding = "analogLib";

 *)
c1234 ( \8:I_REXT_REF100 , \3:VDDRX  );
capacitor #(.c(1.407e-17)) (*
integer library_binding = "analogLib";

 *)
c1235 ( \8:I_REXT_REF100 , \3:ADC_1p0(4)  );
capacitor #(.c(3.121e-16)) (*
integer library_binding = "analogLib";

 *)
c1236 ( \8:I_REXT_REF100 , \6:VDD  );
capacitor #(.c(1.7e-16)) (*
integer library_binding = "analogLib";

 *)
c1237 ( \8:I_REXT_REF100 , \5:GND  );
capacitor #(.c(1.235e-16)) (*
integer library_binding = "analogLib";

 *)
c1238 ( \8:I_REXT_REF100 , \6:GNDRX  );
capacitor #(.c(1.243e-15)) (*
integer library_binding = "analogLib";

 *)
c1239 ( \8:I_REXT_REF100 , \4:RCLK125_1p0  );
capacitor #(.c(1.111e-17)) (*
integer library_binding = "analogLib";

 *)
c1240 ( \8:I_REXT_REF100 , \I_RPOLY_100(4)  );
capacitor #(.c(1.392e-17)) (*
integer library_binding = "analogLib";

 *)
c1241 ( \8:I_REXT_REF100 , \ADC_1p0(0)  );
capacitor #(.c(1.101e-17)) (*
integer library_binding = "analogLib";

 *)
c1242 ( \8:I_REXT_REF100 , \4:ADC_1p0(2)  );
capacitor #(.c(1.407e-17)) (*
integer library_binding = "analogLib";

 *)
c1243 ( \8:I_REXT_REF100 , \4:I_RPOLY_100(5)  );
capacitor #(.c(1.703e-17)) (*
integer library_binding = "analogLib";

 *)
c1244 ( \8:I_REXT_REF100 , \4:FLASH_1p0(0)  );
capacitor #(.c(1.518e-17)) (*
integer library_binding = "analogLib";

 *)
c1245 ( \8:I_REXT_REF100 , \ADC_1p0(5)  );
capacitor #(.c(7.382e-16)) (*
integer library_binding = "analogLib";

 *)
c1246 ( \8:I_REXT_REF100 , \4:I_RPOLY_REF100  );
capacitor #(.c(7.605e-19)) (*
integer library_binding = "analogLib";

 *)
c1247 ( \8:I_REXT_REF100 , \2:I_REXT_50(1)  );
capacitor #(.c(8.379e-18)) (*
integer library_binding = "analogLib";

 *)
c1248 ( \8:I_REXT_REF100 , \I_REXT_50(1)  );
capacitor #(.c(1.225e-17)) (*
integer library_binding = "analogLib";

 *)
c1249 ( \8:I_REXT_REF100 , \4:I_REXT_100(2)  );
capacitor #(.c(1.225e-17)) (*
integer library_binding = "analogLib";

 *)
c1250 ( \8:I_REXT_REF100 , \4:I_RPOLY_100(0)  );
capacitor #(.c(1.225e-17)) (*
integer library_binding = "analogLib";

 *)
c1251 ( \8:I_REXT_REF100 , \4:I_REXT_100(3)  );
capacitor #(.c(1.225e-17)) (*
integer library_binding = "analogLib";

 *)
c1252 ( \8:I_REXT_REF100 , \4:I_RPOLY_100(1)  );
capacitor #(.c(1.225e-17)) (*
integer library_binding = "analogLib";

 *)
c1253 ( \8:I_REXT_REF100 , \4:I_REXT_100(4)  );
capacitor #(.c(1.225e-17)) (*
integer library_binding = "analogLib";

 *)
c1254 ( \8:I_REXT_REF100 , \4:I_RPOLY_100(2)  );
capacitor #(.c(1.225e-17)) (*
integer library_binding = "analogLib";

 *)
c1255 ( \8:I_REXT_REF100 , \4:I_REXT_100(5)  );
capacitor #(.c(1.225e-17)) (*
integer library_binding = "analogLib";

 *)
c1256 ( \8:I_REXT_REF100 , \4:I_REXT_100(6)  );
capacitor #(.c(1.445e-17)) (*
integer library_binding = "analogLib";

 *)
c1257 ( \8:I_REXT_REF100 , \25:GND  );
capacitor #(.c(4.862e-15)) (*
integer library_binding = "analogLib";

 *)
c1258 ( \8:I_REXT_REF100 , GND );
capacitor #(.c(7.305e-15)) (*
integer library_binding = "analogLib";

 *)
c1259 ( \8:I_REXT_REF100 , \12:I_RPOLY_REF100  );
capacitor #(.c(6.767e-17)) (*
integer library_binding = "analogLib";

 *)
c1260 ( \PHASE_250(7) , \4:GND  );
capacitor #(.c(3.221e-16)) (*
integer library_binding = "analogLib";

 *)
c1261 ( \PHASE_250(7) , \PHASE_250(2)  );
capacitor #(.c(2.891e-16)) (*
integer library_binding = "analogLib";

 *)
c1262 ( \PHASE_250(7) , \4:PHASE_250(2)  );
capacitor #(.c(1.174e-19)) (*
integer library_binding = "analogLib";

 *)
c1263 ( \PHASE_250(7) , \MLT3_TDATA_2p5(1)  );
capacitor #(.c(1.088e-17)) (*
integer library_binding = "analogLib";

 *)
c1264 ( \PHASE_250(7) , \5:ADC_TEST_2p5  );
capacitor #(.c(1.451e-18)) (*
integer library_binding = "analogLib";

 *)
c1265 ( \PHASE_250(7) , \3:MR_SQUELCH_DISB_2p5  );
capacitor #(.c(1.009e-19)) (*
integer library_binding = "analogLib";

 *)
c1266 ( \PHASE_250(7) , \3:TP_DISC_2p5  );
capacitor #(.c(1.4e-18)) (*
integer library_binding = "analogLib";

 *)
c1267 ( \PHASE_250(7) , \9:TX100_DIS_2p5  );
capacitor #(.c(5.402e-18)) (*
integer library_binding = "analogLib";

 *)
c1268 ( \PHASE_250(7) , \2:TX100_DIS_2p5  );
capacitor #(.c(1.976e-17)) (*
integer library_binding = "analogLib";

 *)
c1269 ( \PHASE_250(7) , ADC_DIS_2p5 );
capacitor #(.c(1.803e-17)) (*
integer library_binding = "analogLib";

 *)
c1270 ( \PHASE_250(7) , \6:AEQ_DIS_2p5  );
capacitor #(.c(1.137e-17)) (*
integer library_binding = "analogLib";

 *)
c1271 ( \PHASE_250(7) , \2:I_REXT_50(0)  );
capacitor #(.c(1.137e-17)) (*
integer library_binding = "analogLib";

 *)
c1272 ( \PHASE_250(7) , \3:I_REXT_100_NC  );
capacitor #(.c(7.785e-18)) (*
integer library_binding = "analogLib";

 *)
c1273 ( \PHASE_250(7) , \4:I_RPOLY_REF100  );
capacitor #(.c(1.481e-17)) (*
integer library_binding = "analogLib";

 *)
c1274 ( \PHASE_250(7) , TP_DISC_2p5 );
capacitor #(.c(1.377e-17)) (*
integer library_binding = "analogLib";

 *)
c1275 ( \PHASE_250(7) , \4:MLT3_TDATA_2p5(1)  );
capacitor #(.c(1.382e-17)) (*
integer library_binding = "analogLib";

 *)
c1276 ( \PHASE_250(7) , \MLT3_TDATA_2p5(0)  );
capacitor #(.c(1.297e-19)) (*
integer library_binding = "analogLib";

 *)
c1277 ( \PHASE_250(7) , \3:MLT3_TDATA_2p5(0)  );
capacitor #(.c(1.185e-17)) (*
integer library_binding = "analogLib";

 *)
c1278 ( \PHASE_250(7) , \6:RX10_PRESENT_2p5  );
capacitor #(.c(1.591e-18)) (*
integer library_binding = "analogLib";

 *)
c1279 ( \PHASE_250(7) , \3:MR_SQUELCH_RANGE_2p5(1)  );
capacitor #(.c(2.847e-17)) (*
integer library_binding = "analogLib";

 *)
c1280 ( \PHASE_250(7) , \3:PHASE_250(9)  );
capacitor #(.c(2.368e-17)) (*
integer library_binding = "analogLib";

 *)
c1281 ( \PHASE_250(7) , \PHASE_250(4)  );
capacitor #(.c(1.983e-17)) (*
integer library_binding = "analogLib";

 *)
c1282 ( \PHASE_250(7) , \4:PHASE_250(4)  );
capacitor #(.c(8.259e-16)) (*
integer library_binding = "analogLib";

 *)
c1283 ( \PHASE_250(7) , ADC_TEST_2p5 );
capacitor #(.c(7.228e-18)) (*
integer library_binding = "analogLib";

 *)
c1284 ( \PHASE_250(7) , \MR_SQUELCH_RANGE_2p5(1)  );
capacitor #(.c(4.552e-18)) (*
integer library_binding = "analogLib";

 *)
c1285 ( \PHASE_250(7) , \PHASE_250(10)  );
capacitor #(.c(6.278e-18)) (*
integer library_binding = "analogLib";

 *)
c1286 ( \PHASE_250(7) , \4:PHASE_250(10)  );
capacitor #(.c(4.283e-18)) (*
integer library_binding = "analogLib";

 *)
c1287 ( \PHASE_250(7) , RCLK125_TST );
capacitor #(.c(5.797e-18)) (*
integer library_binding = "analogLib";

 *)
c1288 ( \PHASE_250(7) , \4:RCLK125_TST  );
capacitor #(.c(5.936e-19)) (*
integer library_binding = "analogLib";

 *)
c1289 ( \PHASE_250(7) , AEQ_DIS_2p5 );
capacitor #(.c(1.191e-16)) (*
integer library_binding = "analogLib";

 *)
c1290 ( \PHASE_250(7) , \4:PLL_160_IN  );
capacitor #(.c(7.56e-19)) (*
integer library_binding = "analogLib";

 *)
c1291 ( \PHASE_250(7) , \1:PLL_160_IN  );
capacitor #(.c(7.093e-18)) (*
integer library_binding = "analogLib";

 *)
c1292 ( \PHASE_250(7) , \4:MR_SQUELCH_RANGE_2p5(0)  );
capacitor #(.c(2.177e-18)) (*
integer library_binding = "analogLib";

 *)
c1293 ( \PHASE_250(7) , \MR_SQUELCH_RANGE_2p5(0)  );
capacitor #(.c(7.356e-20)) (*
integer library_binding = "analogLib";

 *)
c1294 ( \PHASE_250(7) , \3:XTAL25  );
capacitor #(.c(1.766e-17)) (*
integer library_binding = "analogLib";

 *)
c1295 ( \PHASE_250(7) , \6:XTAL25  );
capacitor #(.c(1.019e-17)) (*
integer library_binding = "analogLib";

 *)
c1296 ( \PHASE_250(7) , \PHASE_250(9)  );
capacitor #(.c(1.136e-16)) (*
integer library_binding = "analogLib";

 *)
c1297 ( \PHASE_250(7) , \4:PHASE_250(6)  );
capacitor #(.c(4.028e-19)) (*
integer library_binding = "analogLib";

 *)
c1298 ( \PHASE_250(7) , RX10_PRESENT_2p5 );
capacitor #(.c(2.832e-19)) (*
integer library_binding = "analogLib";

 *)
c1299 ( \PHASE_250(7) , \5:ADC_DIS_2p5  );
capacitor #(.c(1.517e-17)) (*
integer library_binding = "analogLib";

 *)
c1300 ( \PHASE_250(7) , \6:I_REXT_50(1)  );
capacitor #(.c(1.611e-19)) (*
integer library_binding = "analogLib";

 *)
c1301 ( \PHASE_250(7) , \2:I_REXT_50(1)  );
capacitor #(.c(1.863e-17)) (*
integer library_binding = "analogLib";

 *)
c1302 ( \PHASE_250(7) , BLW_DIS_2p5 );
capacitor #(.c(1.471e-18)) (*
integer library_binding = "analogLib";

 *)
c1303 ( \PHASE_250(7) , \5:BLW_DIS_2p5  );
capacitor #(.c(1.311e-17)) (*
integer library_binding = "analogLib";

 *)
c1304 ( \PHASE_250(7) , MR_SQUELCH_DISB_2p5 );
capacitor #(.c(1.047e-15)) (*
integer library_binding = "analogLib";

 *)
c1305 ( \PHASE_250(7) , GND );
capacitor #(.c(1.058e-17)) (*
integer library_binding = "analogLib";

 *)
c1306 ( \PHASE_250(7) , \3:X10_DIS_2p5  );
capacitor #(.c(6.534e-16)) (*
integer library_binding = "analogLib";

 *)
c1307 ( \PHASE_250(7) , \PHASE_250(6)  );
capacitor #(.c(6.663e-17)) (*
integer library_binding = "analogLib";

 *)
c1308 ( \4:PHASE_250(7) , \4:GND  );
capacitor #(.c(5.504e-16)) (*
integer library_binding = "analogLib";

 *)
c1309 ( \4:PHASE_250(7) , \PHASE_250(2)  );
capacitor #(.c(1.01e-15)) (*
integer library_binding = "analogLib";

 *)
c1310 ( \4:PHASE_250(7) , \4:PHASE_250(2)  );
capacitor #(.c(9.125e-20)) (*
integer library_binding = "analogLib";

 *)
c1311 ( \4:PHASE_250(7) , \MLT3_TDATA_2p5(1)  );
capacitor #(.c(8.453e-18)) (*
integer library_binding = "analogLib";

 *)
c1312 ( \4:PHASE_250(7) , \5:ADC_TEST_2p5  );
capacitor #(.c(7.839e-20)) (*
integer library_binding = "analogLib";

 *)
c1313 ( \4:PHASE_250(7) , \3:TP_DISC_2p5  );
capacitor #(.c(1.088e-18)) (*
integer library_binding = "analogLib";

 *)
c1314 ( \4:PHASE_250(7) , \9:TX100_DIS_2p5  );
capacitor #(.c(4.199e-18)) (*
integer library_binding = "analogLib";

 *)
c1315 ( \4:PHASE_250(7) , \2:TX100_DIS_2p5  );
capacitor #(.c(1.159e-16)) (*
integer library_binding = "analogLib";

 *)
c1316 ( \4:PHASE_250(7) , \PHASE_250(6)  );
capacitor #(.c(1.536e-17)) (*
integer library_binding = "analogLib";

 *)
c1317 ( \4:PHASE_250(7) , ADC_DIS_2p5 );
capacitor #(.c(1.402e-17)) (*
integer library_binding = "analogLib";

 *)
c1318 ( \4:PHASE_250(7) , \6:AEQ_DIS_2p5  );
capacitor #(.c(8.839e-18)) (*
integer library_binding = "analogLib";

 *)
c1319 ( \4:PHASE_250(7) , \2:I_REXT_50(0)  );
capacitor #(.c(8.839e-18)) (*
integer library_binding = "analogLib";

 *)
c1320 ( \4:PHASE_250(7) , \3:I_REXT_100_NC  );
capacitor #(.c(6.051e-18)) (*
integer library_binding = "analogLib";

 *)
c1321 ( \4:PHASE_250(7) , \4:I_RPOLY_REF100  );
capacitor #(.c(5.64e-18)) (*
integer library_binding = "analogLib";

 *)
c1322 ( \4:PHASE_250(7) , BLW_DIS_2p5 );
capacitor #(.c(1.151e-17)) (*
integer library_binding = "analogLib";

 *)
c1323 ( \4:PHASE_250(7) , TP_DISC_2p5 );
capacitor #(.c(1.07e-17)) (*
integer library_binding = "analogLib";

 *)
c1324 ( \4:PHASE_250(7) , \4:MLT3_TDATA_2p5(1)  );
capacitor #(.c(1.074e-17)) (*
integer library_binding = "analogLib";

 *)
c1325 ( \4:PHASE_250(7) , \MLT3_TDATA_2p5(0)  );
capacitor #(.c(1.009e-19)) (*
integer library_binding = "analogLib";

 *)
c1326 ( \4:PHASE_250(7) , \3:MLT3_TDATA_2p5(0)  );
capacitor #(.c(1.237e-18)) (*
integer library_binding = "analogLib";

 *)
c1327 ( \4:PHASE_250(7) , \3:MR_SQUELCH_RANGE_2p5(1)  );
capacitor #(.c(2.213e-17)) (*
integer library_binding = "analogLib";

 *)
c1328 ( \4:PHASE_250(7) , \3:PHASE_250(9)  );
capacitor #(.c(1.84e-17)) (*
integer library_binding = "analogLib";

 *)
c1329 ( \4:PHASE_250(7) , \PHASE_250(4)  );
capacitor #(.c(1.541e-17)) (*
integer library_binding = "analogLib";

 *)
c1330 ( \4:PHASE_250(7) , \4:PHASE_250(4)  );
capacitor #(.c(6.42e-16)) (*
integer library_binding = "analogLib";

 *)
c1331 ( \4:PHASE_250(7) , ADC_TEST_2p5 );
capacitor #(.c(3.329e-18)) (*
integer library_binding = "analogLib";

 *)
c1332 ( \4:PHASE_250(7) , RCLK125_TST );
capacitor #(.c(4.614e-19)) (*
integer library_binding = "analogLib";

 *)
c1333 ( \4:PHASE_250(7) , AEQ_DIS_2p5 );
capacitor #(.c(9.259e-17)) (*
integer library_binding = "analogLib";

 *)
c1334 ( \4:PHASE_250(7) , \4:PLL_160_IN  );
capacitor #(.c(5.876e-19)) (*
integer library_binding = "analogLib";

 *)
c1335 ( \4:PHASE_250(7) , \1:PLL_160_IN  );
capacitor #(.c(1.692e-18)) (*
integer library_binding = "analogLib";

 *)
c1336 ( \4:PHASE_250(7) , \MR_SQUELCH_RANGE_2p5(0)  );
capacitor #(.c(8.833e-17)) (*
integer library_binding = "analogLib";

 *)
c1337 ( \4:PHASE_250(7) , \4:PHASE_250(6)  );
capacitor #(.c(3.131e-19)) (*
integer library_binding = "analogLib";

 *)
c1338 ( \4:PHASE_250(7) , RX10_PRESENT_2p5 );
capacitor #(.c(2.201e-19)) (*
integer library_binding = "analogLib";

 *)
c1339 ( \4:PHASE_250(7) , \5:ADC_DIS_2p5  );
capacitor #(.c(3.768e-17)) (*
integer library_binding = "analogLib";

 *)
c1340 ( \4:PHASE_250(7) , \MR_SQUELCH_RANGE_2p5(1)  );
capacitor #(.c(1.832e-17)) (*
integer library_binding = "analogLib";

 *)
c1341 ( \4:PHASE_250(7) , \6:RX10_PRESENT_2p5  );
capacitor #(.c(2.341e-17)) (*
integer library_binding = "analogLib";

 *)
c1342 ( \4:PHASE_250(7) , \PHASE_250(9)  );
capacitor #(.c(1.666e-17)) (*
integer library_binding = "analogLib";

 *)
c1343 ( \4:PHASE_250(7) , MR_SQUELCH_DISB_2p5 );
capacitor #(.c(4.113e-17)) (*
integer library_binding = "analogLib";

 *)
c1344 ( \4:PHASE_250(7) , \4:RCLK125_TST  );
capacitor #(.c(2.101e-17)) (*
integer library_binding = "analogLib";

 *)
c1345 ( \4:PHASE_250(7) , \4:MR_SQUELCH_RANGE_2p5(0)  );
capacitor #(.c(1.938e-17)) (*
integer library_binding = "analogLib";

 *)
c1346 ( \4:PHASE_250(7) , \4:PHASE_250(10)  );
capacitor #(.c(4.53e-18)) (*
integer library_binding = "analogLib";

 *)
c1347 ( \4:PHASE_250(7) , \PHASE_250(10)  );
capacitor #(.c(1.033e-18)) (*
integer library_binding = "analogLib";

 *)
c1348 ( \4:PHASE_250(7) , \3:XTAL25  );
capacitor #(.c(2.48e-16)) (*
integer library_binding = "analogLib";

 *)
c1349 ( \4:PHASE_250(7) , \6:XTAL25  );
capacitor #(.c(1.034e-15)) (*
integer library_binding = "analogLib";

 *)
c1350 ( \4:PHASE_250(7) , GND );
capacitor #(.c(7.583e-16)) (*
integer library_binding = "analogLib";

 *)
c1351 ( \3:I_REXT_100_NC , \4:GND  );
capacitor #(.c(1.118e-17)) (*
integer library_binding = "analogLib";

 *)
c1352 ( \3:I_REXT_100_NC , \PHASE_250(2)  );
capacitor #(.c(8.135e-18)) (*
integer library_binding = "analogLib";

 *)
c1353 ( \3:I_REXT_100_NC , \4:PHASE_250(2)  );
capacitor #(.c(1.4e-18)) (*
integer library_binding = "analogLib";

 *)
c1354 ( \3:I_REXT_100_NC , \WANDER_CNT(4)  );
capacitor #(.c(2.741e-17)) (*
integer library_binding = "analogLib";

 *)
c1355 ( \3:I_REXT_100_NC , \4:PHASE_250(8)  );
capacitor #(.c(2.405e-17)) (*
integer library_binding = "analogLib";

 *)
c1356 ( \3:I_REXT_100_NC , \PHASE_250(8)  );
capacitor #(.c(1.316e-18)) (*
integer library_binding = "analogLib";

 *)
c1357 ( \3:I_REXT_100_NC , \AEQ_CNT_ANLG(1)  );
capacitor #(.c(9.966e-19)) (*
integer library_binding = "analogLib";

 *)
c1358 ( \3:I_REXT_100_NC , \4:WANDER_CNT(5)  );
capacitor #(.c(1.203e-17)) (*
integer library_binding = "analogLib";

 *)
c1359 ( \3:I_REXT_100_NC , \WANDER_CNT(5)  );
capacitor #(.c(2.172e-18)) (*
integer library_binding = "analogLib";

 *)
c1360 ( \3:I_REXT_100_NC , \5:ADC_TEST_2p5  );
capacitor #(.c(8.001e-19)) (*
integer library_binding = "analogLib";

 *)
c1361 ( \3:I_REXT_100_NC , \WANDER_CNT(2)  );
capacitor #(.c(1.623e-17)) (*
integer library_binding = "analogLib";

 *)
c1362 ( \3:I_REXT_100_NC , \5:WANDER_CNT(2)  );
capacitor #(.c(1.622e-18)) (*
integer library_binding = "analogLib";

 *)
c1363 ( \3:I_REXT_100_NC , \AEQ_CNT_ANLG(4)  );
capacitor #(.c(1.185e-17)) (*
integer library_binding = "analogLib";

 *)
c1364 ( \3:I_REXT_100_NC , \3:PHASE_250(1)  );
capacitor #(.c(7.467e-18)) (*
integer library_binding = "analogLib";

 *)
c1365 ( \3:I_REXT_100_NC , \PHASE_250(1)  );
capacitor #(.c(4.446e-18)) (*
integer library_binding = "analogLib";

 *)
c1366 ( \3:I_REXT_100_NC , \9:TX100_DIS_2p5  );
capacitor #(.c(1.716e-17)) (*
integer library_binding = "analogLib";

 *)
c1367 ( \3:I_REXT_100_NC , \2:TX100_DIS_2p5  );
capacitor #(.c(1.402e-18)) (*
integer library_binding = "analogLib";

 *)
c1368 ( \3:I_REXT_100_NC , \4:AEQ_CNT_ANLG(2)  );
capacitor #(.c(1.538e-17)) (*
integer library_binding = "analogLib";

 *)
c1369 ( \3:I_REXT_100_NC , \AEQ_CNT_ANLG(2)  );
capacitor #(.c(2.129e-18)) (*
integer library_binding = "analogLib";

 *)
c1370 ( \3:I_REXT_100_NC , \5:ADC_DIS_2p5  );
capacitor #(.c(1.296e-17)) (*
integer library_binding = "analogLib";

 *)
c1371 ( \3:I_REXT_100_NC , \WANDER_CNT(0)  );
capacitor #(.c(9.899e-19)) (*
integer library_binding = "analogLib";

 *)
c1372 ( \3:I_REXT_100_NC , \4:WANDER_CNT(0)  );
capacitor #(.c(2.278e-16)) (*
integer library_binding = "analogLib";

 *)
c1373 ( \3:I_REXT_100_NC , \24:VDDTX  );
capacitor #(.c(1.196e-15)) (*
integer library_binding = "analogLib";

 *)
c1374 ( \3:I_REXT_100_NC , \25:VDDTX  );
capacitor #(.c(4.021e-18)) (*
integer library_binding = "analogLib";

 *)
c1375 ( \3:I_REXT_100_NC , RX10_PRESENT_2p5 );
capacitor #(.c(1.064e-17)) (*
integer library_binding = "analogLib";

 *)
c1376 ( \3:I_REXT_100_NC , \PHASE_250(6)  );
capacitor #(.c(9.568e-18)) (*
integer library_binding = "analogLib";

 *)
c1377 ( \3:I_REXT_100_NC , \4:PHASE_250(6)  );
capacitor #(.c(1.275e-17)) (*
integer library_binding = "analogLib";

 *)
c1378 ( \3:I_REXT_100_NC , ADC_DIS_2p5 );
capacitor #(.c(1.587e-17)) (*
integer library_binding = "analogLib";

 *)
c1379 ( \3:I_REXT_100_NC , \AEQ_CNT_ANLG(0)  );
capacitor #(.c(1.158e-18)) (*
integer library_binding = "analogLib";

 *)
c1380 ( \3:I_REXT_100_NC , \4:AEQ_CNT_ANLG(0)  );
capacitor #(.c(1.01e-18)) (*
integer library_binding = "analogLib";

 *)
c1381 ( \3:I_REXT_100_NC , \WANDER_CNT(1)  );
capacitor #(.c(6.619e-17)) (*
integer library_binding = "analogLib";

 *)
c1382 ( \3:I_REXT_100_NC , \MR_SQUELCH_RANGE_2p5(0)  );
capacitor #(.c(1.651e-17)) (*
integer library_binding = "analogLib";

 *)
c1383 ( \3:I_REXT_100_NC , \6:RX10_PRESENT_2p5  );
capacitor #(.c(1.72e-17)) (*
integer library_binding = "analogLib";

 *)
c1384 ( \3:I_REXT_100_NC , \5:WANDER_CNT(6)  );
capacitor #(.c(1.16e-18)) (*
integer library_binding = "analogLib";

 *)
c1385 ( \3:I_REXT_100_NC , \WANDER_CNT(6)  );
capacitor #(.c(1.311e-17)) (*
integer library_binding = "analogLib";

 *)
c1386 ( \3:I_REXT_100_NC , \5:WANDER_CNT(1)  );
capacitor #(.c(2.928e-16)) (*
integer library_binding = "analogLib";

 *)
c1387 ( \3:I_REXT_100_NC , \4:MR_SQUELCH_RANGE_2p5(0)  );
capacitor #(.c(1.008e-18)) (*
integer library_binding = "analogLib";

 *)
c1388 ( \3:I_REXT_100_NC , AEQ_DIS_2p5 );
capacitor #(.c(1.831e-17)) (*
integer library_binding = "analogLib";

 *)
c1389 ( \3:I_REXT_100_NC , \6:AEQ_DIS_2p5  );
capacitor #(.c(6.923e-18)) (*
integer library_binding = "analogLib";

 *)
c1390 ( \3:I_REXT_100_NC , \4:RCLK125_TST  );
capacitor #(.c(1.312e-17)) (*
integer library_binding = "analogLib";

 *)
c1391 ( \3:I_REXT_100_NC , RCLK125_TST );
capacitor #(.c(5.115e-16)) (*
integer library_binding = "analogLib";

 *)
c1392 ( \3:I_REXT_100_NC , \PHASE_250(5)  );
capacitor #(.c(1.248e-17)) (*
integer library_binding = "analogLib";

 *)
c1393 ( \3:I_REXT_100_NC , \3:RCLK125_TST_SEL  );
capacitor #(.c(7.526e-18)) (*
integer library_binding = "analogLib";

 *)
c1394 ( \3:I_REXT_100_NC , RCLK125_TST_SEL );
capacitor #(.c(1.211e-15)) (*
integer library_binding = "analogLib";

 *)
c1395 ( \3:I_REXT_100_NC , \23:GNDTX  );
capacitor #(.c(5.033e-16)) (*
integer library_binding = "analogLib";

 *)
c1396 ( \3:I_REXT_100_NC , \22:GNDTX  );
capacitor #(.c(1.129e-17)) (*
integer library_binding = "analogLib";

 *)
c1397 ( \3:I_REXT_100_NC , \4:PHASE_250(10)  );
capacitor #(.c(1.032e-17)) (*
integer library_binding = "analogLib";

 *)
c1398 ( \3:I_REXT_100_NC , \PHASE_250(10)  );
capacitor #(.c(8.761e-16)) (*
integer library_binding = "analogLib";

 *)
c1399 ( \3:I_REXT_100_NC , \4:PHASE_250(5)  );
capacitor #(.c(1.496e-17)) (*
integer library_binding = "analogLib";

 *)
c1400 ( \3:I_REXT_100_NC , \5:AEQ_CNT_ANLG(1)  );
capacitor #(.c(1.446e-17)) (*
integer library_binding = "analogLib";

 *)
c1401 ( \3:I_REXT_100_NC , \MR_SQUELCH_RANGE_2p5(1)  );
capacitor #(.c(1.233e-17)) (*
integer library_binding = "analogLib";

 *)
c1402 ( \3:I_REXT_100_NC , ADC_TEST_2p5 );
capacitor #(.c(8.803e-18)) (*
integer library_binding = "analogLib";

 *)
c1403 ( \3:I_REXT_100_NC , \4:PHASE_250(4)  );
capacitor #(.c(1.051e-17)) (*
integer library_binding = "analogLib";

 *)
c1404 ( \3:I_REXT_100_NC , \PHASE_250(4)  );
capacitor #(.c(1.165e-18)) (*
integer library_binding = "analogLib";

 *)
c1405 ( \3:I_REXT_100_NC , \4:WANDER_CNT(3)  );
capacitor #(.c(5.569e-18)) (*
integer library_binding = "analogLib";

 *)
c1406 ( \3:I_REXT_100_NC , \3:MR_SQUELCH_RANGE_2p5(1)  );
capacitor #(.c(1.213e-17)) (*
integer library_binding = "analogLib";

 *)
c1407 ( \3:I_REXT_100_NC , \PHASE_250(3)  );
capacitor #(.c(7.189e-18)) (*
integer library_binding = "analogLib";

 *)
c1408 ( \3:I_REXT_100_NC , \4:PHASE_250(3)  );
capacitor #(.c(1.646e-17)) (*
integer library_binding = "analogLib";

 *)
c1409 ( \3:I_REXT_100_NC , \5:WANDER_CNT(4)  );
capacitor #(.c(1.449e-17)) (*
integer library_binding = "analogLib";

 *)
c1410 ( \3:I_REXT_100_NC , \WANDER_CNT(3)  );
capacitor #(.c(1.51e-17)) (*
integer library_binding = "analogLib";

 *)
c1411 ( \3:I_REXT_100_NC , \5:AEQ_CNT_ANLG(4)  );
capacitor #(.c(1.764e-17)) (*
integer library_binding = "analogLib";

 *)
c1412 ( \3:I_REXT_100_NC , \5:BASEFX_DIS  );
capacitor #(.c(2.004e-17)) (*
integer library_binding = "analogLib";

 *)
c1413 ( \3:I_REXT_100_NC , RESET_DSP );
capacitor #(.c(1.335e-17)) (*
integer library_binding = "analogLib";

 *)
c1414 ( \3:I_REXT_100_NC , \2:I_REXT_50(0)  );
capacitor #(.c(1.931e-17)) (*
integer library_binding = "analogLib";

 *)
c1415 ( \3:I_REXT_100_NC , BLW_DIS_2p5 );
capacitor #(.c(1.931e-17)) (*
integer library_binding = "analogLib";

 *)
c1416 ( \3:I_REXT_100_NC , MR_SQUELCH_DISB_2p5 );
capacitor #(.c(2.161e-17)) (*
integer library_binding = "analogLib";

 *)
c1417 ( \3:I_REXT_100_NC , \7:X10_DIS_2p5  );
capacitor #(.c(2.024e-17)) (*
integer library_binding = "analogLib";

 *)
c1418 ( \3:I_REXT_100_NC , TIMING_UP_ANLG );
capacitor #(.c(1.868e-17)) (*
integer library_binding = "analogLib";

 *)
c1419 ( \3:I_REXT_100_NC , \5:TIMING_DN_ANLG  );
capacitor #(.c(1.171e-14)) (*
integer library_binding = "analogLib";

 *)
c1420 ( \3:I_REXT_100_NC , GND );
capacitor #(.c(1.05e-17)) (*
integer library_binding = "analogLib";

 *)
c1421 ( \3:I_REXT_100_NC , MR_BYPASS10RX_FILTER );
capacitor #(.c(1.876e-17)) (*
integer library_binding = "analogLib";

 *)
c1422 ( \3:I_REXT_100_NC , \PHASE_250(9)  );
capacitor #(.c(3.167e-16)) (*
integer library_binding = "analogLib";

 *)
c1423 ( \9:I_REXT_100_NC , \4:GND  );
capacitor #(.c(4.88e-15)) (*
integer library_binding = "analogLib";

 *)
c1424 ( \9:I_REXT_100_NC , GND );
capacitor #(.c(1.215e-15)) (*
integer library_binding = "analogLib";

 *)
c1425 ( \6:I_REXT_100_NC , \4:GND  );
capacitor #(.c(1.272e-17)) (*
integer library_binding = "analogLib";

 *)
c1426 ( \6:I_REXT_100_NC , POS_DETECT_2p5 );
capacitor #(.c(8.886e-18)) (*
integer library_binding = "analogLib";

 *)
c1427 ( \6:I_REXT_100_NC , \5:POS_DETECT_2p5  );
capacitor #(.c(9.132e-18)) (*
integer library_binding = "analogLib";

 *)
c1428 ( \6:I_REXT_100_NC , NEG_DETECT_2p5 );
capacitor #(.c(1.247e-17)) (*
integer library_binding = "analogLib";

 *)
c1429 ( \6:I_REXT_100_NC , \4:NEG_DETECT_2p5  );
capacitor #(.c(4.668e-17)) (*
integer library_binding = "analogLib";

 *)
c1430 ( \6:I_REXT_100_NC , \6:GNDRX  );
capacitor #(.c(3.79e-17)) (*
integer library_binding = "analogLib";

 *)
c1431 ( \6:I_REXT_100_NC , \5:GND  );
capacitor #(.c(4.668e-17)) (*
integer library_binding = "analogLib";

 *)
c1432 ( \6:I_REXT_100_NC , \3:VDDRX  );
capacitor #(.c(3.253e-18)) (*
integer library_binding = "analogLib";

 *)
c1433 ( \6:I_REXT_100_NC , \4:ADC_1p0(2)  );
capacitor #(.c(6.955e-18)) (*
integer library_binding = "analogLib";

 *)
c1434 ( \6:I_REXT_100_NC , \6:VDD  );
capacitor #(.c(4.668e-17)) (*
integer library_binding = "analogLib";

 *)
c1435 ( \6:I_REXT_100_NC , \27:GND  );
capacitor #(.c(2.996e-18)) (*
integer library_binding = "analogLib";

 *)
c1436 ( \6:I_REXT_100_NC , \ADC_1p0(5)  );
capacitor #(.c(2.144e-18)) (*
integer library_binding = "analogLib";

 *)
c1437 ( \6:I_REXT_100_NC , \4:RCLK125_1p0  );
capacitor #(.c(3.005e-18)) (*
integer library_binding = "analogLib";

 *)
c1438 ( \6:I_REXT_100_NC , \4:FLASH_1p0(1)  );
capacitor #(.c(2.763e-18)) (*
integer library_binding = "analogLib";

 *)
c1439 ( \6:I_REXT_100_NC , \ADC_1p0(0)  );
capacitor #(.c(4.668e-17)) (*
integer library_binding = "analogLib";

 *)
c1440 ( \6:I_REXT_100_NC , \12:VDD  );
capacitor #(.c(1.983e-17)) (*
integer library_binding = "analogLib";

 *)
c1441 ( \6:I_REXT_100_NC , \7:I_REXT_50(0)  );
capacitor #(.c(1.343e-19)) (*
integer library_binding = "analogLib";

 *)
c1442 ( \6:I_REXT_100_NC , \I_RPOLY_100(4)  );
capacitor #(.c(1.8e-19)) (*
integer library_binding = "analogLib";

 *)
c1443 ( \6:I_REXT_100_NC , \3:ADC_1p0(4)  );
capacitor #(.c(1.331e-19)) (*
integer library_binding = "analogLib";

 *)
c1444 ( \6:I_REXT_100_NC , \4:I_RPOLY_100(3)  );
capacitor #(.c(1.8e-19)) (*
integer library_binding = "analogLib";

 *)
c1445 ( \6:I_REXT_100_NC , \3:ADC_1p0(3)  );
capacitor #(.c(1.331e-19)) (*
integer library_binding = "analogLib";

 *)
c1446 ( \6:I_REXT_100_NC , \4:I_RPOLY_100(2)  );
capacitor #(.c(1.331e-19)) (*
integer library_binding = "analogLib";

 *)
c1447 ( \6:I_REXT_100_NC , \4:I_REXT_100(6)  );
capacitor #(.c(1.331e-19)) (*
integer library_binding = "analogLib";

 *)
c1448 ( \6:I_REXT_100_NC , \4:I_RPOLY_100(1)  );
capacitor #(.c(1.331e-19)) (*
integer library_binding = "analogLib";

 *)
c1449 ( \6:I_REXT_100_NC , \4:I_REXT_100(5)  );
capacitor #(.c(1.952e-19)) (*
integer library_binding = "analogLib";

 *)
c1450 ( \6:I_REXT_100_NC , \4:FLASH_1p0(0)  );
capacitor #(.c(1.331e-19)) (*
integer library_binding = "analogLib";

 *)
c1451 ( \6:I_REXT_100_NC , \4:I_RPOLY_100(0)  );
capacitor #(.c(1.331e-19)) (*
integer library_binding = "analogLib";

 *)
c1452 ( \6:I_REXT_100_NC , \4:I_REXT_100(4)  );
capacitor #(.c(1.331e-19)) (*
integer library_binding = "analogLib";

 *)
c1453 ( \6:I_REXT_100_NC , \4:I_REXT_100(3)  );
capacitor #(.c(1.897e-19)) (*
integer library_binding = "analogLib";

 *)
c1454 ( \6:I_REXT_100_NC , \4:I_RPOLY_100(5)  );
capacitor #(.c(1.331e-19)) (*
integer library_binding = "analogLib";

 *)
c1455 ( \6:I_REXT_100_NC , \4:I_REXT_100(2)  );
capacitor #(.c(1.872e-14)) (*
integer library_binding = "analogLib";

 *)
c1456 ( \6:I_REXT_100_NC , GND );
capacitor #(.c(4.722e-17)) (*
integer library_binding = "analogLib";

 *)
c1457 ( \6:I_REXT_100_NC , \25:GND  );
capacitor #(.c(1.741e-17)) (*
integer library_binding = "analogLib";

 *)
c1458 ( \6:I_REXT_100_NC , \4:I_RPOLY_REF100  );
capacitor #(.c(2.409e-17)) (*
integer library_binding = "analogLib";

 *)
c1459 ( \6:I_REXT_100_NC , \I_REXT_50(0)  );
capacitor #(.c(4.93e-16)) (*
integer library_binding = "analogLib";

 *)
c1460 ( \10:I_REXT_100_NC , \4:GND  );
capacitor #(.c(2.031e-16)) (*
integer library_binding = "analogLib";

 *)
c1461 ( \10:I_REXT_100_NC , \6:GNDRX  );
capacitor #(.c(1.649e-16)) (*
integer library_binding = "analogLib";

 *)
c1462 ( \10:I_REXT_100_NC , \5:GND  );
capacitor #(.c(2.031e-16)) (*
integer library_binding = "analogLib";

 *)
c1463 ( \10:I_REXT_100_NC , \3:VDDRX  );
capacitor #(.c(1.416e-17)) (*
integer library_binding = "analogLib";

 *)
c1464 ( \10:I_REXT_100_NC , \4:ADC_1p0(2)  );
capacitor #(.c(3.026e-17)) (*
integer library_binding = "analogLib";

 *)
c1465 ( \10:I_REXT_100_NC , \6:VDD  );
capacitor #(.c(2.031e-16)) (*
integer library_binding = "analogLib";

 *)
c1466 ( \10:I_REXT_100_NC , \27:GND  );
capacitor #(.c(1.304e-17)) (*
integer library_binding = "analogLib";

 *)
c1467 ( \10:I_REXT_100_NC , \ADC_1p0(5)  );
capacitor #(.c(9.33e-18)) (*
integer library_binding = "analogLib";

 *)
c1468 ( \10:I_REXT_100_NC , \4:RCLK125_1p0  );
capacitor #(.c(1.308e-17)) (*
integer library_binding = "analogLib";

 *)
c1469 ( \10:I_REXT_100_NC , \4:FLASH_1p0(1)  );
capacitor #(.c(1.202e-17)) (*
integer library_binding = "analogLib";

 *)
c1470 ( \10:I_REXT_100_NC , \ADC_1p0(0)  );
capacitor #(.c(2.031e-16)) (*
integer library_binding = "analogLib";

 *)
c1471 ( \10:I_REXT_100_NC , \12:VDD  );
capacitor #(.c(9.933e-18)) (*
integer library_binding = "analogLib";

 *)
c1472 ( \10:I_REXT_100_NC , \4:I_REXT_100(2)  );
capacitor #(.c(1.415e-17)) (*
integer library_binding = "analogLib";

 *)
c1473 ( \10:I_REXT_100_NC , \4:I_RPOLY_100(5)  );
capacitor #(.c(9.933e-18)) (*
integer library_binding = "analogLib";

 *)
c1474 ( \10:I_REXT_100_NC , \4:I_REXT_100(3)  );
capacitor #(.c(9.933e-18)) (*
integer library_binding = "analogLib";

 *)
c1475 ( \10:I_REXT_100_NC , \4:I_REXT_100(4)  );
capacitor #(.c(9.933e-18)) (*
integer library_binding = "analogLib";

 *)
c1476 ( \10:I_REXT_100_NC , \4:I_RPOLY_100(0)  );
capacitor #(.c(2.113e-17)) (*
integer library_binding = "analogLib";

 *)
c1477 ( \10:I_REXT_100_NC , \25:GND  );
capacitor #(.c(1.456e-17)) (*
integer library_binding = "analogLib";

 *)
c1478 ( \10:I_REXT_100_NC , \4:FLASH_1p0(0)  );
capacitor #(.c(9.933e-18)) (*
integer library_binding = "analogLib";

 *)
c1479 ( \10:I_REXT_100_NC , \4:I_REXT_100(5)  );
capacitor #(.c(9.933e-18)) (*
integer library_binding = "analogLib";

 *)
c1480 ( \10:I_REXT_100_NC , \4:I_RPOLY_100(1)  );
capacitor #(.c(9.933e-18)) (*
integer library_binding = "analogLib";

 *)
c1481 ( \10:I_REXT_100_NC , \4:I_REXT_100(6)  );
capacitor #(.c(9.933e-18)) (*
integer library_binding = "analogLib";

 *)
c1482 ( \10:I_REXT_100_NC , \4:I_RPOLY_100(2)  );
capacitor #(.c(1.343e-17)) (*
integer library_binding = "analogLib";

 *)
c1483 ( \10:I_REXT_100_NC , \3:ADC_1p0(3)  );
capacitor #(.c(9.933e-18)) (*
integer library_binding = "analogLib";

 *)
c1484 ( \10:I_REXT_100_NC , \4:I_RPOLY_100(3)  );
capacitor #(.c(1.343e-17)) (*
integer library_binding = "analogLib";

 *)
c1485 ( \10:I_REXT_100_NC , \3:ADC_1p0(4)  );
capacitor #(.c(1.002e-17)) (*
integer library_binding = "analogLib";

 *)
c1486 ( \10:I_REXT_100_NC , \I_RPOLY_100(4)  );
capacitor #(.c(1.363e-17)) (*
integer library_binding = "analogLib";

 *)
c1487 ( \10:I_REXT_100_NC , \I_REXT_50(0)  );
capacitor #(.c(7.603e-15)) (*
integer library_binding = "analogLib";

 *)
c1488 ( \10:I_REXT_100_NC , GND );
capacitor #(.c(3.081e-16)) (*
integer library_binding = "analogLib";

 *)
c1489 ( \10:I_REXT_100_NC , \7:I_REXT_50(0)  );
capacitor #(.c(3.748e-18)) (*
integer library_binding = "analogLib";

 *)
c1490 ( clkpll_sc, \4:GND  );
capacitor #(.c(2.146e-17)) (*
integer library_binding = "analogLib";

 *)
c1491 ( clkpll_sc, \9:VDD  );
capacitor #(.c(9.335e-18)) (*
integer library_binding = "analogLib";

 *)
c1492 ( clkpll_sc, \4:VDD  );
capacitor #(.c(5.775e-17)) (*
integer library_binding = "analogLib";

 *)
c1493 ( clkpll_sc, GND );
capacitor #(.c(3.746e-18)) (*
integer library_binding = "analogLib";

 *)
c1494 ( \1:clkpll_sc , \4:GND  );
capacitor #(.c(2.144e-17)) (*
integer library_binding = "analogLib";

 *)
c1495 ( \1:clkpll_sc , \9:VDD  );
capacitor #(.c(9.326e-18)) (*
integer library_binding = "analogLib";

 *)
c1496 ( \1:clkpll_sc , \4:VDD  );
capacitor #(.c(5.773e-17)) (*
integer library_binding = "analogLib";

 *)
c1497 ( \1:clkpll_sc , GND );
capacitor #(.c(1.768e-16)) (*
integer library_binding = "analogLib";

 *)
c1498 ( \1:SYMBOL_MODE , \4:GND  );
capacitor #(.c(2.725e-15)) (*
integer library_binding = "analogLib";

 *)
c1499 ( \1:SYMBOL_MODE , GND );
capacitor #(.c(3.293e-16)) (*
integer library_binding = "analogLib";

 *)
c1500 ( \1:SYMBOL_MODE , \4:VDD  );
capacitor #(.c(2.725e-15)) (*
integer library_binding = "analogLib";

 *)
c1501 ( SYMBOL_MODE, GND );
capacitor #(.c(3.651e-16)) (*
integer library_binding = "analogLib";

 *)
c1502 ( SYMBOL_MODE, \4:GND  );
capacitor #(.c(6.643e-17)) (*
integer library_binding = "analogLib";

 *)
c1503 ( \WANDER_CNT(5) , \4:GND  );
capacitor #(.c(3.348e-17)) (*
integer library_binding = "analogLib";

 *)
c1504 ( \WANDER_CNT(5) , \WANDER_CNT(4)  );
capacitor #(.c(5.086e-17)) (*
integer library_binding = "analogLib";

 *)
c1505 ( \WANDER_CNT(5) , \2:PHASE_IN(5)  );
capacitor #(.c(1.581e-17)) (*
integer library_binding = "analogLib";

 *)
c1506 ( \WANDER_CNT(5) , \2:PHASE_IN(1)  );
capacitor #(.c(1.566e-17)) (*
integer library_binding = "analogLib";

 *)
c1507 ( \WANDER_CNT(5) , \PHASE_IN(0)  );
capacitor #(.c(7.132e-17)) (*
integer library_binding = "analogLib";

 *)
c1508 ( \WANDER_CNT(5) , \6:X10_DIS_2p5  );
capacitor #(.c(1.159e-17)) (*
integer library_binding = "analogLib";

 *)
c1509 ( \WANDER_CNT(5) , \2:I_REXT_50(0)  );
capacitor #(.c(4.061e-16)) (*
integer library_binding = "analogLib";

 *)
c1510 ( \WANDER_CNT(5) , \6:AEQ_BYPASS  );
capacitor #(.c(3.224e-16)) (*
integer library_binding = "analogLib";

 *)
c1511 ( \WANDER_CNT(5) , \3:X10_DIS_2p5  );
capacitor #(.c(1.912e-17)) (*
integer library_binding = "analogLib";

 *)
c1512 ( \WANDER_CNT(5) , \5:BASEFX_DIS  );
capacitor #(.c(1.157e-16)) (*
integer library_binding = "analogLib";

 *)
c1513 ( \WANDER_CNT(5) , \4:PHASE_IN(2)  );
capacitor #(.c(2.151e-16)) (*
integer library_binding = "analogLib";

 *)
c1514 ( \WANDER_CNT(5) , \3:MR_SQUELCH_DISB_2p5  );
capacitor #(.c(1.395e-17)) (*
integer library_binding = "analogLib";

 *)
c1515 ( \WANDER_CNT(5) , \5:AEQ_CNT_ANLG(4)  );
capacitor #(.c(2.851e-16)) (*
integer library_binding = "analogLib";

 *)
c1516 ( \WANDER_CNT(5) , \WANDER_CNT(3)  );
capacitor #(.c(2e-16)) (*
integer library_binding = "analogLib";
 *)

c1517 ( \WANDER_CNT(5) , \5:WANDER_CNT(4)  );
capacitor #(.c(3.844e-17)) (*
integer library_binding = "analogLib";

 *)
c1518 ( \WANDER_CNT(5) , \4:WANDER_CNT(3)  );
capacitor #(.c(2.425e-18)) (*
integer library_binding = "analogLib";

 *)
c1519 ( \WANDER_CNT(5) , AEQ_DIS_2p5 );
capacitor #(.c(7.958e-15)) (*
integer library_binding = "analogLib";

 *)
c1520 ( \WANDER_CNT(5) , ADC_TEST_2p5 );
capacitor #(.c(1.381e-17)) (*
integer library_binding = "analogLib";

 *)
c1521 ( \WANDER_CNT(5) , \5:AEQ_CNT_ANLG(1)  );
capacitor #(.c(9.681e-18)) (*
integer library_binding = "analogLib";

 *)
c1522 ( \WANDER_CNT(5) , \6:AEQ_DIS_2p5  );
capacitor #(.c(1.211e-17)) (*
integer library_binding = "analogLib";

 *)
c1523 ( \WANDER_CNT(5) , \5:WANDER_CNT(1)  );
capacitor #(.c(8.365e-20)) (*
integer library_binding = "analogLib";

 *)
c1524 ( \WANDER_CNT(5) , \5:BLW_DIS_2p5  );
capacitor #(.c(8.884e-20)) (*
integer library_binding = "analogLib";

 *)
c1525 ( \WANDER_CNT(5) , \8:TX100_DIS_2p5  );
capacitor #(.c(6.28e-20)) (*
integer library_binding = "analogLib";

 *)
c1526 ( \WANDER_CNT(5) , T2_MODE );
capacitor #(.c(1.367e-18)) (*
integer library_binding = "analogLib";

 *)
c1527 ( \WANDER_CNT(5) , \4:AEQ_CNT_ANLG(2)  );
capacitor #(.c(2.081e-18)) (*
integer library_binding = "analogLib";

 *)
c1528 ( \WANDER_CNT(5) , RX10_PRESENT_2p5 );
capacitor #(.c(1.288e-18)) (*
integer library_binding = "analogLib";

 *)
c1529 ( \WANDER_CNT(5) , \AEQ_CNT_ANLG(1)  );
capacitor #(.c(9.92e-20)) (*
integer library_binding = "analogLib";

 *)
c1530 ( \WANDER_CNT(5) , \WANDER_CNT(6)  );
capacitor #(.c(1.142e-18)) (*
integer library_binding = "analogLib";

 *)
c1531 ( \WANDER_CNT(5) , \4:AEQ_CNT_ANLG(0)  );
capacitor #(.c(7.561e-20)) (*
integer library_binding = "analogLib";

 *)
c1532 ( \WANDER_CNT(5) , \7:BASEFX_DIS  );
capacitor #(.c(8.25e-18)) (*
integer library_binding = "analogLib";

 *)
c1533 ( \WANDER_CNT(5) , \6:RX10_PRESENT_2p5  );
capacitor #(.c(9.328e-19)) (*
integer library_binding = "analogLib";

 *)
c1534 ( \WANDER_CNT(5) , \WANDER_CNT(1)  );
capacitor #(.c(1.466e-17)) (*
integer library_binding = "analogLib";

 *)
c1535 ( \WANDER_CNT(5) , \AEQ_CNT_ANLG(0)  );
capacitor #(.c(7.985e-15)) (*
integer library_binding = "analogLib";

 *)
c1536 ( \WANDER_CNT(5) , ADC_DIS_2p5 );
capacitor #(.c(5.48e-16)) (*
integer library_binding = "analogLib";

 *)
c1537 ( \WANDER_CNT(5) , \25:VDDTX  );
capacitor #(.c(1.044e-16)) (*
integer library_binding = "analogLib";

 *)
c1538 ( \WANDER_CNT(5) , \24:VDDTX  );
capacitor #(.c(8.347e-19)) (*
integer library_binding = "analogLib";

 *)
c1539 ( \WANDER_CNT(5) , \4:WANDER_CNT(0)  );
capacitor #(.c(1.093e-17)) (*
integer library_binding = "analogLib";

 *)
c1540 ( \WANDER_CNT(5) , \WANDER_CNT(0)  );
capacitor #(.c(4.695e-15)) (*
integer library_binding = "analogLib";

 *)
c1541 ( \WANDER_CNT(5) , \5:ADC_DIS_2p5  );
capacitor #(.c(1.42e-17)) (*
integer library_binding = "analogLib";

 *)
c1542 ( \WANDER_CNT(5) , \AEQ_CNT_ANLG(2)  );
capacitor #(.c(3.193e-16)) (*
integer library_binding = "analogLib";

 *)
c1543 ( \WANDER_CNT(5) , AEQ_BYPASS );
capacitor #(.c(1.836e-16)) (*
integer library_binding = "analogLib";

 *)
c1544 ( \WANDER_CNT(5) , MR_SQUELCH_DISB_2p5 );
capacitor #(.c(1.56e-18)) (*
integer library_binding = "analogLib";

 *)
c1545 ( \WANDER_CNT(5) , \AEQ_CNT_ANLG(4)  );
capacitor #(.c(1.499e-17)) (*
integer library_binding = "analogLib";

 *)
c1546 ( \WANDER_CNT(5) , \5:WANDER_CNT(2)  );
capacitor #(.c(7.388e-19)) (*
integer library_binding = "analogLib";

 *)
c1547 ( \WANDER_CNT(5) , \WANDER_CNT(2)  );
capacitor #(.c(5.071e-15)) (*
integer library_binding = "analogLib";

 *)
c1548 ( \WANDER_CNT(5) , \5:ADC_TEST_2p5  );
capacitor #(.c(5.143e-16)) (*
integer library_binding = "analogLib";

 *)
c1549 ( \WANDER_CNT(5) , \23:GNDTX  );
capacitor #(.c(2.138e-16)) (*
integer library_binding = "analogLib";

 *)
c1550 ( \WANDER_CNT(5) , \22:GNDTX  );
capacitor #(.c(1.066e-15)) (*
integer library_binding = "analogLib";

 *)
c1551 ( \WANDER_CNT(5) , GND );
capacitor #(.c(1.441e-16)) (*
integer library_binding = "analogLib";

 *)
c1552 ( \4:WANDER_CNT(5) , \4:GND  );
capacitor #(.c(2.953e-15)) (*
integer library_binding = "analogLib";

 *)
c1553 ( \4:WANDER_CNT(5) , \WANDER_CNT(4)  );
capacitor #(.c(4.215e-18)) (*
integer library_binding = "analogLib";

 *)
c1554 ( \4:WANDER_CNT(5) , \2:PHASE_IN(5)  );
capacitor #(.c(1.31e-18)) (*
integer library_binding = "analogLib";

 *)
c1555 ( \4:WANDER_CNT(5) , \2:PHASE_IN(1)  );
capacitor #(.c(1.298e-18)) (*
integer library_binding = "analogLib";

 *)
c1556 ( \4:WANDER_CNT(5) , \PHASE_IN(0)  );
capacitor #(.c(9.605e-19)) (*
integer library_binding = "analogLib";

 *)
c1557 ( \4:WANDER_CNT(5) , \2:I_REXT_50(0)  );
capacitor #(.c(2.672e-17)) (*
integer library_binding = "analogLib";

 *)
c1558 ( \4:WANDER_CNT(5) , \3:X10_DIS_2p5  );
capacitor #(.c(1.584e-18)) (*
integer library_binding = "analogLib";

 *)
c1559 ( \4:WANDER_CNT(5) , \5:BASEFX_DIS  );
capacitor #(.c(9.588e-18)) (*
integer library_binding = "analogLib";

 *)
c1560 ( \4:WANDER_CNT(5) , \4:PHASE_IN(2)  );
capacitor #(.c(2.629e-17)) (*
integer library_binding = "analogLib";

 *)
c1561 ( \4:WANDER_CNT(5) , \5:WANDER_CNT(4)  );
capacitor #(.c(1.145e-18)) (*
integer library_binding = "analogLib";

 *)
c1562 ( \4:WANDER_CNT(5) , \5:AEQ_CNT_ANLG(1)  );
capacitor #(.c(8.023e-19)) (*
integer library_binding = "analogLib";

 *)
c1563 ( \4:WANDER_CNT(5) , \6:AEQ_DIS_2p5  );
capacitor #(.c(1.004e-18)) (*
integer library_binding = "analogLib";

 *)
c1564 ( \4:WANDER_CNT(5) , \5:WANDER_CNT(1)  );
capacitor #(.c(6.837e-19)) (*
integer library_binding = "analogLib";

 *)
c1565 ( \4:WANDER_CNT(5) , \6:RX10_PRESENT_2p5  );
capacitor #(.c(7.73e-20)) (*
integer library_binding = "analogLib";

 *)
c1566 ( \4:WANDER_CNT(5) , \WANDER_CNT(1)  );
capacitor #(.c(1.215e-18)) (*
integer library_binding = "analogLib";

 *)
c1567 ( \4:WANDER_CNT(5) , \AEQ_CNT_ANLG(0)  );
capacitor #(.c(4.542e-17)) (*
integer library_binding = "analogLib";

 *)
c1568 ( \4:WANDER_CNT(5) , \25:VDDTX  );
capacitor #(.c(8.65e-18)) (*
integer library_binding = "analogLib";

 *)
c1569 ( \4:WANDER_CNT(5) , \24:VDDTX  );
capacitor #(.c(6.918e-20)) (*
integer library_binding = "analogLib";

 *)
c1570 ( \4:WANDER_CNT(5) , \4:WANDER_CNT(0)  );
capacitor #(.c(9.055e-19)) (*
integer library_binding = "analogLib";

 *)
c1571 ( \4:WANDER_CNT(5) , \WANDER_CNT(0)  );
capacitor #(.c(1.177e-18)) (*
integer library_binding = "analogLib";

 *)
c1572 ( \4:WANDER_CNT(5) , \AEQ_CNT_ANLG(2)  );
capacitor #(.c(1.522e-17)) (*
integer library_binding = "analogLib";

 *)
c1573 ( \4:WANDER_CNT(5) , MR_SQUELCH_DISB_2p5 );
capacitor #(.c(1.242e-18)) (*
integer library_binding = "analogLib";

 *)
c1574 ( \4:WANDER_CNT(5) , \5:WANDER_CNT(2)  );
capacitor #(.c(6.123e-20)) (*
integer library_binding = "analogLib";

 *)
c1575 ( \4:WANDER_CNT(5) , \WANDER_CNT(2)  );
capacitor #(.c(6.229e-15)) (*
integer library_binding = "analogLib";

 *)
c1576 ( \4:WANDER_CNT(5) , \5:ADC_TEST_2p5  );
capacitor #(.c(1.342e-18)) (*
integer library_binding = "analogLib";

 *)
c1577 ( \4:WANDER_CNT(5) , \5:AEQ_CNT_ANLG(4)  );
capacitor #(.c(1.118e-17)) (*
integer library_binding = "analogLib";

 *)
c1578 ( \4:WANDER_CNT(5) , \AEQ_CNT_ANLG(4)  );
capacitor #(.c(3.927e-17)) (*
integer library_binding = "analogLib";

 *)
c1579 ( \4:WANDER_CNT(5) , \6:AEQ_BYPASS  );
capacitor #(.c(3.037e-16)) (*
integer library_binding = "analogLib";

 *)
c1580 ( \4:WANDER_CNT(5) , AEQ_BYPASS );
capacitor #(.c(6.67e-15)) (*
integer library_binding = "analogLib";

 *)
c1581 ( \4:WANDER_CNT(5) , \5:ADC_DIS_2p5  );
capacitor #(.c(7.245e-16)) (*
integer library_binding = "analogLib";

 *)
c1582 ( \4:WANDER_CNT(5) , ADC_DIS_2p5 );
capacitor #(.c(2.11e-19)) (*
integer library_binding = "analogLib";

 *)
c1583 ( \4:WANDER_CNT(5) , BLW_DIS_2p5 );
capacitor #(.c(1.983e-16)) (*
integer library_binding = "analogLib";

 *)
c1584 ( \4:WANDER_CNT(5) , \3:MR_SQUELCH_DISB_2p5  );
capacitor #(.c(1.474e-17)) (*
integer library_binding = "analogLib";

 *)
c1585 ( \4:WANDER_CNT(5) , AEQ_DIS_2p5 );
capacitor #(.c(1.354e-17)) (*
integer library_binding = "analogLib";

 *)
c1586 ( \4:WANDER_CNT(5) , \7:BASEFX_DIS  );
capacitor #(.c(1.303e-17)) (*
integer library_binding = "analogLib";

 *)
c1587 ( \4:WANDER_CNT(5) , \4:AEQ_CNT_ANLG(0)  );
capacitor #(.c(1.777e-17)) (*
integer library_binding = "analogLib";

 *)
c1588 ( \4:WANDER_CNT(5) , \WANDER_CNT(6)  );
capacitor #(.c(1.305e-17)) (*
integer library_binding = "analogLib";

 *)
c1589 ( \4:WANDER_CNT(5) , \AEQ_CNT_ANLG(1)  );
capacitor #(.c(2.234e-16)) (*
integer library_binding = "analogLib";

 *)
c1590 ( \4:WANDER_CNT(5) , \6:X10_DIS_2p5  );
capacitor #(.c(1.311e-17)) (*
integer library_binding = "analogLib";

 *)
c1591 ( \4:WANDER_CNT(5) , RX10_PRESENT_2p5 );
capacitor #(.c(1.305e-17)) (*
integer library_binding = "analogLib";

 *)
c1592 ( \4:WANDER_CNT(5) , \4:AEQ_CNT_ANLG(2)  );
capacitor #(.c(1.125e-17)) (*
integer library_binding = "analogLib";

 *)
c1593 ( \4:WANDER_CNT(5) , T2_MODE );
capacitor #(.c(2.743e-19)) (*
integer library_binding = "analogLib";

 *)
c1594 ( \4:WANDER_CNT(5) , \2:TX100_DIS_2p5  );
capacitor #(.c(1.591e-17)) (*
integer library_binding = "analogLib";

 *)
c1595 ( \4:WANDER_CNT(5) , \8:TX100_DIS_2p5  );
capacitor #(.c(4.795e-17)) (*
integer library_binding = "analogLib";

 *)
c1596 ( \4:WANDER_CNT(5) , \WANDER_CNT(3)  );
capacitor #(.c(2.781e-15)) (*
integer library_binding = "analogLib";

 *)
c1597 ( \4:WANDER_CNT(5) , \4:WANDER_CNT(3)  );
capacitor #(.c(7.818e-16)) (*
integer library_binding = "analogLib";

 *)
c1598 ( \4:WANDER_CNT(5) , ADC_TEST_2p5 );
capacitor #(.c(1.498e-17)) (*
integer library_binding = "analogLib";

 *)
c1599 ( \4:WANDER_CNT(5) , \5:BLW_DIS_2p5  );
capacitor #(.c(2.224e-15)) (*
integer library_binding = "analogLib";

 *)
c1600 ( \4:WANDER_CNT(5) , GND );
capacitor #(.c(7.072e-17)) (*
integer library_binding = "analogLib";

 *)
c1601 ( \I_RPOLY_100(1) , \4:GND  );
capacitor #(.c(1.585e-15)) (*
integer library_binding = "analogLib";

 *)
c1602 ( \I_RPOLY_100(1) , \I_RPOLY_100(0)  );
capacitor #(.c(4.713e-16)) (*
integer library_binding = "analogLib";

 *)
c1603 ( \I_RPOLY_100(1) , \2:I_RPOLY_100(0)  );
capacitor #(.c(5.718e-18)) (*
integer library_binding = "analogLib";

 *)
c1604 ( \I_RPOLY_100(1) , POS_DETECT_2p5 );
capacitor #(.c(3.995e-18)) (*
integer library_binding = "analogLib";

 *)
c1605 ( \I_RPOLY_100(1) , \5:POS_DETECT_2p5  );
capacitor #(.c(4.105e-18)) (*
integer library_binding = "analogLib";

 *)
c1606 ( \I_RPOLY_100(1) , NEG_DETECT_2p5 );
capacitor #(.c(5.608e-18)) (*
integer library_binding = "analogLib";

 *)
c1607 ( \I_RPOLY_100(1) , \4:NEG_DETECT_2p5  );
capacitor #(.c(1.593e-15)) (*
integer library_binding = "analogLib";

 *)
c1608 ( \I_RPOLY_100(1) , \3:I_RPOLY_100(2)  );
capacitor #(.c(5.321e-16)) (*
integer library_binding = "analogLib";

 *)
c1609 ( \I_RPOLY_100(1) , \I_RPOLY_100(2)  );
capacitor #(.c(1.096e-15)) (*
integer library_binding = "analogLib";

 *)
c1610 ( \I_RPOLY_100(1) , GND );
capacitor #(.c(1.741e-17)) (*
integer library_binding = "analogLib";

 *)
c1611 ( \I_RPOLY_100(1) , \2:I_REXT_50(1)  );
capacitor #(.c(1.406e-16)) (*
integer library_binding = "analogLib";

 *)
c1612 ( \2:I_RPOLY_100(1) , \4:GND  );
capacitor #(.c(5.261e-16)) (*
integer library_binding = "analogLib";

 *)
c1613 ( \2:I_RPOLY_100(1) , \I_RPOLY_100(0)  );
capacitor #(.c(1.713e-18)) (*
integer library_binding = "analogLib";

 *)
c1614 ( \2:I_RPOLY_100(1) , POS_DETECT_2p5 );
capacitor #(.c(1.197e-18)) (*
integer library_binding = "analogLib";

 *)
c1615 ( \2:I_RPOLY_100(1) , \5:POS_DETECT_2p5  );
capacitor #(.c(1.23e-18)) (*
integer library_binding = "analogLib";

 *)
c1616 ( \2:I_RPOLY_100(1) , NEG_DETECT_2p5 );
capacitor #(.c(1.68e-18)) (*
integer library_binding = "analogLib";

 *)
c1617 ( \2:I_RPOLY_100(1) , \4:NEG_DETECT_2p5  );
capacitor #(.c(4.772e-16)) (*
integer library_binding = "analogLib";

 *)
c1618 ( \2:I_RPOLY_100(1) , \3:I_RPOLY_100(2)  );
capacitor #(.c(1.648e-14)) (*
integer library_binding = "analogLib";

 *)
c1619 ( \2:I_RPOLY_100(1) , \2:I_RPOLY_100(0)  );
capacitor #(.c(1.65e-14)) (*
integer library_binding = "analogLib";

 *)
c1620 ( \2:I_RPOLY_100(1) , \I_RPOLY_100(2)  );
capacitor #(.c(1.262e-17)) (*
integer library_binding = "analogLib";

 *)
c1621 ( \2:I_RPOLY_100(1) , \2:I_REXT_50(1)  );
capacitor #(.c(2.179e-15)) (*
integer library_binding = "analogLib";

 *)
c1622 ( \2:I_RPOLY_100(1) , GND );
capacitor #(.c(2.495e-17)) (*
integer library_binding = "analogLib";

 *)
c1623 ( \2:I_RPOLY_100(1) , \25:GND  );
capacitor #(.c(4.544e-17)) (*
integer library_binding = "analogLib";

 *)
c1624 ( \2:I_RPOLY_100(1) , \4:I_RPOLY_100(0)  );
capacitor #(.c(1.122e-16)) (*
integer library_binding = "analogLib";

 *)
c1625 ( \4:I_RPOLY_100(1) , \4:GND  );
capacitor #(.c(1.276e-17)) (*
integer library_binding = "analogLib";

 *)
c1626 ( \4:I_RPOLY_100(1) , \7:I_REXT_50(0)  );
capacitor #(.c(1.974e-17)) (*
integer library_binding = "analogLib";

 *)
c1627 ( \4:I_RPOLY_100(1) , \25:GND  );
capacitor #(.c(1.285e-14)) (*
integer library_binding = "analogLib";

 *)
c1628 ( \4:I_RPOLY_100(1) , \4:I_RPOLY_100(2)  );
capacitor #(.c(1.22e-17)) (*
integer library_binding = "analogLib";

 *)
c1629 ( \4:I_RPOLY_100(1) , \ADC_1p0(5)  );
capacitor #(.c(1.508e-17)) (*
integer library_binding = "analogLib";

 *)
c1630 ( \4:I_RPOLY_100(1) , \3:ADC_1p0(4)  );
capacitor #(.c(1.283e-14)) (*
integer library_binding = "analogLib";

 *)
c1631 ( \4:I_RPOLY_100(1) , \4:I_RPOLY_100(0)  );
capacitor #(.c(9.746e-17)) (*
integer library_binding = "analogLib";

 *)
c1632 ( \4:I_RPOLY_100(1) , \5:GND  );
capacitor #(.c(1.246e-17)) (*
integer library_binding = "analogLib";

 *)
c1633 ( \4:I_RPOLY_100(1) , \4:FLASH_1p0(0)  );
capacitor #(.c(9.746e-17)) (*
integer library_binding = "analogLib";

 *)
c1634 ( \4:I_RPOLY_100(1) , \6:GNDRX  );
capacitor #(.c(1.246e-17)) (*
integer library_binding = "analogLib";

 *)
c1635 ( \4:I_RPOLY_100(1) , \ADC_1p0(0)  );
capacitor #(.c(1.79e-15)) (*
integer library_binding = "analogLib";

 *)
c1636 ( \4:I_RPOLY_100(1) , GND );
capacitor #(.c(9.746e-17)) (*
integer library_binding = "analogLib";

 *)
c1637 ( \4:I_RPOLY_100(1) , \3:VDDRX  );
capacitor #(.c(9.746e-17)) (*
integer library_binding = "analogLib";

 *)
c1638 ( \4:I_RPOLY_100(1) , \6:VDD  );
capacitor #(.c(4.544e-17)) (*
integer library_binding = "analogLib";

 *)
c1639 ( \4:I_RPOLY_100(1) , \I_RPOLY_100(2)  );
capacitor #(.c(2.725e-15)) (*
integer library_binding = "analogLib";

 *)
c1640 ( SCAN_ENABLE, GND );
capacitor #(.c(3.651e-16)) (*
integer library_binding = "analogLib";

 *)
c1641 ( SCAN_ENABLE, \4:GND  );
capacitor #(.c(1.768e-16)) (*
integer library_binding = "analogLib";

 *)
c1642 ( \1:SCAN_ENABLE , \4:GND  );
capacitor #(.c(2.725e-15)) (*
integer library_binding = "analogLib";

 *)
c1643 ( \1:SCAN_ENABLE , GND );
capacitor #(.c(3.293e-16)) (*
integer library_binding = "analogLib";

 *)
c1644 ( \1:SCAN_ENABLE , \4:VDD  );
capacitor #(.c(1.546e-16)) (*
integer library_binding = "analogLib";

 *)
c1645 ( \3:VDDRX , \4:GND  );
capacitor #(.c(1.024e-16)) (*
integer library_binding = "analogLib";

 *)
c1646 ( \3:VDDRX , \12:I_RPOLY_REF100  );
capacitor #(.c(1.009e-17)) (*
integer library_binding = "analogLib";

 *)
c1647 ( \3:VDDRX , \4:I_RPOLY_REF100  );
capacitor #(.c(2.809e-16)) (*
integer library_binding = "analogLib";

 *)
c1648 ( \3:VDDRX , \7:I_REXT_50(0)  );
capacitor #(.c(3.942e-17)) (*
integer library_binding = "analogLib";

 *)
c1649 ( \3:VDDRX , \I_REXT_50(0)  );
capacitor #(.c(1.602e-16)) (*
integer library_binding = "analogLib";

 *)
c1650 ( \3:VDDRX , \I_REXT_50(1)  );
capacitor #(.c(1.454e-17)) (*
integer library_binding = "analogLib";

 *)
c1651 ( \3:VDDRX , \2:I_REXT_50(1)  );
capacitor #(.c(2.382e-15)) (*
integer library_binding = "analogLib";

 *)
c1652 ( \3:VDDRX , GND );
capacitor #(.c(9.746e-17)) (*
integer library_binding = "analogLib";

 *)
c1653 ( \3:VDDRX , \4:I_REXT_100(6)  );
capacitor #(.c(2.498e-16)) (*
integer library_binding = "analogLib";

 *)
c1654 ( \3:VDDRX , \4:FLASH_1p0(1)  );
capacitor #(.c(1.019e-16)) (*
integer library_binding = "analogLib";

 *)
c1655 ( \3:VDDRX , \4:I_REXT_100(5)  );
capacitor #(.c(2.498e-16)) (*
integer library_binding = "analogLib";

 *)
c1656 ( \3:VDDRX , \ADC_1p0(5)  );
capacitor #(.c(9.746e-17)) (*
integer library_binding = "analogLib";

 *)
c1657 ( \3:VDDRX , \4:I_REXT_100(4)  );
capacitor #(.c(1.736e-16)) (*
integer library_binding = "analogLib";

 *)
c1658 ( \3:VDDRX , \3:ADC_1p0(4)  );
capacitor #(.c(2.498e-16)) (*
integer library_binding = "analogLib";

 *)
c1659 ( \3:VDDRX , \4:ADC_1p0(2)  );
capacitor #(.c(1.736e-16)) (*
integer library_binding = "analogLib";

 *)
c1660 ( \3:VDDRX , \4:I_RPOLY_100(5)  );
capacitor #(.c(9.746e-17)) (*
integer library_binding = "analogLib";

 *)
c1661 ( \3:VDDRX , \4:I_REXT_100(3)  );
capacitor #(.c(1.736e-16)) (*
integer library_binding = "analogLib";

 *)
c1662 ( \3:VDDRX , \3:ADC_1p0(3)  );
capacitor #(.c(9.746e-17)) (*
integer library_binding = "analogLib";

 *)
c1663 ( \3:VDDRX , \I_RPOLY_100(4)  );
capacitor #(.c(9.746e-17)) (*
integer library_binding = "analogLib";

 *)
c1664 ( \3:VDDRX , \4:I_REXT_100(2)  );
capacitor #(.c(1.594e-15)) (*
integer library_binding = "analogLib";

 *)
c1665 ( \3:VDDRX , \6:VDD  );
capacitor #(.c(1.565e-15)) (*
integer library_binding = "analogLib";

 *)
c1666 ( \3:VDDRX , \5:GND  );
capacitor #(.c(9.741e-17)) (*
integer library_binding = "analogLib";

 *)
c1667 ( \3:VDDRX , \4:I_RPOLY_100(3)  );
capacitor #(.c(2.498e-16)) (*
integer library_binding = "analogLib";

 *)
c1668 ( \3:VDDRX , \4:FLASH_1p0(0)  );
capacitor #(.c(9.746e-17)) (*
integer library_binding = "analogLib";

 *)
c1669 ( \3:VDDRX , \4:I_RPOLY_100(2)  );
capacitor #(.c(2.424e-16)) (*
integer library_binding = "analogLib";

 *)
c1670 ( \3:VDDRX , \ADC_1p0(0)  );
capacitor #(.c(1.288e-16)) (*
integer library_binding = "analogLib";

 *)
c1671 ( \3:VDDRX , \25:GND  );
capacitor #(.c(1.984e-16)) (*
integer library_binding = "analogLib";

 *)
c1672 ( \3:VDDRX , \4:RCLK125_1p0  );
capacitor #(.c(9.746e-17)) (*
integer library_binding = "analogLib";

 *)
c1673 ( \3:VDDRX , \4:I_RPOLY_100(0)  );
capacitor #(.c(4.292e-16)) (*
integer library_binding = "analogLib";

 *)
c1674 ( \2:VDDRX , \4:GND  );
capacitor #(.c(6.614e-15)) (*
integer library_binding = "analogLib";

 *)
c1675 ( \2:VDDRX , GND );
capacitor #(.c(1.61e-15)) (*
integer library_binding = "analogLib";

 *)
c1676 ( \2:VDDRX , \5:GNDRX  );
capacitor #(.c(2.268e-16)) (*
integer library_binding = "analogLib";

 *)
c1677 ( \2:VDDRX , \4:FLASH_1p0(0)  );
capacitor #(.c(2.268e-16)) (*
integer library_binding = "analogLib";

 *)
c1678 ( \2:VDDRX , \ADC_1p0(0)  );
capacitor #(.c(1.824e-16)) (*
integer library_binding = "analogLib";

 *)
c1679 ( \2:VDDRX , \4:RCLK125_1p0  );
capacitor #(.c(9.755e-17)) (*
integer library_binding = "analogLib";

 *)
c1680 ( \2:VDDRX , \4:FLASH_1p0(1)  );
capacitor #(.c(2.08e-16)) (*
integer library_binding = "analogLib";

 *)
c1681 ( \2:VDDRX , \ADC_1p0(5)  );
capacitor #(.c(1.374e-16)) (*
integer library_binding = "analogLib";

 *)
c1682 ( \2:VDDRX , \4:ADC_1p0(2)  );
capacitor #(.c(2.685e-16)) (*
integer library_binding = "analogLib";

 *)
c1683 ( \2:VDDRX , \3:ADC_1p0(4)  );
capacitor #(.c(1.564e-16)) (*
integer library_binding = "analogLib";

 *)
c1684 ( \2:VDDRX , \3:ADC_1p0(3)  );
capacitor #(.c(3.318e-17)) (*
integer library_binding = "analogLib";

 *)
c1685 ( \4:VDDRX , \4:GND  );
capacitor #(.c(5.113e-16)) (*
integer library_binding = "analogLib";

 *)
c1686 ( \4:VDDRX , GND );
capacitor #(.c(3.078e-16)) (*
integer library_binding = "analogLib";

 *)
c1687 ( \WANDER_CNT(1) , \4:GND  );
capacitor #(.c(1.795e-17)) (*
integer library_binding = "analogLib";

 *)
c1688 ( \WANDER_CNT(1) , \7:BASEFX_DIS  );
capacitor #(.c(7.916e-20)) (*
integer library_binding = "analogLib";

 *)
c1689 ( \WANDER_CNT(1) , \WANDER_CNT(4)  );
capacitor #(.c(2.752e-15)) (*
integer library_binding = "analogLib";

 *)
c1690 ( \WANDER_CNT(1) , \AEQ_CNT_ANLG(4)  );
capacitor #(.c(1.106e-18)) (*
integer library_binding = "analogLib";

 *)
c1691 ( \WANDER_CNT(1) , \9:TX100_DIS_2p5  );
capacitor #(.c(3.82e-16)) (*
integer library_binding = "analogLib";

 *)
c1692 ( \WANDER_CNT(1) , AEQ_BYPASS );
capacitor #(.c(1.528e-18)) (*
integer library_binding = "analogLib";

 *)
c1693 ( \WANDER_CNT(1) , \AEQ_CNT_ANLG(2)  );
capacitor #(.c(1.143e-15)) (*
integer library_binding = "analogLib";

 *)
c1694 ( \WANDER_CNT(1) , \WANDER_CNT(0)  );
capacitor #(.c(4.79e-17)) (*
integer library_binding = "analogLib";

 *)
c1695 ( \WANDER_CNT(1) , BLW_DIS_2p5 );
capacitor #(.c(8.096e-18)) (*
integer library_binding = "analogLib";

 *)
c1696 ( \WANDER_CNT(1) , \24:VDDTX  );
capacitor #(.c(4.251e-17)) (*
integer library_binding = "analogLib";

 *)
c1697 ( \WANDER_CNT(1) , \25:VDDTX  );
capacitor #(.c(1.455e-17)) (*
integer library_binding = "analogLib";

 *)
c1698 ( \WANDER_CNT(1) , RX10_PRESENT_2p5 );
capacitor #(.c(1.437e-17)) (*
integer library_binding = "analogLib";

 *)
c1699 ( \WANDER_CNT(1) , \4:AEQ_CNT_ANLG(2)  );
capacitor #(.c(1.339e-18)) (*
integer library_binding = "analogLib";

 *)
c1700 ( \WANDER_CNT(1) , \AEQ_CNT_ANLG(0)  );
capacitor #(.c(1.48e-17)) (*
integer library_binding = "analogLib";

 *)
c1701 ( \WANDER_CNT(1) , \4:AEQ_CNT_ANLG(0)  );
capacitor #(.c(1.479e-17)) (*
integer library_binding = "analogLib";

 *)
c1702 ( \WANDER_CNT(1) , \AEQ_CNT_ANLG(1)  );
capacitor #(.c(1.849e-17)) (*
integer library_binding = "analogLib";

 *)
c1703 ( \WANDER_CNT(1) , AEQ_DIS_2p5 );
capacitor #(.c(4.112e-17)) (*
integer library_binding = "analogLib";

 *)
c1704 ( \WANDER_CNT(1) , \2:TX100_DIS_2p5  );
capacitor #(.c(2.798e-16)) (*
integer library_binding = "analogLib";

 *)
c1705 ( \WANDER_CNT(1) , \8:TX100_DIS_2p5  );
capacitor #(.c(1.605e-17)) (*
integer library_binding = "analogLib";

 *)
c1706 ( \WANDER_CNT(1) , T2_MODE );
capacitor #(.c(3.659e-19)) (*
integer library_binding = "analogLib";

 *)
c1707 ( \WANDER_CNT(1) , \6:T2_MODE  );
capacitor #(.c(1.487e-14)) (*
integer library_binding = "analogLib";

 *)
c1708 ( \WANDER_CNT(1) , \4:WANDER_CNT(0)  );
capacitor #(.c(1.802e-17)) (*
integer library_binding = "analogLib";

 *)
c1709 ( \WANDER_CNT(1) , \WANDER_CNT(6)  );
capacitor #(.c(6.035e-16)) (*
integer library_binding = "analogLib";

 *)
c1710 ( \WANDER_CNT(1) , \5:BLW_DIS_2p5  );
capacitor #(.c(8.132e-19)) (*
integer library_binding = "analogLib";

 *)
c1711 ( \WANDER_CNT(1) , \6:AEQ_DIS_2p5  );
capacitor #(.c(1.07e-18)) (*
integer library_binding = "analogLib";

 *)
c1712 ( \WANDER_CNT(1) , \5:AEQ_CNT_ANLG(1)  );
capacitor #(.c(8.682e-20)) (*
integer library_binding = "analogLib";

 *)
c1713 ( \WANDER_CNT(1) , \4:WANDER_CNT(3)  );
capacitor #(.c(9.309e-19)) (*
integer library_binding = "analogLib";

 *)
c1714 ( \WANDER_CNT(1) , \5:WANDER_CNT(4)  );
capacitor #(.c(1.079e-18)) (*
integer library_binding = "analogLib";

 *)
c1715 ( \WANDER_CNT(1) , \WANDER_CNT(3)  );
capacitor #(.c(3.715e-16)) (*
integer library_binding = "analogLib";

 *)
c1716 ( \WANDER_CNT(1) , \5:AEQ_CNT_ANLG(4)  );
capacitor #(.c(9.763e-19)) (*
integer library_binding = "analogLib";

 *)
c1717 ( \WANDER_CNT(1) , \2:I_REXT_50(0)  );
capacitor #(.c(9.155e-18)) (*
integer library_binding = "analogLib";

 *)
c1718 ( \WANDER_CNT(1) , \2:PHASE_IN(1)  );
capacitor #(.c(3.827e-17)) (*
integer library_binding = "analogLib";

 *)
c1719 ( \WANDER_CNT(1) , \6:AEQ_BYPASS  );
capacitor #(.c(1.913e-18)) (*
integer library_binding = "analogLib";

 *)
c1720 ( \WANDER_CNT(1) , \5:BASEFX_DIS  );
capacitor #(.c(1.735e-18)) (*
integer library_binding = "analogLib";

 *)
c1721 ( \WANDER_CNT(1) , \PHASE_IN(0)  );
capacitor #(.c(3.559e-19)) (*
integer library_binding = "analogLib";

 *)
c1722 ( \WANDER_CNT(1) , \5:WANDER_CNT(6)  );
capacitor #(.c(1.022e-18)) (*
integer library_binding = "analogLib";

 *)
c1723 ( \WANDER_CNT(1) , \6:RX10_PRESENT_2p5  );
capacitor #(.c(4.751e-15)) (*
integer library_binding = "analogLib";

 *)
c1724 ( \WANDER_CNT(1) , GND );
capacitor #(.c(1.948e-16)) (*
integer library_binding = "analogLib";

 *)
c1725 ( \WANDER_CNT(1) , \WANDER_CNT(2)  );
capacitor #(.c(1.27e-16)) (*
integer library_binding = "analogLib";

 *)
c1726 ( \5:WANDER_CNT(1) , \4:GND  );
capacitor #(.c(1.958e-19)) (*
integer library_binding = "analogLib";

 *)
c1727 ( \5:WANDER_CNT(1) , \7:BASEFX_DIS  );
capacitor #(.c(1.028e-18)) (*
integer library_binding = "analogLib";

 *)
c1728 ( \5:WANDER_CNT(1) , \WANDER_CNT(4)  );
capacitor #(.c(2.617e-15)) (*
integer library_binding = "analogLib";

 *)
c1729 ( \5:WANDER_CNT(1) , \AEQ_CNT_ANLG(4)  );
capacitor #(.c(1.436e-17)) (*
integer library_binding = "analogLib";

 *)
c1730 ( \5:WANDER_CNT(1) , \9:TX100_DIS_2p5  );
capacitor #(.c(4.025e-16)) (*
integer library_binding = "analogLib";

 *)
c1731 ( \5:WANDER_CNT(1) , AEQ_BYPASS );
capacitor #(.c(1.428e-17)) (*
integer library_binding = "analogLib";

 *)
c1732 ( \5:WANDER_CNT(1) , \AEQ_CNT_ANLG(2)  );
capacitor #(.c(1.291e-14)) (*
integer library_binding = "analogLib";

 *)
c1733 ( \5:WANDER_CNT(1) , \WANDER_CNT(0)  );
capacitor #(.c(5.183e-16)) (*
integer library_binding = "analogLib";

 *)
c1734 ( \5:WANDER_CNT(1) , BLW_DIS_2p5 );
capacitor #(.c(1.051e-16)) (*
integer library_binding = "analogLib";

 *)
c1735 ( \5:WANDER_CNT(1) , \24:VDDTX  );
capacitor #(.c(5.519e-16)) (*
integer library_binding = "analogLib";

 *)
c1736 ( \5:WANDER_CNT(1) , \25:VDDTX  );
capacitor #(.c(2.377e-18)) (*
integer library_binding = "analogLib";

 *)
c1737 ( \5:WANDER_CNT(1) , RX10_PRESENT_2p5 );
capacitor #(.c(1.457e-18)) (*
integer library_binding = "analogLib";

 *)
c1738 ( \5:WANDER_CNT(1) , \4:AEQ_CNT_ANLG(2)  );
capacitor #(.c(1.738e-17)) (*
integer library_binding = "analogLib";

 *)
c1739 ( \5:WANDER_CNT(1) , \AEQ_CNT_ANLG(0)  );
capacitor #(.c(1.429e-18)) (*
integer library_binding = "analogLib";

 *)
c1740 ( \5:WANDER_CNT(1) , \4:AEQ_CNT_ANLG(0)  );
capacitor #(.c(1.382e-18)) (*
integer library_binding = "analogLib";

 *)
c1741 ( \5:WANDER_CNT(1) , \AEQ_CNT_ANLG(1)  );
capacitor #(.c(1.047e-18)) (*
integer library_binding = "analogLib";

 *)
c1742 ( \5:WANDER_CNT(1) , \WANDER_CNT(2)  );
capacitor #(.c(1.751e-19)) (*
integer library_binding = "analogLib";

 *)
c1743 ( \5:WANDER_CNT(1) , T2_MODE );
capacitor #(.c(1.148e-15)) (*
integer library_binding = "analogLib";

 *)
c1744 ( \5:WANDER_CNT(1) , \4:WANDER_CNT(0)  );
capacitor #(.c(1.966e-19)) (*
integer library_binding = "analogLib";

 *)
c1745 ( \5:WANDER_CNT(1) , \WANDER_CNT(6)  );
capacitor #(.c(9.121e-18)) (*
integer library_binding = "analogLib";

 *)
c1746 ( \5:WANDER_CNT(1) , \6:RX10_PRESENT_2p5  );
capacitor #(.c(2.252e-17)) (*
integer library_binding = "analogLib";

 *)
c1747 ( \5:WANDER_CNT(1) , \PHASE_IN(0)  );
capacitor #(.c(1.922e-17)) (*
integer library_binding = "analogLib";

 *)
c1748 ( \5:WANDER_CNT(1) , \5:BASEFX_DIS  );
capacitor #(.c(4.046e-16)) (*
integer library_binding = "analogLib";

 *)
c1749 ( \5:WANDER_CNT(1) , \6:AEQ_BYPASS  );
capacitor #(.c(4.729e-16)) (*
integer library_binding = "analogLib";

 *)
c1750 ( \5:WANDER_CNT(1) , \2:TX100_DIS_2p5  );
capacitor #(.c(1.189e-16)) (*
integer library_binding = "analogLib";

 *)
c1751 ( \5:WANDER_CNT(1) , \2:PHASE_IN(1)  );
capacitor #(.c(1.268e-17)) (*
integer library_binding = "analogLib";

 *)
c1752 ( \5:WANDER_CNT(1) , \2:I_REXT_50(0)  );
capacitor #(.c(4.268e-15)) (*
integer library_binding = "analogLib";

 *)
c1753 ( \5:WANDER_CNT(1) , \5:AEQ_CNT_ANLG(4)  );
capacitor #(.c(9.932e-17)) (*
integer library_binding = "analogLib";

 *)
c1754 ( \5:WANDER_CNT(1) , \8:TX100_DIS_2p5  );
capacitor #(.c(1.401e-17)) (*
integer library_binding = "analogLib";

 *)
c1755 ( \5:WANDER_CNT(1) , \WANDER_CNT(3)  );
capacitor #(.c(1.209e-17)) (*
integer library_binding = "analogLib";

 *)
c1756 ( \5:WANDER_CNT(1) , \5:WANDER_CNT(4)  );
capacitor #(.c(1.127e-18)) (*
integer library_binding = "analogLib";

 *)
c1757 ( \5:WANDER_CNT(1) , \4:WANDER_CNT(3)  );
capacitor #(.c(2.756e-18)) (*
integer library_binding = "analogLib";

 *)
c1758 ( \5:WANDER_CNT(1) , AEQ_DIS_2p5 );
capacitor #(.c(1.389e-17)) (*
integer library_binding = "analogLib";

 *)
c1759 ( \5:WANDER_CNT(1) , \5:AEQ_CNT_ANLG(1)  );
capacitor #(.c(1.056e-17)) (*
integer library_binding = "analogLib";

 *)
c1760 ( \5:WANDER_CNT(1) , \6:AEQ_DIS_2p5  );
capacitor #(.c(4.778e-16)) (*
integer library_binding = "analogLib";

 *)
c1761 ( \5:WANDER_CNT(1) , \5:BLW_DIS_2p5  );
capacitor #(.c(5.143e-16)) (*
integer library_binding = "analogLib";

 *)
c1762 ( \5:WANDER_CNT(1) , \23:GNDTX  );
capacitor #(.c(2.138e-16)) (*
integer library_binding = "analogLib";

 *)
c1763 ( \5:WANDER_CNT(1) , \22:GNDTX  );
capacitor #(.c(2.013e-15)) (*
integer library_binding = "analogLib";

 *)
c1764 ( \5:WANDER_CNT(1) , GND );
capacitor #(.c(2.675e-16)) (*
integer library_binding = "analogLib";

 *)
c1765 ( \MLT3_TDATA_1p0(1) , \4:GND  );
capacitor #(.c(3.161e-15)) (*
integer library_binding = "analogLib";

 *)
c1766 ( \MLT3_TDATA_1p0(1) , \TX_AMPTRIM_1p0(1)  );
capacitor #(.c(3.227e-18)) (*
integer library_binding = "analogLib";

 *)
c1767 ( \MLT3_TDATA_1p0(1) , \5:TXER  );
capacitor #(.c(2.575e-18)) (*
integer library_binding = "analogLib";

 *)
c1768 ( \MLT3_TDATA_1p0(1) , XTAL25_1p0 );
capacitor #(.c(2.966e-18)) (*
integer library_binding = "analogLib";

 *)
c1769 ( \MLT3_TDATA_1p0(1) , POS_DETECT_1p0 );
capacitor #(.c(2.513e-18)) (*
integer library_binding = "analogLib";

 *)
c1770 ( \MLT3_TDATA_1p0(1) , NEG_DETECT_1p0 );
capacitor #(.c(2.94e-18)) (*
integer library_binding = "analogLib";

 *)
c1771 ( \MLT3_TDATA_1p0(1) , X_160 );
capacitor #(.c(1.988e-17)) (*
integer library_binding = "analogLib";

 *)
c1772 ( \MLT3_TDATA_1p0(1) , \3:NEG_DETECT_1p0  );
capacitor #(.c(1.988e-17)) (*
integer library_binding = "analogLib";

 *)
c1773 ( \MLT3_TDATA_1p0(1) , \3:XTAL25_1p0  );
capacitor #(.c(1.948e-17)) (*
integer library_binding = "analogLib";

 *)
c1774 ( \MLT3_TDATA_1p0(1) , X_125 );
capacitor #(.c(1.948e-17)) (*
integer library_binding = "analogLib";

 *)
c1775 ( \MLT3_TDATA_1p0(1) , SLICER_OUT_1p0 );
capacitor #(.c(1.989e-17)) (*
integer library_binding = "analogLib";

 *)
c1776 ( \MLT3_TDATA_1p0(1) , \3:X_160  );
capacitor #(.c(1.948e-17)) (*
integer library_binding = "analogLib";

 *)
c1777 ( \MLT3_TDATA_1p0(1) , \MLT3_TDATA_1p0(0)  );
capacitor #(.c(1.986e-17)) (*
integer library_binding = "analogLib";

 *)
c1778 ( \MLT3_TDATA_1p0(1) , \3:POS_DETECT_1p0  );
capacitor #(.c(1.293e-15)) (*
integer library_binding = "analogLib";

 *)
c1779 ( \MLT3_TDATA_1p0(1) , \4:TX_AMPTRIM_1p0(1)  );
capacitor #(.c(4.123e-15)) (*
integer library_binding = "analogLib";

 *)
c1780 ( \MLT3_TDATA_1p0(1) , GND );
capacitor #(.c(3.058e-16)) (*
integer library_binding = "analogLib";

 *)
c1781 ( \4:MLT3_TDATA_1p0(1) , \4:GND  );
capacitor #(.c(3.804e-16)) (*
integer library_binding = "analogLib";

 *)
c1782 ( \4:MLT3_TDATA_1p0(1) , \TX_AMPTRIM_1p0(1)  );
capacitor #(.c(2.198e-17)) (*
integer library_binding = "analogLib";

 *)
c1783 ( \4:MLT3_TDATA_1p0(1) , \4:MLT3_TDATA_1p0(0)  );
capacitor #(.c(1.853e-17)) (*
integer library_binding = "analogLib";

 *)
c1784 ( \4:MLT3_TDATA_1p0(1) , \4:SLICER_OUT_1p0  );
capacitor #(.c(1.962e-17)) (*
integer library_binding = "analogLib";

 *)
c1785 ( \4:MLT3_TDATA_1p0(1) , \4:X_125  );
capacitor #(.c(1.838e-17)) (*
integer library_binding = "analogLib";

 *)
c1786 ( \4:MLT3_TDATA_1p0(1) , \5:TXER  );
capacitor #(.c(2.175e-15)) (*
integer library_binding = "analogLib";

 *)
c1787 ( \4:MLT3_TDATA_1p0(1) , \4:TX_AMPTRIM_1p0(1)  );
capacitor #(.c(1.467e-17)) (*
integer library_binding = "analogLib";

 *)
c1788 ( \4:MLT3_TDATA_1p0(1) , XTAL25_1p0 );
capacitor #(.c(1.689e-17)) (*
integer library_binding = "analogLib";

 *)
c1789 ( \4:MLT3_TDATA_1p0(1) , POS_DETECT_1p0 );
capacitor #(.c(1.432e-17)) (*
integer library_binding = "analogLib";

 *)
c1790 ( \4:MLT3_TDATA_1p0(1) , NEG_DETECT_1p0 );
capacitor #(.c(2.319e-18)) (*
integer library_binding = "analogLib";

 *)
c1791 ( \4:MLT3_TDATA_1p0(1) , \3:NEG_DETECT_1p0  );
capacitor #(.c(1.675e-17)) (*
integer library_binding = "analogLib";

 *)
c1792 ( \4:MLT3_TDATA_1p0(1) , X_160 );
capacitor #(.c(2.221e-18)) (*
integer library_binding = "analogLib";

 *)
c1793 ( \4:MLT3_TDATA_1p0(1) , \3:POS_DETECT_1p0  );
capacitor #(.c(4.809e-19)) (*
integer library_binding = "analogLib";

 *)
c1794 ( \4:MLT3_TDATA_1p0(1) , \MLT3_TDATA_1p0(0)  );
capacitor #(.c(2.37e-18)) (*
integer library_binding = "analogLib";

 *)
c1795 ( \4:MLT3_TDATA_1p0(1) , \3:X_160  );
capacitor #(.c(3.246e-19)) (*
integer library_binding = "analogLib";

 *)
c1796 ( \4:MLT3_TDATA_1p0(1) , SLICER_OUT_1p0 );
capacitor #(.c(4.467e-20)) (*
integer library_binding = "analogLib";

 *)
c1797 ( \4:MLT3_TDATA_1p0(1) , X_125 );
capacitor #(.c(2.322e-18)) (*
integer library_binding = "analogLib";

 *)
c1798 ( \4:MLT3_TDATA_1p0(1) , \3:XTAL25_1p0  );
capacitor #(.c(1.959e-17)) (*
integer library_binding = "analogLib";

 *)
c1799 ( \4:MLT3_TDATA_1p0(1) , \FLASH_1p0(1)  );
capacitor #(.c(1.959e-17)) (*
integer library_binding = "analogLib";

 *)
c1800 ( \4:MLT3_TDATA_1p0(1) , \1:ADC_1p0(4)  );
capacitor #(.c(1.832e-17)) (*
integer library_binding = "analogLib";

 *)
c1801 ( \4:MLT3_TDATA_1p0(1) , \2:ADC_1p0(0)  );
capacitor #(.c(1.729e-17)) (*
integer library_binding = "analogLib";

 *)
c1802 ( \4:MLT3_TDATA_1p0(1) , \1:RCLK125_1p0  );
capacitor #(.c(1.778e-17)) (*
integer library_binding = "analogLib";

 *)
c1803 ( \4:MLT3_TDATA_1p0(1) , \2:ADC_1p0(3)  );
capacitor #(.c(1.614e-17)) (*
integer library_binding = "analogLib";

 *)
c1804 ( \4:MLT3_TDATA_1p0(1) , \ADC_1p0(2)  );
capacitor #(.c(4.723e-15)) (*
integer library_binding = "analogLib";

 *)
c1805 ( \4:MLT3_TDATA_1p0(1) , GND );
capacitor #(.c(1.835e-17)) (*
integer library_binding = "analogLib";

 *)
c1806 ( \4:MLT3_TDATA_1p0(1) , \FLASH_1p0(0)  );
capacitor #(.c(2.022e-17)) (*
integer library_binding = "analogLib";

 *)
c1807 ( \4:MLT3_TDATA_1p0(1) , \2:ADC_1p0(5)  );
capacitor #(.c(1.514e-16)) (*
integer library_binding = "analogLib";

 *)
c1808 ( \TEST_MODE(0) , \4:GND  );
capacitor #(.c(2.178e-17)) (*
integer library_binding = "analogLib";

 *)
c1809 ( \TEST_MODE(0) , \TX_AMPTRIM_1p0(1)  );
capacitor #(.c(2.084e-17)) (*
integer library_binding = "analogLib";

 *)
c1810 ( \TEST_MODE(0) , \3:TX_AMPTRIM_1p0(0)  );
capacitor #(.c(2.131e-17)) (*
integer library_binding = "analogLib";

 *)
c1811 ( \TEST_MODE(0) , \3:X_160  );
capacitor #(.c(2.112e-17)) (*
integer library_binding = "analogLib";

 *)
c1812 ( \TEST_MODE(0) , \3:POS_DETECT_1p0  );
capacitor #(.c(1.31e-15)) (*
integer library_binding = "analogLib";

 *)
c1813 ( \TEST_MODE(0) , \3:TX_SLOPETRIM_1p0(0)  );
capacitor #(.c(2.176e-17)) (*
integer library_binding = "analogLib";

 *)
c1814 ( \TEST_MODE(0) , RX10_PRESENT_1p0 );
capacitor #(.c(2.176e-17)) (*
integer library_binding = "analogLib";

 *)
c1815 ( \TEST_MODE(0) , SLICER_OUT_1p0 );
capacitor #(.c(2.176e-17)) (*
integer library_binding = "analogLib";

 *)
c1816 ( \TEST_MODE(0) , X_125 );
capacitor #(.c(2.176e-17)) (*
integer library_binding = "analogLib";

 *)
c1817 ( \TEST_MODE(0) , \MLT3_TDATA_1p0(0)  );
capacitor #(.c(2.889e-18)) (*
integer library_binding = "analogLib";

 *)
c1818 ( \TEST_MODE(0) , \5:TXER  );
capacitor #(.c(2.719e-18)) (*
integer library_binding = "analogLib";

 *)
c1819 ( \TEST_MODE(0) , \4:TX_AMPTRIM_1p0(1)  );
capacitor #(.c(2.919e-18)) (*
integer library_binding = "analogLib";

 *)
c1820 ( \TEST_MODE(0) , \TEST_MODE(1)  );
capacitor #(.c(2.094e-17)) (*
integer library_binding = "analogLib";

 *)
c1821 ( \TEST_MODE(0) , \3:TEST_MODE(1)  );
capacitor #(.c(3.526e-18)) (*
integer library_binding = "analogLib";

 *)
c1822 ( \TEST_MODE(0) , POS_DETECT_1p0 );
capacitor #(.c(2.178e-16)) (*
integer library_binding = "analogLib";

 *)
c1823 ( \TEST_MODE(0) , \4:MR_SQUELCH_RANGE_1p0(1)  );
capacitor #(.c(3.334e-18)) (*
integer library_binding = "analogLib";

 *)
c1824 ( \TEST_MODE(0) , X_160 );
capacitor #(.c(1.516e-15)) (*
integer library_binding = "analogLib";

 *)
c1825 ( \TEST_MODE(0) , \MR_SQUELCH_RANGE_1p0(1)  );
capacitor #(.c(3.011e-18)) (*
integer library_binding = "analogLib";

 *)
c1826 ( \TEST_MODE(0) , \TX_AMPTRIM_1p0(0)  );
capacitor #(.c(4.019e-16)) (*
integer library_binding = "analogLib";

 *)
c1827 ( \TEST_MODE(0) , \TX_SLOPETRIM_1p0(0)  );
capacitor #(.c(2.334e-15)) (*
integer library_binding = "analogLib";

 *)
c1828 ( \TEST_MODE(0) , GND );
capacitor #(.c(1.924e-16)) (*
integer library_binding = "analogLib";

 *)
c1829 ( \4:TEST_MODE(0) , \4:GND  );
capacitor #(.c(2.866e-18)) (*
integer library_binding = "analogLib";

 *)
c1830 ( \4:TEST_MODE(0) , \TX_AMPTRIM_1p0(1)  );
capacitor #(.c(1.993e-17)) (*
integer library_binding = "analogLib";

 *)
c1831 ( \4:TEST_MODE(0) , \4:MLT3_TDATA_1p0(0)  );
capacitor #(.c(3.248e-18)) (*
integer library_binding = "analogLib";

 *)
c1832 ( \4:TEST_MODE(0) , \3:TX_AMPTRIM_1p0(0)  );
capacitor #(.c(3.023e-18)) (*
integer library_binding = "analogLib";

 *)
c1833 ( \4:TEST_MODE(0) , \3:X_160  );
capacitor #(.c(1.853e-17)) (*
integer library_binding = "analogLib";

 *)
c1834 ( \4:TEST_MODE(0) , \4:SLICER_OUT_1p0  );
capacitor #(.c(2.034e-17)) (*
integer library_binding = "analogLib";

 *)
c1835 ( \4:TEST_MODE(0) , \4:RX10_PRESENT_1p0  );
capacitor #(.c(2.866e-18)) (*
integer library_binding = "analogLib";

 *)
c1836 ( \4:TEST_MODE(0) , \3:POS_DETECT_1p0  );
capacitor #(.c(1.921e-16)) (*
integer library_binding = "analogLib";

 *)
c1837 ( \4:TEST_MODE(0) , \3:TX_SLOPETRIM_1p0(0)  );
capacitor #(.c(1.962e-17)) (*
integer library_binding = "analogLib";

 *)
c1838 ( \4:TEST_MODE(0) , \4:X_125  );
capacitor #(.c(6.667e-19)) (*
integer library_binding = "analogLib";

 *)
c1839 ( \4:TEST_MODE(0) , RX10_PRESENT_1p0 );
capacitor #(.c(9.465e-19)) (*
integer library_binding = "analogLib";

 *)
c1840 ( \4:TEST_MODE(0) , SLICER_OUT_1p0 );
capacitor #(.c(6.666e-19)) (*
integer library_binding = "analogLib";

 *)
c1841 ( \4:TEST_MODE(0) , X_125 );
capacitor #(.c(1.062e-18)) (*
integer library_binding = "analogLib";

 *)
c1842 ( \4:TEST_MODE(0) , \MLT3_TDATA_1p0(0)  );
capacitor #(.c(1.068e-15)) (*
integer library_binding = "analogLib";

 *)
c1843 ( \4:TEST_MODE(0) , \TX_SLOPETRIM_1p0(0)  );
capacitor #(.c(1.692e-17)) (*
integer library_binding = "analogLib";

 *)
c1844 ( \4:TEST_MODE(0) , \TX_AMPTRIM_1p0(0)  );
capacitor #(.c(3.19e-16)) (*
integer library_binding = "analogLib";

 *)
c1845 ( \4:TEST_MODE(0) , \MR_SQUELCH_RANGE_1p0(1)  );
capacitor #(.c(1.717e-17)) (*
integer library_binding = "analogLib";

 *)
c1846 ( \4:TEST_MODE(0) , X_160 );
capacitor #(.c(1.192e-15)) (*
integer library_binding = "analogLib";

 *)
c1847 ( \4:TEST_MODE(0) , \4:MR_SQUELCH_RANGE_1p0(1)  );
capacitor #(.c(2.965e-15)) (*
integer library_binding = "analogLib";

 *)
c1848 ( \4:TEST_MODE(0) , GND );
capacitor #(.c(1.733e-17)) (*
integer library_binding = "analogLib";

 *)
c1849 ( \4:TEST_MODE(0) , POS_DETECT_1p0 );
capacitor #(.c(3.323e-18)) (*
integer library_binding = "analogLib";

 *)
c1850 ( \4:TEST_MODE(0) , \3:TEST_MODE(1)  );
capacitor #(.c(1.685e-17)) (*
integer library_binding = "analogLib";

 *)
c1851 ( \4:TEST_MODE(0) , \TEST_MODE(1)  );
capacitor #(.c(1.667e-17)) (*
integer library_binding = "analogLib";

 *)
c1852 ( \4:TEST_MODE(0) , \4:TX_AMPTRIM_1p0(1)  );
capacitor #(.c(1.953e-17)) (*
integer library_binding = "analogLib";

 *)
c1853 ( \4:TEST_MODE(0) , \5:TXER  );
capacitor #(.c(1.959e-17)) (*
integer library_binding = "analogLib";

 *)
c1854 ( \4:TEST_MODE(0) , \FLASH_1p0(1)  );
capacitor #(.c(1.959e-17)) (*
integer library_binding = "analogLib";

 *)
c1855 ( \4:TEST_MODE(0) , \1:ADC_1p0(4)  );
capacitor #(.c(2.2e-17)) (*
integer library_binding = "analogLib";

 *)
c1856 ( \4:TEST_MODE(0) , \2:ADC_1p0(0)  );
capacitor #(.c(1.31e-17)) (*
integer library_binding = "analogLib";

 *)
c1857 ( \4:TEST_MODE(0) , \1:RCLK125_1p0  );
capacitor #(.c(1.778e-17)) (*
integer library_binding = "analogLib";

 *)
c1858 ( \4:TEST_MODE(0) , \2:ADC_1p0(3)  );
capacitor #(.c(1.614e-17)) (*
integer library_binding = "analogLib";

 *)
c1859 ( \4:TEST_MODE(0) , \ADC_1p0(2)  );
capacitor #(.c(1.835e-17)) (*
integer library_binding = "analogLib";

 *)
c1860 ( \4:TEST_MODE(0) , \FLASH_1p0(0)  );
capacitor #(.c(2.022e-17)) (*
integer library_binding = "analogLib";

 *)
c1861 ( \4:TEST_MODE(0) , \2:ADC_1p0(5)  );
capacitor #(.c(2.695e-16)) (*
integer library_binding = "analogLib";

 *)
c1862 ( \MLT3_TDATA_2p5(0) , \4:GND  );
capacitor #(.c(1.648e-17)) (*
integer library_binding = "analogLib";

 *)
c1863 ( \MLT3_TDATA_2p5(0) , \4:PHASE_250(8)  );
capacitor #(.c(1.446e-17)) (*
integer library_binding = "analogLib";

 *)
c1864 ( \MLT3_TDATA_2p5(0) , \PHASE_250(8)  );
capacitor #(.c(1.049e-15)) (*
integer library_binding = "analogLib";

 *)
c1865 ( \MLT3_TDATA_2p5(0) , \MLT3_TDATA_2p5(1)  );
capacitor #(.c(2.219e-19)) (*
integer library_binding = "analogLib";

 *)
c1866 ( \MLT3_TDATA_2p5(0) , \5:ADC_TEST_2p5  );
capacitor #(.c(4.281e-15)) (*
integer library_binding = "analogLib";

 *)
c1867 ( \MLT3_TDATA_2p5(0) , TP_DISC_2p5 );
capacitor #(.c(3.717e-17)) (*
integer library_binding = "analogLib";

 *)
c1868 ( \MLT3_TDATA_2p5(0) , \24:VDDTX  );
capacitor #(.c(1.951e-16)) (*
integer library_binding = "analogLib";

 *)
c1869 ( \MLT3_TDATA_2p5(0) , \25:VDDTX  );
capacitor #(.c(2.916e-17)) (*
integer library_binding = "analogLib";

 *)
c1870 ( \MLT3_TDATA_2p5(0) , \PHASE_250(6)  );
capacitor #(.c(2.622e-17)) (*
integer library_binding = "analogLib";

 *)
c1871 ( \MLT3_TDATA_2p5(0) , \4:PHASE_250(6)  );
capacitor #(.c(6.373e-20)) (*
integer library_binding = "analogLib";

 *)
c1872 ( \MLT3_TDATA_2p5(0) , \3:XTAL25  );
capacitor #(.c(1.53e-17)) (*
integer library_binding = "analogLib";

 *)
c1873 ( \MLT3_TDATA_2p5(0) , \6:XTAL25  );
capacitor #(.c(1.482e-15)) (*
integer library_binding = "analogLib";

 *)
c1874 ( \MLT3_TDATA_2p5(0) , \3:TP_DISC_2p5  );
capacitor #(.c(1.778e-17)) (*
integer library_binding = "analogLib";

 *)
c1875 ( \MLT3_TDATA_2p5(0) , \3:RCLK125_TST_SEL  );
capacitor #(.c(1.072e-17)) (*
integer library_binding = "analogLib";

 *)
c1876 ( \MLT3_TDATA_2p5(0) , RCLK125_TST_SEL );
capacitor #(.c(1.658e-16)) (*
integer library_binding = "analogLib";

 *)
c1877 ( \MLT3_TDATA_2p5(0) , \23:GNDTX  );
capacitor #(.c(4.331e-17)) (*
integer library_binding = "analogLib";

 *)
c1878 ( \MLT3_TDATA_2p5(0) , \4:PHASE_250(10)  );
capacitor #(.c(3.957e-17)) (*
integer library_binding = "analogLib";

 *)
c1879 ( \MLT3_TDATA_2p5(0) , \PHASE_250(10)  );
capacitor #(.c(1.685e-17)) (*
integer library_binding = "analogLib";

 *)
c1880 ( \MLT3_TDATA_2p5(0) , ADC_TEST_2p5 );
capacitor #(.c(3.01e-17)) (*
integer library_binding = "analogLib";

 *)
c1881 ( \MLT3_TDATA_2p5(0) , \4:PHASE_250(4)  );
capacitor #(.c(3.594e-17)) (*
integer library_binding = "analogLib";

 *)
c1882 ( \MLT3_TDATA_2p5(0) , \PHASE_250(4)  );
capacitor #(.c(4.49e-16)) (*
integer library_binding = "analogLib";

 *)
c1883 ( \MLT3_TDATA_2p5(0) , \4:PHASE_IN(9)  );
capacitor #(.c(2.102e-17)) (*
integer library_binding = "analogLib";

 *)
c1884 ( \MLT3_TDATA_2p5(0) , \PHASE_IN(0)  );
capacitor #(.c(1.331e-17)) (*
integer library_binding = "analogLib";

 *)
c1885 ( \MLT3_TDATA_2p5(0) , RESET_DSP );
capacitor #(.c(1.228e-14)) (*
integer library_binding = "analogLib";

 *)
c1886 ( \MLT3_TDATA_2p5(0) , \4:MLT3_TDATA_2p5(1)  );
capacitor #(.c(8.411e-17)) (*
integer library_binding = "analogLib";

 *)
c1887 ( \MLT3_TDATA_2p5(0) , \22:GNDTX  );
capacitor #(.c(1.209e-18)) (*
integer library_binding = "analogLib";

 *)
c1888 ( \MLT3_TDATA_2p5(0) , I_RPOLY_REF100 );
capacitor #(.c(2.48e-18)) (*
integer library_binding = "analogLib";

 *)
c1889 ( \MLT3_TDATA_2p5(0) , \5:PHASE_IN(7)  );
capacitor #(.c(4.207e-15)) (*
integer library_binding = "analogLib";

 *)
c1890 ( \MLT3_TDATA_2p5(0) , GND );
capacitor #(.c(3.524e-16)) (*
integer library_binding = "analogLib";

 *)
c1891 ( \3:MLT3_TDATA_2p5(0) , \4:GND  );
capacitor #(.c(6.655e-20)) (*
integer library_binding = "analogLib";

 *)
c1892 ( \3:MLT3_TDATA_2p5(0) , \4:PHASE_250(8)  );
capacitor #(.c(5.841e-20)) (*
integer library_binding = "analogLib";

 *)
c1893 ( \3:MLT3_TDATA_2p5(0) , \PHASE_250(8)  );
capacitor #(.c(1.087e-14)) (*
integer library_binding = "analogLib";

 *)
c1894 ( \3:MLT3_TDATA_2p5(0) , \MLT3_TDATA_2p5(1)  );
capacitor #(.c(2.935e-16)) (*
integer library_binding = "analogLib";

 *)
c1895 ( \3:MLT3_TDATA_2p5(0) , TP_DISC_2p5 );
capacitor #(.c(8.88e-17)) (*
integer library_binding = "analogLib";

 *)
c1896 ( \3:MLT3_TDATA_2p5(0) , \24:VDDTX  );
capacitor #(.c(4.662e-16)) (*
integer library_binding = "analogLib";

 *)
c1897 ( \3:MLT3_TDATA_2p5(0) , \25:VDDTX  );
capacitor #(.c(2.738e-19)) (*
integer library_binding = "analogLib";

 *)
c1898 ( \3:MLT3_TDATA_2p5(0) , \PHASE_250(6)  );
capacitor #(.c(2.462e-19)) (*
integer library_binding = "analogLib";

 *)
c1899 ( \3:MLT3_TDATA_2p5(0) , \4:PHASE_250(6)  );
capacitor #(.c(2.737e-15)) (*
integer library_binding = "analogLib";

 *)
c1900 ( \3:MLT3_TDATA_2p5(0) , \3:TP_DISC_2p5  );
capacitor #(.c(6.496e-20)) (*
integer library_binding = "analogLib";

 *)
c1901 ( \3:MLT3_TDATA_2p5(0) , \3:RCLK125_TST_SEL  );
capacitor #(.c(3.918e-20)) (*
integer library_binding = "analogLib";

 *)
c1902 ( \3:MLT3_TDATA_2p5(0) , RCLK125_TST_SEL );
capacitor #(.c(1.557e-18)) (*
integer library_binding = "analogLib";

 *)
c1903 ( \3:MLT3_TDATA_2p5(0) , \23:GNDTX  );
capacitor #(.c(4.067e-19)) (*
integer library_binding = "analogLib";

 *)
c1904 ( \3:MLT3_TDATA_2p5(0) , \4:PHASE_250(10)  );
capacitor #(.c(3.716e-19)) (*
integer library_binding = "analogLib";

 *)
c1905 ( \3:MLT3_TDATA_2p5(0) , \PHASE_250(10)  );
capacitor #(.c(2.827e-19)) (*
integer library_binding = "analogLib";

 *)
c1906 ( \3:MLT3_TDATA_2p5(0) , \4:PHASE_250(4)  );
capacitor #(.c(3.375e-19)) (*
integer library_binding = "analogLib";

 *)
c1907 ( \3:MLT3_TDATA_2p5(0) , \PHASE_250(4)  );
capacitor #(.c(1.25e-19)) (*
integer library_binding = "analogLib";

 *)
c1908 ( \3:MLT3_TDATA_2p5(0) , RESET_DSP );
capacitor #(.c(9.311e-16)) (*
integer library_binding = "analogLib";

 *)
c1909 ( \3:MLT3_TDATA_2p5(0) , \4:MLT3_TDATA_2p5(1)  );
capacitor #(.c(3.322e-17)) (*
integer library_binding = "analogLib";

 *)
c1910 ( \3:MLT3_TDATA_2p5(0) , \5:PHASE_IN(7)  );
capacitor #(.c(1.006e-16)) (*
integer library_binding = "analogLib";

 *)
c1911 ( \3:MLT3_TDATA_2p5(0) , \PHASE_IN(0)  );
capacitor #(.c(1.62e-17)) (*
integer library_binding = "analogLib";

 *)
c1912 ( \3:MLT3_TDATA_2p5(0) , I_RPOLY_REF100 );
capacitor #(.c(5.533e-16)) (*
integer library_binding = "analogLib";

 *)
c1913 ( \3:MLT3_TDATA_2p5(0) , \4:PHASE_IN(9)  );
capacitor #(.c(5.431e-15)) (*
integer library_binding = "analogLib";

 *)
c1914 ( \3:MLT3_TDATA_2p5(0) , GND );
capacitor #(.c(5.447e-16)) (*
integer library_binding = "analogLib";

 *)
c1915 ( \3:MLT3_TDATA_2p5(0) , \22:GNDTX  );
capacitor #(.c(1.375e-16)) (*
integer library_binding = "analogLib";

 *)
c1916 ( \I_REXT_100(5) , \4:GND  );
capacitor #(.c(4.589e-16)) (*
integer library_binding = "analogLib";

 *)
c1917 ( \I_REXT_100(5) , \I_REXT_100(6)  );
capacitor #(.c(1.681e-18)) (*
integer library_binding = "analogLib";

 *)
c1918 ( \I_REXT_100(5) , POS_DETECT_2p5 );
capacitor #(.c(1.174e-18)) (*
integer library_binding = "analogLib";

 *)
c1919 ( \I_REXT_100(5) , \5:POS_DETECT_2p5  );
capacitor #(.c(1.649e-18)) (*
integer library_binding = "analogLib";

 *)
c1920 ( \I_REXT_100(5) , \4:NEG_DETECT_2p5  );
capacitor #(.c(1.207e-18)) (*
integer library_binding = "analogLib";

 *)
c1921 ( \I_REXT_100(5) , NEG_DETECT_2p5 );
capacitor #(.c(5.085e-16)) (*
integer library_binding = "analogLib";

 *)
c1922 ( \I_REXT_100(5) , \I_REXT_100(4)  );
capacitor #(.c(1.262e-17)) (*
integer library_binding = "analogLib";

 *)
c1923 ( \I_REXT_100(5) , \2:I_REXT_50(1)  );
capacitor #(.c(1.626e-14)) (*
integer library_binding = "analogLib";

 *)
c1924 ( \I_REXT_100(5) , \2:I_REXT_100(4)  );
capacitor #(.c(6.421e-17)) (*
integer library_binding = "analogLib";

 *)
c1925 ( \I_REXT_100(5) , \4:I_REXT_100(4)  );
capacitor #(.c(1.635e-14)) (*
integer library_binding = "analogLib";

 *)
c1926 ( \I_REXT_100(5) , \2:I_REXT_100(6)  );
capacitor #(.c(2.495e-17)) (*
integer library_binding = "analogLib";

 *)
c1927 ( \I_REXT_100(5) , \25:GND  );
capacitor #(.c(2.132e-15)) (*
integer library_binding = "analogLib";

 *)
c1928 ( \I_REXT_100(5) , GND );
capacitor #(.c(1.11e-16)) (*
integer library_binding = "analogLib";

 *)
c1929 ( \4:I_REXT_100(5) , \4:GND  );
capacitor #(.c(1.276e-17)) (*
integer library_binding = "analogLib";

 *)
c1930 ( \4:I_REXT_100(5) , \7:I_REXT_50(0)  );
capacitor #(.c(1.28e-14)) (*
integer library_binding = "analogLib";

 *)
c1931 ( \4:I_REXT_100(5) , \4:I_REXT_100(6)  );
capacitor #(.c(1.246e-17)) (*
integer library_binding = "analogLib";

 *)
c1932 ( \4:I_REXT_100(5) , \4:FLASH_1p0(0)  );
capacitor #(.c(1.246e-17)) (*
integer library_binding = "analogLib";

 *)
c1933 ( \4:I_REXT_100(5) , \ADC_1p0(0)  );
capacitor #(.c(1.974e-17)) (*
integer library_binding = "analogLib";

 *)
c1934 ( \4:I_REXT_100(5) , \25:GND  );
capacitor #(.c(3.278e-17)) (*
integer library_binding = "analogLib";

 *)
c1935 ( \4:I_REXT_100(5) , \5:GNDRX  );
capacitor #(.c(1.279e-14)) (*
integer library_binding = "analogLib";

 *)
c1936 ( \4:I_REXT_100(5) , \4:I_REXT_100(4)  );
capacitor #(.c(9.746e-17)) (*
integer library_binding = "analogLib";

 *)
c1937 ( \4:I_REXT_100(5) , \10:VDD  );
capacitor #(.c(9.746e-17)) (*
integer library_binding = "analogLib";

 *)
c1938 ( \4:I_REXT_100(5) , \5:GND  );
capacitor #(.c(5.013e-17)) (*
integer library_binding = "analogLib";

 *)
c1939 ( \4:I_REXT_100(5) , \2:I_REXT_100(6)  );
capacitor #(.c(1.772e-15)) (*
integer library_binding = "analogLib";

 *)
c1940 ( \4:I_REXT_100(5) , GND );
capacitor #(.c(1.22e-17)) (*
integer library_binding = "analogLib";

 *)
c1941 ( \4:I_REXT_100(5) , \ADC_1p0(5)  );
capacitor #(.c(7.331e-17)) (*
integer library_binding = "analogLib";

 *)
c1942 ( \4:I_REXT_100(5) , \6:GNDRX  );
capacitor #(.c(1.504e-17)) (*
integer library_binding = "analogLib";

 *)
c1943 ( \4:I_REXT_100(5) , \3:ADC_1p0(4)  );
capacitor #(.c(6.769e-17)) (*
integer library_binding = "analogLib";

 *)
c1944 ( \3:I_REXT_100(5) , \4:GND  );
capacitor #(.c(1.57e-15)) (*
integer library_binding = "analogLib";

 *)
c1945 ( \3:I_REXT_100(5) , \I_REXT_100(6)  );
capacitor #(.c(5.751e-18)) (*
integer library_binding = "analogLib";

 *)
c1946 ( \3:I_REXT_100(5) , POS_DETECT_2p5 );
capacitor #(.c(4.017e-18)) (*
integer library_binding = "analogLib";

 *)
c1947 ( \3:I_REXT_100(5) , \5:POS_DETECT_2p5  );
capacitor #(.c(5.146e-16)) (*
integer library_binding = "analogLib";

 *)
c1948 ( \3:I_REXT_100(5) , \2:I_REXT_100(6)  );
capacitor #(.c(4.528e-16)) (*
integer library_binding = "analogLib";

 *)
c1949 ( \3:I_REXT_100(5) , \2:I_REXT_100(4)  );
capacitor #(.c(1.563e-15)) (*
integer library_binding = "analogLib";

 *)
c1950 ( \3:I_REXT_100(5) , \I_REXT_100(4)  );
capacitor #(.c(5.64e-18)) (*
integer library_binding = "analogLib";

 *)
c1951 ( \3:I_REXT_100(5) , \4:NEG_DETECT_2p5  );
capacitor #(.c(4.128e-18)) (*
integer library_binding = "analogLib";

 *)
c1952 ( \3:I_REXT_100(5) , NEG_DETECT_2p5 );
capacitor #(.c(1.049e-15)) (*
integer library_binding = "analogLib";

 *)
c1953 ( \3:I_REXT_100(5) , GND );
capacitor #(.c(1.741e-17)) (*
integer library_binding = "analogLib";

 *)
c1954 ( \3:I_REXT_100(5) , \2:I_REXT_50(1)  );
capacitor #(.c(3.495e-20)) (*
integer library_binding = "analogLib";

 *)
c1955 ( GNDTX, GND );
capacitor #(.c(3.113e-15)) (*
integer library_binding = "analogLib";

 *)
c1956 ( \22:GNDTX , \4:GND  );
capacitor #(.c(2.293e-18)) (*
integer library_binding = "analogLib";

 *)
c1957 ( \22:GNDTX , \AEQ_CNT_ANLG(1)  );
capacitor #(.c(1.346e-16)) (*
integer library_binding = "analogLib";

 *)
c1958 ( \22:GNDTX , \TENBT_FILTER_1p0(3)  );
capacitor #(.c(1.452e-16)) (*
integer library_binding = "analogLib";

 *)
c1959 ( \22:GNDTX , \6:TENBT_FILTER_1p0(4)  );
capacitor #(.c(1.401e-16)) (*
integer library_binding = "analogLib";

 *)
c1960 ( \22:GNDTX , RESET_10BT );
capacitor #(.c(3.998e-18)) (*
integer library_binding = "analogLib";

 *)
c1961 ( \22:GNDTX , \WANDER_CNT(2)  );
capacitor #(.c(8.732e-17)) (*
integer library_binding = "analogLib";

 *)
c1962 ( \22:GNDTX , TP_DISC_2p5 );
capacitor #(.c(1.554e-18)) (*
integer library_binding = "analogLib";

 *)
c1963 ( \22:GNDTX , \4:AEQ_CNT_ANLG(2)  );
capacitor #(.c(1.236e-16)) (*
integer library_binding = "analogLib";

 *)
c1964 ( \22:GNDTX , \6:TENBT_FILTER_1p0(2)  );
capacitor #(.c(1.768e-17)) (*
integer library_binding = "analogLib";

 *)
c1965 ( \22:GNDTX , \5:PHASE_IN(5)  );
capacitor #(.c(5.407e-16)) (*
integer library_binding = "analogLib";

 *)
c1966 ( \22:GNDTX , \25:VDDTX  );
capacitor #(.c(1.967e-17)) (*
integer library_binding = "analogLib";

 *)
c1967 ( \22:GNDTX , \7:PHASE_IN(0)  );
capacitor #(.c(1.347e-16)) (*
integer library_binding = "analogLib";

 *)
c1968 ( \22:GNDTX , \TENBT_FILTER_1p0(1)  );
capacitor #(.c(5.403e-18)) (*
integer library_binding = "analogLib";

 *)
c1969 ( \22:GNDTX , \4:AEQ_CNT_ANLG(0)  );
capacitor #(.c(1.034e-18)) (*
integer library_binding = "analogLib";

 *)
c1970 ( \22:GNDTX , \1:PLL_160_IN  );
capacitor #(.c(1.629e-16)) (*
integer library_binding = "analogLib";

 *)
c1971 ( \22:GNDTX , \4:PLL_160_IN  );
capacitor #(.c(5.74e-19)) (*
integer library_binding = "analogLib";

 *)
c1972 ( \22:GNDTX , \3:XTAL25  );
capacitor #(.c(1.378e-16)) (*
integer library_binding = "analogLib";

 *)
c1973 ( \22:GNDTX , \6:XTAL25  );
capacitor #(.c(1.109e-18)) (*
integer library_binding = "analogLib";

 *)
c1974 ( \22:GNDTX , \WANDER_CNT(6)  );
capacitor #(.c(1.235e-16)) (*
integer library_binding = "analogLib";

 *)
c1975 ( \22:GNDTX , \6:TENBT_FILTER_1p0(0)  );
capacitor #(.c(6.987e-17)) (*
integer library_binding = "analogLib";

 *)
c1976 ( \22:GNDTX , \5:PHASE_IN(7)  );
capacitor #(.c(1.319e-16)) (*
integer library_binding = "analogLib";

 *)
c1977 ( \22:GNDTX , \4:I_RPOLY_REF100  );
capacitor #(.c(8.42e-17)) (*
integer library_binding = "analogLib";

 *)
c1978 ( \22:GNDTX , \4:PHASE_IN(8)  );
capacitor #(.c(1.54e-16)) (*
integer library_binding = "analogLib";

 *)
c1979 ( \22:GNDTX , \2:PHASE_IN(1)  );
capacitor #(.c(1.528e-16)) (*
integer library_binding = "analogLib";

 *)
c1980 ( \22:GNDTX , \PHASE_IN(0)  );
capacitor #(.c(1.085e-16)) (*
integer library_binding = "analogLib";

 *)
c1981 ( \22:GNDTX , \4:PHASE_IN(10)  );
capacitor #(.c(8.711e-17)) (*
integer library_binding = "analogLib";

 *)
c1982 ( \22:GNDTX , \4:PHASE_IN(2)  );
capacitor #(.c(7.31e-17)) (*
integer library_binding = "analogLib";

 *)
c1983 ( \22:GNDTX , \4:PHASE_IN(3)  );
capacitor #(.c(1.77e-16)) (*
integer library_binding = "analogLib";

 *)
c1984 ( \22:GNDTX , \4:PHASE_IN(9)  );
capacitor #(.c(8.088e-17)) (*
integer library_binding = "analogLib";

 *)
c1985 ( \22:GNDTX , \2:PHASE_IN(5)  );
capacitor #(.c(3.168e-17)) (*
integer library_binding = "analogLib";

 *)
c1986 ( \22:GNDTX , MR_BYPASS10RX_FILTER );
capacitor #(.c(9.665e-17)) (*
integer library_binding = "analogLib";

 *)
c1987 ( \22:GNDTX , BASEFX_DIS );
capacitor #(.c(3.184e-17)) (*
integer library_binding = "analogLib";

 *)
c1988 ( \22:GNDTX , \6:AEQ_BYPASS  );
capacitor #(.c(2.116e-16)) (*
integer library_binding = "analogLib";

 *)
c1989 ( \22:GNDTX , \AEQ_CNT_ANLG(0)  );
capacitor #(.c(2.127e-16)) (*
integer library_binding = "analogLib";

 *)
c1990 ( \22:GNDTX , \WANDER_CNT(0)  );
capacitor #(.c(1.72e-16)) (*
integer library_binding = "analogLib";

 *)
c1991 ( \22:GNDTX , \5:AEQ_CNT_ANLG(1)  );
capacitor #(.c(1.522e-16)) (*
integer library_binding = "analogLib";

 *)
c1992 ( \22:GNDTX , \AEQ_CNT_ANLG(2)  );
capacitor #(.c(2.109e-16)) (*
integer library_binding = "analogLib";

 *)
c1993 ( \22:GNDTX , \5:WANDER_CNT(2)  );
capacitor #(.c(2.138e-16)) (*
integer library_binding = "analogLib";

 *)
c1994 ( \22:GNDTX , \WANDER_CNT(3)  );
capacitor #(.c(3.161e-17)) (*
integer library_binding = "analogLib";

 *)
c1995 ( \22:GNDTX , \6:T2_MODE  );
capacitor #(.c(2.127e-16)) (*
integer library_binding = "analogLib";

 *)
c1996 ( \22:GNDTX , \5:AEQ_CNT_ANLG(4)  );
capacitor #(.c(2.127e-16)) (*
integer library_binding = "analogLib";

 *)
c1997 ( \22:GNDTX , \5:WANDER_CNT(4)  );
capacitor #(.c(2.149e-16)) (*
integer library_binding = "analogLib";

 *)
c1998 ( \22:GNDTX , \5:WANDER_CNT(6)  );
capacitor #(.c(8.396e-17)) (*
integer library_binding = "analogLib";

 *)
c1999 ( \22:GNDTX , \4:MLT3_TDATA_2p5(1)  );
capacitor #(.c(2.21e-17)) (*
integer library_binding = "analogLib";

 *)
c2000 ( \22:GNDTX , \7:PHASE_IN(9)  );
capacitor #(.c(1.926e-17)) (*
integer library_binding = "analogLib";

 *)
c2001 ( \22:GNDTX , \5:PHASE_IN(1)  );
capacitor #(.c(2.044e-17)) (*
integer library_binding = "analogLib";

 *)
c2002 ( \22:GNDTX , \PHASE_IN(2)  );
capacitor #(.c(1.838e-17)) (*
integer library_binding = "analogLib";

 *)
c2003 ( \22:GNDTX , \7:PHASE_IN(8)  );
capacitor #(.c(4.797e-14)) (*
integer library_binding = "analogLib";

 *)
c2004 ( \22:GNDTX , GND );
capacitor #(.c(4.191e-16)) (*
integer library_binding = "analogLib";

 *)
c2005 ( \22:GNDTX , \5:RESET_10BT  );
capacitor #(.c(5.419e-16)) (*
integer library_binding = "analogLib";

 *)
c2006 ( \22:GNDTX , \MLT3_TDATA_2p5(1)  );
capacitor #(.c(4.141e-16)) (*
integer library_binding = "analogLib";

 *)
c2007 ( \22:GNDTX , \TENBT_FILTER_1p0(4)  );
capacitor #(.c(3.38e-16)) (*
integer library_binding = "analogLib";

 *)
c2008 ( \22:GNDTX , \5:TENBT_FILTER_1p0(3)  );
capacitor #(.c(3.49e-16)) (*
integer library_binding = "analogLib";

 *)
c2009 ( \22:GNDTX , \TENBT_FILTER_1p0(2)  );
capacitor #(.c(3.378e-16)) (*
integer library_binding = "analogLib";

 *)
c2010 ( \22:GNDTX , \5:TENBT_FILTER_1p0(1)  );
capacitor #(.c(3.49e-16)) (*
integer library_binding = "analogLib";

 *)
c2011 ( \22:GNDTX , \TENBT_FILTER_1p0(0)  );
capacitor #(.c(5.336e-16)) (*
integer library_binding = "analogLib";

 *)
c2012 ( \22:GNDTX , \3:TP_DISC_2p5  );
capacitor #(.c(6.833e-15)) (*
integer library_binding = "analogLib";

 *)
c2013 ( \22:GNDTX , \24:VDDTX  );
capacitor #(.c(2.237e-15)) (*
integer library_binding = "analogLib";

 *)
c2014 ( \23:GNDTX , \4:GND  );
capacitor #(.c(5.515e-18)) (*
integer library_binding = "analogLib";

 *)
c2015 ( \23:GNDTX , \AEQ_CNT_ANLG(1)  );
capacitor #(.c(1.421e-18)) (*
integer library_binding = "analogLib";

 *)
c2016 ( \23:GNDTX , \MLT3_TDATA_2p5(1)  );
capacitor #(.c(9.617e-18)) (*
integer library_binding = "analogLib";

 *)
c2017 ( \23:GNDTX , \WANDER_CNT(2)  );
capacitor #(.c(2.066e-18)) (*
integer library_binding = "analogLib";

 *)
c2018 ( \23:GNDTX , \3:TP_DISC_2p5  );
capacitor #(.c(1.621e-16)) (*
integer library_binding = "analogLib";

 *)
c2019 ( \23:GNDTX , TP_DISC_2p5 );
capacitor #(.c(7.103e-17)) (*
integer library_binding = "analogLib";

 *)
c2020 ( \23:GNDTX , TIMING_DN_ANLG );
capacitor #(.c(4.372e-17)) (*
integer library_binding = "analogLib";

 *)
c2021 ( \23:GNDTX , \5:TIMING_DN_ANLG  );
capacitor #(.c(3.737e-18)) (*
integer library_binding = "analogLib";

 *)
c2022 ( \23:GNDTX , \4:AEQ_CNT_ANLG(2)  );
capacitor #(.c(4.254e-17)) (*
integer library_binding = "analogLib";

 *)
c2023 ( \23:GNDTX , \5:PHASE_IN(5)  );
capacitor #(.c(2.477e-16)) (*
integer library_binding = "analogLib";

 *)
c2024 ( \23:GNDTX , \24:VDDTX  );
capacitor #(.c(1.301e-15)) (*
integer library_binding = "analogLib";

 *)
c2025 ( \23:GNDTX , \25:VDDTX  );
capacitor #(.c(4.732e-17)) (*
integer library_binding = "analogLib";

 *)
c2026 ( \23:GNDTX , \7:PHASE_IN(0)  );
capacitor #(.c(1.3e-17)) (*
integer library_binding = "analogLib";

 *)
c2027 ( \23:GNDTX , \4:AEQ_CNT_ANLG(0)  );
capacitor #(.c(1.109e-16)) (*
integer library_binding = "analogLib";

 *)
c2028 ( \23:GNDTX , \7:PHASE_IN(10)  );
capacitor #(.c(2.487e-18)) (*
integer library_binding = "analogLib";

 *)
c2029 ( \23:GNDTX , \1:PLL_160_IN  );
capacitor #(.c(3.919e-16)) (*
integer library_binding = "analogLib";

 *)
c2030 ( \23:GNDTX , \4:PLL_160_IN  );
capacitor #(.c(1.381e-18)) (*
integer library_binding = "analogLib";

 *)
c2031 ( \23:GNDTX , \3:XTAL25  );
capacitor #(.c(3.315e-16)) (*
integer library_binding = "analogLib";

 *)
c2032 ( \23:GNDTX , \6:XTAL25  );
capacitor #(.c(2.668e-18)) (*
integer library_binding = "analogLib";

 *)
c2033 ( \23:GNDTX , \WANDER_CNT(6)  );
capacitor #(.c(8.586e-17)) (*
integer library_binding = "analogLib";

 *)
c2034 ( \23:GNDTX , \7:PHASE_IN(3)  );
capacitor #(.c(9.105e-17)) (*
integer library_binding = "analogLib";

 *)
c2035 ( \23:GNDTX , \6:RESET_DSP  );
capacitor #(.c(5.709e-17)) (*
integer library_binding = "analogLib";

 *)
c2036 ( \23:GNDTX , RESET_DSP );
capacitor #(.c(5.72e-17)) (*
integer library_binding = "analogLib";

 *)
c2037 ( \23:GNDTX , TIMING_UP_ANLG );
capacitor #(.c(9.209e-17)) (*
integer library_binding = "analogLib";

 *)
c2038 ( \23:GNDTX , \6:TIMING_UP_ANLG  );
capacitor #(.c(3.172e-16)) (*
integer library_binding = "analogLib";

 *)
c2039 ( \23:GNDTX , \4:I_RPOLY_REF100  );
capacitor #(.c(2.025e-16)) (*
integer library_binding = "analogLib";

 *)
c2040 ( \23:GNDTX , \4:PHASE_IN(8)  );
capacitor #(.c(3.705e-16)) (*
integer library_binding = "analogLib";

 *)
c2041 ( \23:GNDTX , \2:PHASE_IN(1)  );
capacitor #(.c(3.675e-16)) (*
integer library_binding = "analogLib";

 *)
c2042 ( \23:GNDTX , \PHASE_IN(0)  );
capacitor #(.c(2.774e-16)) (*
integer library_binding = "analogLib";

 *)
c2043 ( \23:GNDTX , \4:PHASE_IN(10)  );
capacitor #(.c(2.096e-16)) (*
integer library_binding = "analogLib";

 *)
c2044 ( \23:GNDTX , \4:PHASE_IN(2)  );
capacitor #(.c(2.171e-16)) (*
integer library_binding = "analogLib";

 *)
c2045 ( \23:GNDTX , \4:PHASE_IN(3)  );
capacitor #(.c(4.258e-16)) (*
integer library_binding = "analogLib";

 *)
c2046 ( \23:GNDTX , \4:PHASE_IN(9)  );
capacitor #(.c(1.946e-16)) (*
integer library_binding = "analogLib";

 *)
c2047 ( \23:GNDTX , \2:PHASE_IN(5)  );
capacitor #(.c(7.62e-17)) (*
integer library_binding = "analogLib";

 *)
c2048 ( \23:GNDTX , MR_BYPASS10RX_FILTER );
capacitor #(.c(2.325e-16)) (*
integer library_binding = "analogLib";

 *)
c2049 ( \23:GNDTX , BASEFX_DIS );
capacitor #(.c(7.66e-17)) (*
integer library_binding = "analogLib";

 *)
c2050 ( \23:GNDTX , \6:AEQ_BYPASS  );
capacitor #(.c(5.091e-16)) (*
integer library_binding = "analogLib";

 *)
c2051 ( \23:GNDTX , \AEQ_CNT_ANLG(0)  );
capacitor #(.c(5.118e-16)) (*
integer library_binding = "analogLib";

 *)
c2052 ( \23:GNDTX , \WANDER_CNT(0)  );
capacitor #(.c(4.137e-16)) (*
integer library_binding = "analogLib";

 *)
c2053 ( \23:GNDTX , \5:AEQ_CNT_ANLG(1)  );
capacitor #(.c(3.66e-16)) (*
integer library_binding = "analogLib";

 *)
c2054 ( \23:GNDTX , \AEQ_CNT_ANLG(2)  );
capacitor #(.c(5.073e-16)) (*
integer library_binding = "analogLib";

 *)
c2055 ( \23:GNDTX , \5:WANDER_CNT(2)  );
capacitor #(.c(5.143e-16)) (*
integer library_binding = "analogLib";

 *)
c2056 ( \23:GNDTX , \WANDER_CNT(3)  );
capacitor #(.c(7.605e-17)) (*
integer library_binding = "analogLib";

 *)
c2057 ( \23:GNDTX , \6:T2_MODE  );
capacitor #(.c(5.118e-16)) (*
integer library_binding = "analogLib";

 *)
c2058 ( \23:GNDTX , \5:AEQ_CNT_ANLG(4)  );
capacitor #(.c(5.118e-16)) (*
integer library_binding = "analogLib";

 *)
c2059 ( \23:GNDTX , \5:WANDER_CNT(4)  );
capacitor #(.c(5.168e-16)) (*
integer library_binding = "analogLib";

 *)
c2060 ( \23:GNDTX , \5:WANDER_CNT(6)  );
capacitor #(.c(1.667e-16)) (*
integer library_binding = "analogLib";

 *)
c2061 ( \23:GNDTX , \4:MLT3_TDATA_2p5(1)  );
capacitor #(.c(5.316e-17)) (*
integer library_binding = "analogLib";

 *)
c2062 ( \23:GNDTX , \7:PHASE_IN(9)  );
capacitor #(.c(4.632e-17)) (*
integer library_binding = "analogLib";

 *)
c2063 ( \23:GNDTX , \5:PHASE_IN(1)  );
capacitor #(.c(4.916e-17)) (*
integer library_binding = "analogLib";

 *)
c2064 ( \23:GNDTX , \PHASE_IN(2)  );
capacitor #(.c(4.421e-17)) (*
integer library_binding = "analogLib";

 *)
c2065 ( \23:GNDTX , \7:PHASE_IN(8)  );
capacitor #(.c(1.463e-16)) (*
integer library_binding = "analogLib";

 *)
c2066 ( \23:GNDTX , \9:BASEFX_DIS  );
capacitor #(.c(1.878e-18)) (*
integer library_binding = "analogLib";

 *)
c2067 ( \23:GNDTX , \5:BASEFX_DIS  );
capacitor #(.c(1.81e-16)) (*
integer library_binding = "analogLib";

 *)
c2068 ( \23:GNDTX , \5:PHASE_IN(7)  );
capacitor #(.c(6.301e-17)) (*
integer library_binding = "analogLib";

 *)
c2069 ( \23:GNDTX , \7:PHASE_IN(7)  );
capacitor #(.c(3.447e-14)) (*
integer library_binding = "analogLib";

 *)
c2070 ( \23:GNDTX , GND );
capacitor #(.c(7.895e-17)) (*
integer library_binding = "analogLib";

 *)
c2071 ( RCLK125_TST_SEL, \4:GND  );
capacitor #(.c(5.6e-17)) (*
integer library_binding = "analogLib";

 *)
c2072 ( RCLK125_TST_SEL, \PHASE_250(8)  );
capacitor #(.c(3.566e-20)) (*
integer library_binding = "analogLib";

 *)
c2073 ( RCLK125_TST_SEL, \MLT3_TDATA_2p5(1)  );
capacitor #(.c(7.974e-19)) (*
integer library_binding = "analogLib";

 *)
c2074 ( RCLK125_TST_SEL, \5:ADC_TEST_2p5  );
capacitor #(.c(4.464e-20)) (*
integer library_binding = "analogLib";

 *)
c2075 ( RCLK125_TST_SEL, \3:TP_DISC_2p5  );
capacitor #(.c(9.238e-19)) (*
integer library_binding = "analogLib";

 *)
c2076 ( RCLK125_TST_SEL, \9:TX100_DIS_2p5  );
capacitor #(.c(3.565e-18)) (*
integer library_binding = "analogLib";

 *)
c2077 ( RCLK125_TST_SEL, \2:TX100_DIS_2p5  );
capacitor #(.c(1.326e-17)) (*
integer library_binding = "analogLib";

 *)
c2078 ( RCLK125_TST_SEL, TIMING_DN_ANLG );
capacitor #(.c(1.044e-18)) (*
integer library_binding = "analogLib";

 *)
c2079 ( RCLK125_TST_SEL, \5:ADC_DIS_2p5  );
capacitor #(.c(1.711e-16)) (*
integer library_binding = "analogLib";

 *)
c2080 ( RCLK125_TST_SEL, \4:PHASE_250(8)  );
capacitor #(.c(1.476e-18)) (*
integer library_binding = "analogLib";

 *)
c2081 ( RCLK125_TST_SEL, RX10_PRESENT_2p5 );
capacitor #(.c(1.439e-18)) (*
integer library_binding = "analogLib";

 *)
c2082 ( RCLK125_TST_SEL, \MR_SQUELCH_RANGE_2p5(0)  );
capacitor #(.c(4.157e-20)) (*
integer library_binding = "analogLib";

 *)
c2083 ( RCLK125_TST_SEL, \1:PLL_160_IN  );
capacitor #(.c(8.868e-19)) (*
integer library_binding = "analogLib";

 *)
c2084 ( RCLK125_TST_SEL, \3:XTAL25  );
capacitor #(.c(2.129e-16)) (*
integer library_binding = "analogLib";

 *)
c2085 ( RCLK125_TST_SEL, \6:XTAL25  );
capacitor #(.c(4.025e-18)) (*
integer library_binding = "analogLib";

 *)
c2086 ( RCLK125_TST_SEL, \6:RESET_DSP  );
capacitor #(.c(2.524e-18)) (*
integer library_binding = "analogLib";

 *)
c2087 ( RCLK125_TST_SEL, RESET_DSP );
capacitor #(.c(7.54e-18)) (*
integer library_binding = "analogLib";

 *)
c2088 ( RCLK125_TST_SEL, \2:I_REXT_50(0)  );
capacitor #(.c(2.076e-16)) (*
integer library_binding = "analogLib";

 *)
c2089 ( RCLK125_TST_SEL, \5:TIMING_DN_ANLG  );
capacitor #(.c(1.044e-16)) (*
integer library_binding = "analogLib";

 *)
c2090 ( RCLK125_TST_SEL, \4:PHASE_IN(10)  );
capacitor #(.c(1.073e-17)) (*
integer library_binding = "analogLib";

 *)
c2091 ( RCLK125_TST_SEL, \4:MLT3_TDATA_2p5(1)  );
capacitor #(.c(1.31e-17)) (*
integer library_binding = "analogLib";

 *)
c2092 ( RCLK125_TST_SEL, \4:PLL_160_IN  );
capacitor #(.c(5.147e-18)) (*
integer library_binding = "analogLib";

 *)
c2093 ( RCLK125_TST_SEL, \4:I_RPOLY_REF100  );
capacitor #(.c(1.005e-17)) (*
integer library_binding = "analogLib";

 *)
c2094 ( RCLK125_TST_SEL, TP_DISC_2p5 );
capacitor #(.c(8.513e-18)) (*
integer library_binding = "analogLib";

 *)
c2095 ( RCLK125_TST_SEL, \5:PHASE_IN(7)  );
capacitor #(.c(1.051e-18)) (*
integer library_binding = "analogLib";

 *)
c2096 ( RCLK125_TST_SEL, \3:MR_SQUELCH_RANGE_2p5(1)  );
capacitor #(.c(1.285e-18)) (*
integer library_binding = "analogLib";

 *)
c2097 ( RCLK125_TST_SEL, AEQ_DIS_2p5 );
capacitor #(.c(2.353e-17)) (*
integer library_binding = "analogLib";

 *)
c2098 ( RCLK125_TST_SEL, ADC_DIS_2p5 );
capacitor #(.c(1.728e-17)) (*
integer library_binding = "analogLib";

 *)
c2099 ( RCLK125_TST_SEL, MR_SQUELCH_DISB_2p5 );
capacitor #(.c(2.181e-17)) (*
integer library_binding = "analogLib";

 *)
c2100 ( RCLK125_TST_SEL, ADC_TEST_2p5 );
capacitor #(.c(2.489e-17)) (*
integer library_binding = "analogLib";

 *)
c2101 ( RCLK125_TST_SEL, \6:AEQ_DIS_2p5  );
capacitor #(.c(2.098e-17)) (*
integer library_binding = "analogLib";

 *)
c2102 ( RCLK125_TST_SEL, \4:MR_SQUELCH_RANGE_2p5(0)  );
capacitor #(.c(2.001e-17)) (*
integer library_binding = "analogLib";

 *)
c2103 ( RCLK125_TST_SEL, \MR_SQUELCH_RANGE_2p5(1)  );
capacitor #(.c(2.334e-17)) (*
integer library_binding = "analogLib";

 *)
c2104 ( RCLK125_TST_SEL, \6:RX10_PRESENT_2p5  );
capacitor #(.c(1.728e-17)) (*
integer library_binding = "analogLib";

 *)
c2105 ( RCLK125_TST_SEL, BLW_DIS_2p5 );
capacitor #(.c(1.22e-15)) (*
integer library_binding = "analogLib";

 *)
c2106 ( RCLK125_TST_SEL, GND );
capacitor #(.c(9.095e-17)) (*
integer library_binding = "analogLib";

 *)
c2107 ( \3:RCLK125_TST_SEL , \4:GND  );
capacitor #(.c(3.53e-17)) (*
integer library_binding = "analogLib";

 *)
c2108 ( \3:RCLK125_TST_SEL , \PHASE_250(8)  );
capacitor #(.c(5.912e-20)) (*
integer library_binding = "analogLib";

 *)
c2109 ( \3:RCLK125_TST_SEL , \MLT3_TDATA_2p5(1)  );
capacitor #(.c(1.322e-18)) (*
integer library_binding = "analogLib";

 *)
c2110 ( \3:RCLK125_TST_SEL , \5:ADC_TEST_2p5  );
capacitor #(.c(4.606e-18)) (*
integer library_binding = "analogLib";

 *)
c2111 ( \3:RCLK125_TST_SEL , \3:MR_SQUELCH_DISB_2p5  );
capacitor #(.c(7.401e-20)) (*
integer library_binding = "analogLib";

 *)
c2112 ( \3:RCLK125_TST_SEL , \3:TP_DISC_2p5  );
capacitor #(.c(1.532e-18)) (*
integer library_binding = "analogLib";

 *)
c2113 ( \3:RCLK125_TST_SEL , \9:TX100_DIS_2p5  );
capacitor #(.c(5.912e-18)) (*
integer library_binding = "analogLib";

 *)
c2114 ( \3:RCLK125_TST_SEL , \2:TX100_DIS_2p5  );
capacitor #(.c(2.198e-17)) (*
integer library_binding = "analogLib";

 *)
c2115 ( \3:RCLK125_TST_SEL , TIMING_DN_ANLG );
capacitor #(.c(1.731e-18)) (*
integer library_binding = "analogLib";

 *)
c2116 ( \3:RCLK125_TST_SEL , \5:ADC_DIS_2p5  );
capacitor #(.c(1.501e-17)) (*
integer library_binding = "analogLib";

 *)
c2117 ( \3:RCLK125_TST_SEL , \6:I_REXT_50(1)  );
capacitor #(.c(1.595e-19)) (*
integer library_binding = "analogLib";

 *)
c2118 ( \3:RCLK125_TST_SEL , \2:I_REXT_50(1)  );
capacitor #(.c(4.103e-17)) (*
integer library_binding = "analogLib";

 *)
c2119 ( \3:RCLK125_TST_SEL , \4:PHASE_250(8)  );
capacitor #(.c(2.448e-18)) (*
integer library_binding = "analogLib";

 *)
c2120 ( \3:RCLK125_TST_SEL , RX10_PRESENT_2p5 );
capacitor #(.c(2.386e-18)) (*
integer library_binding = "analogLib";

 *)
c2121 ( \3:RCLK125_TST_SEL , \MR_SQUELCH_RANGE_2p5(0)  );
capacitor #(.c(6.892e-20)) (*
integer library_binding = "analogLib";

 *)
c2122 ( \3:RCLK125_TST_SEL , \1:PLL_160_IN  );
capacitor #(.c(4.517e-19)) (*
integer library_binding = "analogLib";

 *)
c2123 ( \3:RCLK125_TST_SEL , \3:XTAL25  );
capacitor #(.c(1.084e-16)) (*
integer library_binding = "analogLib";

 *)
c2124 ( \3:RCLK125_TST_SEL , \6:XTAL25  );
capacitor #(.c(6.674e-18)) (*
integer library_binding = "analogLib";

 *)
c2125 ( \3:RCLK125_TST_SEL , \6:RESET_DSP  );
capacitor #(.c(4.185e-18)) (*
integer library_binding = "analogLib";

 *)
c2126 ( \3:RCLK125_TST_SEL , RESET_DSP );
capacitor #(.c(4.088e-18)) (*
integer library_binding = "analogLib";

 *)
c2127 ( \3:RCLK125_TST_SEL , \5:BLW_DIS_2p5  );
capacitor #(.c(1.25e-17)) (*
integer library_binding = "analogLib";

 *)
c2128 ( \3:RCLK125_TST_SEL , \2:I_REXT_50(0)  );
capacitor #(.c(1.731e-16)) (*
integer library_binding = "analogLib";

 *)
c2129 ( \3:RCLK125_TST_SEL , \4:PHASE_IN(10)  );
capacitor #(.c(1.779e-17)) (*
integer library_binding = "analogLib";

 *)
c2130 ( \3:RCLK125_TST_SEL , \4:MLT3_TDATA_2p5(1)  );
capacitor #(.c(2.172e-17)) (*
integer library_binding = "analogLib";

 *)
c2131 ( \3:RCLK125_TST_SEL , \4:PLL_160_IN  );
capacitor #(.c(8.534e-18)) (*
integer library_binding = "analogLib";

 *)
c2132 ( \3:RCLK125_TST_SEL , \4:I_RPOLY_REF100  );
capacitor #(.c(1.667e-17)) (*
integer library_binding = "analogLib";

 *)
c2133 ( \3:RCLK125_TST_SEL , TP_DISC_2p5 );
capacitor #(.c(1.412e-17)) (*
integer library_binding = "analogLib";

 *)
c2134 ( \3:RCLK125_TST_SEL , \5:PHASE_IN(7)  );
capacitor #(.c(8.727e-18)) (*
integer library_binding = "analogLib";

 *)
c2135 ( \3:RCLK125_TST_SEL , BLW_DIS_2p5 );
capacitor #(.c(1.018e-17)) (*
integer library_binding = "analogLib";

 *)
c2136 ( \3:RCLK125_TST_SEL , \6:RX10_PRESENT_2p5  );
capacitor #(.c(4.653e-18)) (*
integer library_binding = "analogLib";

 *)
c2137 ( \3:RCLK125_TST_SEL , \MR_SQUELCH_RANGE_2p5(1)  );
capacitor #(.c(6.265e-18)) (*
integer library_binding = "analogLib";

 *)
c2138 ( \3:RCLK125_TST_SEL , \4:MR_SQUELCH_RANGE_2p5(0)  );
capacitor #(.c(1.274e-17)) (*
integer library_binding = "analogLib";

 *)
c2139 ( \3:RCLK125_TST_SEL , \6:AEQ_DIS_2p5  );
capacitor #(.c(7.637e-18)) (*
integer library_binding = "analogLib";

 *)
c2140 ( \3:RCLK125_TST_SEL , ADC_TEST_2p5 );
capacitor #(.c(8.434e-18)) (*
integer library_binding = "analogLib";

 *)
c2141 ( \3:RCLK125_TST_SEL , MR_SQUELCH_DISB_2p5 );
capacitor #(.c(1.049e-17)) (*
integer library_binding = "analogLib";

 *)
c2142 ( \3:RCLK125_TST_SEL , ADC_DIS_2p5 );
capacitor #(.c(1.742e-18)) (*
integer library_binding = "analogLib";

 *)
c2143 ( \3:RCLK125_TST_SEL , \3:MR_SQUELCH_RANGE_2p5(1)  );
capacitor #(.c(2.13e-18)) (*
integer library_binding = "analogLib";

 *)
c2144 ( \3:RCLK125_TST_SEL , AEQ_DIS_2p5 );
capacitor #(.c(1.408e-15)) (*
integer library_binding = "analogLib";

 *)
c2145 ( \3:RCLK125_TST_SEL , GND );
capacitor #(.c(9.343e-16)) (*
integer library_binding = "analogLib";

 *)
c2146 ( \3:RCLK125_TST_SEL , \5:TIMING_DN_ANLG  );
capacitor #(.c(1.042e-17)) (*
integer library_binding = "analogLib";

 *)
c2147 ( \3:RCLK125_TST_SEL , \3:X10_DIS_2p5  );
capacitor #(.c(5.348e-16)) (*
integer library_binding = "analogLib";

 *)
c2148 ( \ADC_1p0(2) , \7:ADC_1p0(3)  );
capacitor #(.c(2.129e-18)) (*
integer library_binding = "analogLib";

 *)
c2149 ( \ADC_1p0(2) , \7:FLASH_1p0(1)  );
capacitor #(.c(1.489e-18)) (*
integer library_binding = "analogLib";

 *)
c2150 ( \ADC_1p0(2) , RX10_PRESENT_1p0 );
capacitor #(.c(2.786e-19)) (*
integer library_binding = "analogLib";

 *)
c2151 ( \ADC_1p0(2) , \4:RX10_PRESENT_1p0  );
capacitor #(.c(2.122e-18)) (*
integer library_binding = "analogLib";

 *)
c2152 ( \ADC_1p0(2) , \7:ADC_1p0(5)  );
capacitor #(.c(2.825e-19)) (*
integer library_binding = "analogLib";

 *)
c2153 ( \ADC_1p0(2) , \TEST_MODE(2)  );
capacitor #(.c(1.485e-18)) (*
integer library_binding = "analogLib";

 *)
c2154 ( \ADC_1p0(2) , \3:TEST_MODE(2)  );
capacitor #(.c(2.207e-19)) (*
integer library_binding = "analogLib";

 *)
c2155 ( \ADC_1p0(2) , \TX_SLOPETRIM_1p0(1)  );
capacitor #(.c(2.417e-19)) (*
integer library_binding = "analogLib";

 *)
c2156 ( \ADC_1p0(2) , SLICER_OUT_1p0 );
capacitor #(.c(1.592e-17)) (*
integer library_binding = "analogLib";

 *)
c2157 ( \ADC_1p0(2) , \4:TX_SLOPETRIM_1p0(1)  );
capacitor #(.c(1.59e-17)) (*
integer library_binding = "analogLib";

 *)
c2158 ( \ADC_1p0(2) , \4:SLICER_OUT_1p0  );
capacitor #(.c(5.217e-16)) (*
integer library_binding = "analogLib";

 *)
c2159 ( \ADC_1p0(2) , \4:X_125  );
capacitor #(.c(1.421e-16)) (*
integer library_binding = "analogLib";

 *)
c2160 ( \ADC_1p0(2) , X_125 );
capacitor #(.c(1.614e-17)) (*
integer library_binding = "analogLib";

 *)
c2161 ( \ADC_1p0(2) , \MR_SQUELCH_RANGE_1p0(0)  );
capacitor #(.c(1.539e-17)) (*
integer library_binding = "analogLib";

 *)
c2162 ( \ADC_1p0(2) , \2:ADC_1p0(5)  );
capacitor #(.c(1.614e-17)) (*
integer library_binding = "analogLib";

 *)
c2163 ( \ADC_1p0(2) , POS_DETECT_1p0 );
capacitor #(.c(6.055e-16)) (*
integer library_binding = "analogLib";

 *)
c2164 ( \ADC_1p0(2) , \4:GND  );
capacitor #(.c(1.614e-17)) (*
integer library_binding = "analogLib";

 *)
c2165 ( \ADC_1p0(2) , X_160 );
capacitor #(.c(4.039e-15)) (*
integer library_binding = "analogLib";

 *)
c2166 ( \ADC_1p0(2) , \FLASH_1p0(1)  );
capacitor #(.c(1.614e-17)) (*
integer library_binding = "analogLib";

 *)
c2167 ( \ADC_1p0(2) , \4:MR_SQUELCH_DISB_1p0  );
capacitor #(.c(1.614e-17)) (*
integer library_binding = "analogLib";

 *)
c2168 ( \ADC_1p0(2) , \TX_SLOPETRIM_1p0(0)  );
capacitor #(.c(4.038e-15)) (*
integer library_binding = "analogLib";

 *)
c2169 ( \ADC_1p0(2) , \1:ADC_1p0(4)  );
capacitor #(.c(1.614e-17)) (*
integer library_binding = "analogLib";

 *)
c2170 ( \ADC_1p0(2) , NEG_DETECT_1p0 );
capacitor #(.c(1.614e-17)) (*
integer library_binding = "analogLib";

 *)
c2171 ( \ADC_1p0(2) , \4:TX_AMPTRIM_1p0(1)  );
capacitor #(.c(1.614e-17)) (*
integer library_binding = "analogLib";

 *)
c2172 ( \ADC_1p0(2) , \TEST_MODE(1)  );
capacitor #(.c(2.821e-15)) (*
integer library_binding = "analogLib";

 *)
c2173 ( \ADC_1p0(2) , GND );
capacitor #(.c(5.628e-15)) (*
integer library_binding = "analogLib";

 *)
c2174 ( \ADC_1p0(2) , \2:ADC_1p0(3)  );
capacitor #(.c(1.614e-17)) (*
integer library_binding = "analogLib";

 *)
c2175 ( \ADC_1p0(2) , XTAL25_1p0 );
capacitor #(.c(1.614e-17)) (*
integer library_binding = "analogLib";

 *)
c2176 ( \ADC_1p0(2) , \5:B10_DIS  );
capacitor #(.c(1.614e-17)) (*
integer library_binding = "analogLib";

 *)
c2177 ( \ADC_1p0(2) , \TX_AMPTRIM_1p0(0)  );
capacitor #(.c(1.614e-17)) (*
integer library_binding = "analogLib";

 *)
c2178 ( \ADC_1p0(2) , \5:TXER  );
capacitor #(.c(1.614e-17)) (*
integer library_binding = "analogLib";

 *)
c2179 ( \ADC_1p0(2) , \4:MR_SQUELCH_RANGE_1p0(1)  );
capacitor #(.c(1.614e-17)) (*
integer library_binding = "analogLib";

 *)
c2180 ( \ADC_1p0(2) , \4:MLT3_TDATA_1p0(0)  );
capacitor #(.c(1.982e-16)) (*
integer library_binding = "analogLib";

 *)
c2181 ( \7:ADC_1p0(2) , \4:GND  );
capacitor #(.c(4.35e-15)) (*
integer library_binding = "analogLib";

 *)
c2182 ( \7:ADC_1p0(2) , \7:ADC_1p0(3)  );
capacitor #(.c(1.732e-17)) (*
integer library_binding = "analogLib";

 *)
c2183 ( \7:ADC_1p0(2) , \7:FLASH_1p0(1)  );
capacitor #(.c(1.925e-18)) (*
integer library_binding = "analogLib";

 *)
c2184 ( \7:ADC_1p0(2) , \FLASH_1p0(1)  );
capacitor #(.c(1.211e-17)) (*
integer library_binding = "analogLib";

 *)
c2185 ( \7:ADC_1p0(2) , RX10_PRESENT_1p0 );
capacitor #(.c(2.267e-18)) (*
integer library_binding = "analogLib";

 *)
c2186 ( \7:ADC_1p0(2) , \4:RX10_PRESENT_1p0  );
capacitor #(.c(1.726e-17)) (*
integer library_binding = "analogLib";

 *)
c2187 ( \7:ADC_1p0(2) , \7:ADC_1p0(5)  );
capacitor #(.c(1.978e-18)) (*
integer library_binding = "analogLib";

 *)
c2188 ( \7:ADC_1p0(2) , \2:ADC_1p0(5)  );
capacitor #(.c(2.298e-18)) (*
integer library_binding = "analogLib";

 *)
c2189 ( \7:ADC_1p0(2) , \TEST_MODE(2)  );
capacitor #(.c(1.208e-17)) (*
integer library_binding = "analogLib";

 *)
c2190 ( \7:ADC_1p0(2) , \3:TEST_MODE(2)  );
capacitor #(.c(5.891e-17)) (*
integer library_binding = "analogLib";

 *)
c2191 ( \7:ADC_1p0(2) , \4:X_125  );
capacitor #(.c(7.16e-16)) (*
integer library_binding = "analogLib";

 *)
c2192 ( \7:ADC_1p0(2) , \2:ADC_1p0(3)  );
capacitor #(.c(3.258e-16)) (*
integer library_binding = "analogLib";

 *)
c2193 ( \7:ADC_1p0(2) , X_125 );
capacitor #(.c(3.054e-15)) (*
integer library_binding = "analogLib";

 *)
c2194 ( \7:ADC_1p0(2) , GND );
capacitor #(.c(7.751e-18)) (*
integer library_binding = "analogLib";

 *)
c2195 ( \3:ADC_1p0(2) , \1:RCLK125_1p0  );
capacitor #(.c(7.171e-18)) (*
integer library_binding = "analogLib";

 *)
c2196 ( \3:ADC_1p0(2) , \4:RCLK125_1p0  );
capacitor #(.c(1.307e-17)) (*
integer library_binding = "analogLib";

 *)
c2197 ( \3:ADC_1p0(2) , \3:ADC_1p0(5)  );
capacitor #(.c(1.244e-17)) (*
integer library_binding = "analogLib";

 *)
c2198 ( \3:ADC_1p0(2) , \3:ADC_1p0(0)  );
capacitor #(.c(6.005e-15)) (*
integer library_binding = "analogLib";

 *)
c2199 ( \3:ADC_1p0(2) , GND );
capacitor #(.c(1.724e-17)) (*
integer library_binding = "analogLib";

 *)
c2200 ( \3:ADC_1p0(2) , \FLASH_1p0(1)  );
capacitor #(.c(1.635e-17)) (*
integer library_binding = "analogLib";

 *)
c2201 ( \3:ADC_1p0(2) , \ADC_1p0(3)  );
capacitor #(.c(8.69e-16)) (*
integer library_binding = "analogLib";

 *)
c2202 ( \3:ADC_1p0(2) , \4:GND  );
capacitor #(.c(3.591e-16)) (*
integer library_binding = "analogLib";

 *)
c2203 ( \3:ADC_1p0(2) , \1:ADC_1p0(4)  );
capacitor #(.c(3.661e-15)) (*
integer library_binding = "analogLib";

 *)
c2204 ( \3:ADC_1p0(2) , \ADC_1p0(4)  );
capacitor #(.c(4.004e-15)) (*
integer library_binding = "analogLib";

 *)
c2205 ( \3:ADC_1p0(2) , \3:FLASH_1p0(1)  );
capacitor #(.c(5.444e-16)) (*
integer library_binding = "analogLib";

 *)
c2206 ( \4:ADC_1p0(2) , \4:GND  );
capacitor #(.c(1.494e-19)) (*
integer library_binding = "analogLib";

 *)
c2207 ( \4:ADC_1p0(2) , \6:ADC_1p0(3)  );
capacitor #(.c(1.013e-17)) (*
integer library_binding = "analogLib";

 *)
c2208 ( \4:ADC_1p0(2) , \12:I_RPOLY_REF100  );
capacitor #(.c(9.988e-19)) (*
integer library_binding = "analogLib";

 *)
c2209 ( \4:ADC_1p0(2) , \4:I_RPOLY_REF100  );
capacitor #(.c(1.509e-19)) (*
integer library_binding = "analogLib";

 *)
c2210 ( \4:ADC_1p0(2) , \6:FLASH_1p0(0)  );
capacitor #(.c(1.509e-19)) (*
integer library_binding = "analogLib";

 *)
c2211 ( \4:ADC_1p0(2) , \6:ADC_1p0(4)  );
capacitor #(.c(1.493e-19)) (*
integer library_binding = "analogLib";

 *)
c2212 ( \4:ADC_1p0(2) , \6:ADC_1p0(5)  );
capacitor #(.c(8.037e-17)) (*
integer library_binding = "analogLib";

 *)
c2213 ( \4:ADC_1p0(2) , RCLK125_1p0 );
capacitor #(.c(4.958e-16)) (*
integer library_binding = "analogLib";

 *)
c2214 ( \4:ADC_1p0(2) , \6:FLASH_1p0(1)  );
capacitor #(.c(1.895e-17)) (*
integer library_binding = "analogLib";

 *)
c2215 ( \4:ADC_1p0(2) , \7:I_REXT_50(0)  );
capacitor #(.c(2.659e-18)) (*
integer library_binding = "analogLib";

 *)
c2216 ( \4:ADC_1p0(2) , \I_REXT_50(0)  );
capacitor #(.c(1.265e-17)) (*
integer library_binding = "analogLib";

 *)
c2217 ( \4:ADC_1p0(2) , \I_REXT_50(1)  );
capacitor #(.c(1.148e-18)) (*
integer library_binding = "analogLib";

 *)
c2218 ( \4:ADC_1p0(2) , \2:I_REXT_50(1)  );
capacitor #(.c(1.374e-16)) (*
integer library_binding = "analogLib";

 *)
c2219 ( \4:ADC_1p0(2) , \5:GNDRX  );
capacitor #(.c(9.953e-15)) (*
integer library_binding = "analogLib";

 *)
c2220 ( \4:ADC_1p0(2) , \4:RCLK125_1p0  );
capacitor #(.c(1.374e-16)) (*
integer library_binding = "analogLib";

 *)
c2221 ( \4:ADC_1p0(2) , \6:VDD  );
capacitor #(.c(8.485e-15)) (*
integer library_binding = "analogLib";

 *)
c2222 ( \4:ADC_1p0(2) , GND );
capacitor #(.c(2.717e-14)) (*
integer library_binding = "analogLib";

 *)
c2223 ( \4:ADC_1p0(2) , \4:FLASH_1p0(1)  );
capacitor #(.c(1.097e-17)) (*
integer library_binding = "analogLib";

 *)
c2224 ( \4:ADC_1p0(2) , \4:I_RPOLY_100(5)  );
capacitor #(.c(2.498e-16)) (*
integer library_binding = "analogLib";

 *)
c2225 ( \4:ADC_1p0(2) , \12:VDD  );
capacitor #(.c(2.498e-16)) (*
integer library_binding = "analogLib";

 *)
c2226 ( \4:ADC_1p0(2) , \6:GNDRX  );
capacitor #(.c(2.443e-16)) (*
integer library_binding = "analogLib";

 *)
c2227 ( \6:ADC_1p0(2) , \4:GND  );
capacitor #(.c(1.848e-17)) (*
integer library_binding = "analogLib";

 *)
c2228 ( \6:ADC_1p0(2) , \6:ADC_1p0(3)  );
capacitor #(.c(1.91e-19)) (*
integer library_binding = "analogLib";

 *)
c2229 ( \6:ADC_1p0(2) , \3:ADC_1p0(3)  );
capacitor #(.c(1.867e-17)) (*
integer library_binding = "analogLib";

 *)
c2230 ( \6:ADC_1p0(2) , \6:FLASH_1p0(0)  );
capacitor #(.c(2.811e-16)) (*
integer library_binding = "analogLib";

 *)
c2231 ( \6:ADC_1p0(2) , \4:RCLK125_1p0  );
capacitor #(.c(1.867e-17)) (*
integer library_binding = "analogLib";

 *)
c2232 ( \6:ADC_1p0(2) , \6:ADC_1p0(4)  );
capacitor #(.c(2.046e-19)) (*
integer library_binding = "analogLib";

 *)
c2233 ( \6:ADC_1p0(2) , \ADC_1p0(5)  );
capacitor #(.c(1.847e-17)) (*
integer library_binding = "analogLib";

 *)
c2234 ( \6:ADC_1p0(2) , \6:ADC_1p0(5)  );
capacitor #(.c(9.943e-15)) (*
integer library_binding = "analogLib";

 *)
c2235 ( \6:ADC_1p0(2) , RCLK125_1p0 );
capacitor #(.c(2.332e-16)) (*
integer library_binding = "analogLib";

 *)
c2236 ( \6:ADC_1p0(2) , \4:FLASH_1p0(1)  );
capacitor #(.c(2.653e-14)) (*
integer library_binding = "analogLib";

 *)
c2237 ( \6:ADC_1p0(2) , \6:FLASH_1p0(1)  );
capacitor #(.c(3.768e-15)) (*
integer library_binding = "analogLib";

 *)
c2238 ( \6:ADC_1p0(2) , GND );
capacitor #(.c(3.404e-16)) (*
integer library_binding = "analogLib";

 *)
c2239 ( \I_REXT_50(1) , \4:GND  );
capacitor #(.c(3.038e-17)) (*
integer library_binding = "analogLib";

 *)
c2240 ( \I_REXT_50(1) , \I_REXT_50(0)  );
capacitor #(.c(1.602e-16)) (*
integer library_binding = "analogLib";

 *)
c2241 ( \I_REXT_50(1) , \6:GNDRX  );
capacitor #(.c(2.068e-15)) (*
integer library_binding = "analogLib";

 *)
c2242 ( \I_REXT_50(1) , \4:I_RPOLY_REF100  );
capacitor #(.c(1.686e-17)) (*
integer library_binding = "analogLib";

 *)
c2243 ( \I_REXT_50(1) , \ADC_1p0(5)  );
capacitor #(.c(1.364e-17)) (*
integer library_binding = "analogLib";

 *)
c2244 ( \I_REXT_50(1) , \4:FLASH_1p0(1)  );
capacitor #(.c(2.849e-16)) (*
integer library_binding = "analogLib";

 *)
c2245 ( \I_REXT_50(1) , \6:VDD  );
capacitor #(.c(1.602e-16)) (*
integer library_binding = "analogLib";

 *)
c2246 ( \I_REXT_50(1) , \5:GND  );
capacitor #(.c(1.603e-17)) (*
integer library_binding = "analogLib";

 *)
c2247 ( \I_REXT_50(1) , \4:RCLK125_1p0  );
capacitor #(.c(1.221e-17)) (*
integer library_binding = "analogLib";

 *)
c2248 ( \I_REXT_50(1) , \ADC_1p0(0)  );
capacitor #(.c(1.013e-17)) (*
integer library_binding = "analogLib";

 *)
c2249 ( \I_REXT_50(1) , \4:I_RPOLY_100(5)  );
capacitor #(.c(1.312e-17)) (*
integer library_binding = "analogLib";

 *)
c2250 ( \I_REXT_50(1) , \4:FLASH_1p0(0)  );
capacitor #(.c(1.013e-17)) (*
integer library_binding = "analogLib";

 *)
c2251 ( \I_REXT_50(1) , \3:ADC_1p0(3)  );
capacitor #(.c(1.013e-17)) (*
integer library_binding = "analogLib";

 *)
c2252 ( \I_REXT_50(1) , \3:ADC_1p0(4)  );
capacitor #(.c(8.236e-16)) (*
integer library_binding = "analogLib";

 *)
c2253 ( \I_REXT_50(1) , \7:I_REXT_50(0)  );
capacitor #(.c(5.341e-15)) (*
integer library_binding = "analogLib";

 *)
c2254 ( \I_REXT_50(1) , GND );
capacitor #(.c(1.208e-14)) (*
integer library_binding = "analogLib";

 *)
c2255 ( \I_REXT_50(1) , \12:I_RPOLY_REF100  );
capacitor #(.c(2.204e-15)) (*
integer library_binding = "analogLib";

 *)
c2256 ( \2:I_REXT_50(1) , \4:GND  );
capacitor #(.c(1.41e-17)) (*
integer library_binding = "analogLib";

 *)
c2257 ( \2:I_REXT_50(1) , \7:X10_DIS_2p5  );
capacitor #(.c(3.304e-18)) (*
integer library_binding = "analogLib";

 *)
c2258 ( \2:I_REXT_50(1) , \3:X10_DIS_2p5  );
capacitor #(.c(9.784e-16)) (*
integer library_binding = "analogLib";

 *)
c2259 ( \2:I_REXT_50(1) , \12:I_RPOLY_REF100  );
capacitor #(.c(8.405e-20)) (*
integer library_binding = "analogLib";

 *)
c2260 ( \2:I_REXT_50(1) , \3:MR_SQUELCH_DISB_2p5  );
capacitor #(.c(1.83e-19)) (*
integer library_binding = "analogLib";

 *)
c2261 ( \2:I_REXT_50(1) , \PHASE_250(4)  );
capacitor #(.c(1.423e-19)) (*
integer library_binding = "analogLib";

 *)
c2262 ( \2:I_REXT_50(1) , \3:TP_DISC_2p5  );
capacitor #(.c(1.391e-19)) (*
integer library_binding = "analogLib";

 *)
c2263 ( \2:I_REXT_50(1) , \5:TIMING_DN_ANLG  );
capacitor #(.c(1.83e-19)) (*
integer library_binding = "analogLib";

 *)
c2264 ( \2:I_REXT_50(1) , \PHASE_250(5)  );
capacitor #(.c(1.657e-19)) (*
integer library_binding = "analogLib";

 *)
c2265 ( \2:I_REXT_50(1) , TIMING_UP_ANLG );
capacitor #(.c(1.595e-19)) (*
integer library_binding = "analogLib";

 *)
c2266 ( \2:I_REXT_50(1) , RESET_DSP );
capacitor #(.c(1.604e-19)) (*
integer library_binding = "analogLib";

 *)
c2267 ( \2:I_REXT_50(1) , \PHASE_250(6)  );
capacitor #(.c(1.83e-19)) (*
integer library_binding = "analogLib";

 *)
c2268 ( \2:I_REXT_50(1) , \PHASE_250(10)  );
capacitor #(.c(1.383e-19)) (*
integer library_binding = "analogLib";

 *)
c2269 ( \2:I_REXT_50(1) , \2:TX100_DIS_2p5  );
capacitor #(.c(1.83e-19)) (*
integer library_binding = "analogLib";

 *)
c2270 ( \2:I_REXT_50(1) , \PHASE_250(8)  );
capacitor #(.c(1.83e-19)) (*
integer library_binding = "analogLib";

 *)
c2271 ( \2:I_REXT_50(1) , \3:PHASE_250(1)  );
capacitor #(.c(1.83e-19)) (*
integer library_binding = "analogLib";

 *)
c2272 ( \2:I_REXT_50(1) , \3:PHASE_250(9)  );
capacitor #(.c(1.83e-19)) (*
integer library_binding = "analogLib";

 *)
c2273 ( \2:I_REXT_50(1) , \PHASE_250(2)  );
capacitor #(.c(1.595e-19)) (*
integer library_binding = "analogLib";

 *)
c2274 ( \2:I_REXT_50(1) , RCLK125_TST );
capacitor #(.c(1.83e-19)) (*
integer library_binding = "analogLib";

 *)
c2275 ( \2:I_REXT_50(1) , \PHASE_250(3)  );
capacitor #(.c(4.337e-20)) (*
integer library_binding = "analogLib";

 *)
c2276 ( \2:I_REXT_50(1) , \3:MR_SQUELCH_RANGE_2p5(1)  );
capacitor #(.c(1.126e-19)) (*
integer library_binding = "analogLib";

 *)
c2277 ( \2:I_REXT_50(1) , \MR_SQUELCH_RANGE_2p5(1)  );
capacitor #(.c(3.368e-19)) (*
integer library_binding = "analogLib";

 *)
c2278 ( \2:I_REXT_50(1) , MR_SQUELCH_DISB_2p5 );
capacitor #(.c(1.018e-19)) (*
integer library_binding = "analogLib";

 *)
c2279 ( \2:I_REXT_50(1) , \4:MR_SQUELCH_RANGE_2p5(0)  );
capacitor #(.c(3.959e-20)) (*
integer library_binding = "analogLib";

 *)
c2280 ( \2:I_REXT_50(1) , \MR_SQUELCH_RANGE_2p5(0)  );
capacitor #(.c(6.607e-17)) (*
integer library_binding = "analogLib";

 *)
c2281 ( \2:I_REXT_50(1) , \25:VDDTX  );
capacitor #(.c(1.258e-17)) (*
integer library_binding = "analogLib";

 *)
c2282 ( \2:I_REXT_50(1) , \24:VDDTX  );
capacitor #(.c(2.096e-20)) (*
integer library_binding = "analogLib";

 *)
c2283 ( \2:I_REXT_50(1) , \5:BLW_DIS_2p5  );
capacitor #(.c(1.621e-19)) (*
integer library_binding = "analogLib";

 *)
c2284 ( \2:I_REXT_50(1) , BLW_DIS_2p5 );
capacitor #(.c(3.25e-17)) (*
integer library_binding = "analogLib";

 *)
c2285 ( \2:I_REXT_50(1) , \7:I_REXT_50(0)  );
capacitor #(.c(2.746e-18)) (*
integer library_binding = "analogLib";

 *)
c2286 ( \2:I_REXT_50(1) , \I_REXT_50(0)  );
capacitor #(.c(1.454e-17)) (*
integer library_binding = "analogLib";

 *)
c2287 ( \2:I_REXT_50(1) , \6:GNDRX  );
capacitor #(.c(1.53e-18)) (*
integer library_binding = "analogLib";

 *)
c2288 ( \2:I_REXT_50(1) , \ADC_1p0(5)  );
capacitor #(.c(1.238e-18)) (*
integer library_binding = "analogLib";

 *)
c2289 ( \2:I_REXT_50(1) , \4:FLASH_1p0(1)  );
capacitor #(.c(2.586e-17)) (*
integer library_binding = "analogLib";

 *)
c2290 ( \2:I_REXT_50(1) , \6:VDD  );
capacitor #(.c(1.454e-17)) (*
integer library_binding = "analogLib";

 *)
c2291 ( \2:I_REXT_50(1) , \5:GND  );
capacitor #(.c(1.455e-18)) (*
integer library_binding = "analogLib";

 *)
c2292 ( \2:I_REXT_50(1) , \4:RCLK125_1p0  );
capacitor #(.c(1.109e-18)) (*
integer library_binding = "analogLib";

 *)
c2293 ( \2:I_REXT_50(1) , \ADC_1p0(0)  );
capacitor #(.c(9.192e-19)) (*
integer library_binding = "analogLib";

 *)
c2294 ( \2:I_REXT_50(1) , \4:I_RPOLY_100(5)  );
capacitor #(.c(1.191e-18)) (*
integer library_binding = "analogLib";

 *)
c2295 ( \2:I_REXT_50(1) , \4:FLASH_1p0(0)  );
capacitor #(.c(9.192e-19)) (*
integer library_binding = "analogLib";

 *)
c2296 ( \2:I_REXT_50(1) , \3:ADC_1p0(3)  );
capacitor #(.c(9.192e-19)) (*
integer library_binding = "analogLib";

 *)
c2297 ( \2:I_REXT_50(1) , \3:ADC_1p0(4)  );
capacitor #(.c(1.741e-17)) (*
integer library_binding = "analogLib";

 *)
c2298 ( \2:I_REXT_50(1) , \3:I_RPOLY_100(4)  );
capacitor #(.c(1.741e-17)) (*
integer library_binding = "analogLib";

 *)
c2299 ( \2:I_REXT_50(1) , \I_REXT_100(4)  );
capacitor #(.c(1.785e-17)) (*
integer library_binding = "analogLib";

 *)
c2300 ( \2:I_REXT_50(1) , \2:I_RPOLY_100(5)  );
capacitor #(.c(1.089e-14)) (*
integer library_binding = "analogLib";

 *)
c2301 ( \2:I_REXT_50(1) , \4:I_RPOLY_REF100  );
capacitor #(.c(1.741e-17)) (*
integer library_binding = "analogLib";

 *)
c2302 ( \2:I_REXT_50(1) , \I_RPOLY_100(3)  );
capacitor #(.c(1.262e-17)) (*
integer library_binding = "analogLib";

 *)
c2303 ( \2:I_REXT_50(1) , \2:I_REXT_100(6)  );
capacitor #(.c(1.741e-17)) (*
integer library_binding = "analogLib";

 *)
c2304 ( \2:I_REXT_50(1) , \I_REXT_100(3)  );
capacitor #(.c(1.741e-17)) (*
integer library_binding = "analogLib";

 *)
c2305 ( \2:I_REXT_50(1) , \3:I_RPOLY_100(2)  );
capacitor #(.c(1.262e-17)) (*
integer library_binding = "analogLib";

 *)
c2306 ( \2:I_REXT_50(1) , \2:I_RPOLY_100(0)  );
capacitor #(.c(1.535e-17)) (*
integer library_binding = "analogLib";

 *)
c2307 ( \2:I_REXT_50(1) , \I_REXT_100(2)  );
capacitor #(.c(3.397e-14)) (*
integer library_binding = "analogLib";

 *)
c2308 ( \2:I_REXT_50(1) , GND );
capacitor #(.c(1.262e-17)) (*
integer library_binding = "analogLib";

 *)
c2309 ( \2:I_REXT_50(1) , \2:I_REXT_100(2)  );
capacitor #(.c(1.741e-17)) (*
integer library_binding = "analogLib";

 *)
c2310 ( \2:I_REXT_50(1) , \I_RPOLY_100(0)  );
capacitor #(.c(1.741e-17)) (*
integer library_binding = "analogLib";

 *)
c2311 ( \2:I_REXT_50(1) , NEG_DETECT_2p5 );
capacitor #(.c(1.262e-17)) (*
integer library_binding = "analogLib";

 *)
c2312 ( \2:I_REXT_50(1) , \I_RPOLY_100(2)  );
capacitor #(.c(1.262e-17)) (*
integer library_binding = "analogLib";

 *)
c2313 ( \2:I_REXT_50(1) , \2:I_REXT_100(3)  );
capacitor #(.c(1.741e-17)) (*
integer library_binding = "analogLib";

 *)
c2314 ( \2:I_REXT_50(1) , \I_REXT_100(6)  );
capacitor #(.c(1.741e-17)) (*
integer library_binding = "analogLib";

 *)
c2315 ( \2:I_REXT_50(1) , \5:POS_DETECT_2p5  );
capacitor #(.c(1.262e-17)) (*
integer library_binding = "analogLib";

 *)
c2316 ( \2:I_REXT_50(1) , \2:I_RPOLY_100(3)  );
capacitor #(.c(1.741e-17)) (*
integer library_binding = "analogLib";

 *)
c2317 ( \2:I_REXT_50(1) , \I_RPOLY_100(5)  );
capacitor #(.c(1.262e-17)) (*
integer library_binding = "analogLib";

 *)
c2318 ( \2:I_REXT_50(1) , \2:I_REXT_100(4)  );
capacitor #(.c(3.788e-17)) (*
integer library_binding = "analogLib";

 *)
c2319 ( \2:I_REXT_50(1) , \25:GND  );
capacitor #(.c(1.274e-17)) (*
integer library_binding = "analogLib";

 *)
c2320 ( \2:I_REXT_50(1) , \2:I_RPOLY_100(4)  );
capacitor #(.c(1.36e-15)) (*
integer library_binding = "analogLib";

 *)
c2321 ( \6:I_REXT_50(1) , \4:GND  );
capacitor #(.c(7.911e-18)) (*
integer library_binding = "analogLib";

 *)
c2322 ( \6:I_REXT_50(1) , \3:MR_SQUELCH_DISB_2p5  );
capacitor #(.c(1.723e-17)) (*
integer library_binding = "analogLib";

 *)
c2323 ( \6:I_REXT_50(1) , \PHASE_250(4)  );
capacitor #(.c(1.339e-17)) (*
integer library_binding = "analogLib";

 *)
c2324 ( \6:I_REXT_50(1) , \3:TP_DISC_2p5  );
capacitor #(.c(1.31e-17)) (*
integer library_binding = "analogLib";

 *)
c2325 ( \6:I_REXT_50(1) , \5:TIMING_DN_ANLG  );
capacitor #(.c(1.723e-17)) (*
integer library_binding = "analogLib";

 *)
c2326 ( \6:I_REXT_50(1) , \PHASE_250(5)  );
capacitor #(.c(1.56e-17)) (*
integer library_binding = "analogLib";

 *)
c2327 ( \6:I_REXT_50(1) , TIMING_UP_ANLG );
capacitor #(.c(1.501e-17)) (*
integer library_binding = "analogLib";

 *)
c2328 ( \6:I_REXT_50(1) , RESET_DSP );
capacitor #(.c(1.509e-17)) (*
integer library_binding = "analogLib";

 *)
c2329 ( \6:I_REXT_50(1) , \PHASE_250(6)  );
capacitor #(.c(1.723e-17)) (*
integer library_binding = "analogLib";

 *)
c2330 ( \6:I_REXT_50(1) , \PHASE_250(10)  );
capacitor #(.c(1.302e-17)) (*
integer library_binding = "analogLib";

 *)
c2331 ( \6:I_REXT_50(1) , \2:TX100_DIS_2p5  );
capacitor #(.c(1.723e-17)) (*
integer library_binding = "analogLib";

 *)
c2332 ( \6:I_REXT_50(1) , \PHASE_250(8)  );
capacitor #(.c(1.723e-17)) (*
integer library_binding = "analogLib";

 *)
c2333 ( \6:I_REXT_50(1) , \3:PHASE_250(1)  );
capacitor #(.c(1.723e-17)) (*
integer library_binding = "analogLib";

 *)
c2334 ( \6:I_REXT_50(1) , \3:PHASE_250(9)  );
capacitor #(.c(1.723e-17)) (*
integer library_binding = "analogLib";

 *)
c2335 ( \6:I_REXT_50(1) , \PHASE_250(2)  );
capacitor #(.c(1.501e-17)) (*
integer library_binding = "analogLib";

 *)
c2336 ( \6:I_REXT_50(1) , RCLK125_TST );
capacitor #(.c(1.723e-17)) (*
integer library_binding = "analogLib";

 *)
c2337 ( \6:I_REXT_50(1) , \PHASE_250(3)  );
capacitor #(.c(4.083e-18)) (*
integer library_binding = "analogLib";

 *)
c2338 ( \6:I_REXT_50(1) , \3:MR_SQUELCH_RANGE_2p5(1)  );
capacitor #(.c(1.06e-17)) (*
integer library_binding = "analogLib";

 *)
c2339 ( \6:I_REXT_50(1) , \MR_SQUELCH_RANGE_2p5(1)  );
capacitor #(.c(3.171e-17)) (*
integer library_binding = "analogLib";

 *)
c2340 ( \6:I_REXT_50(1) , MR_SQUELCH_DISB_2p5 );
capacitor #(.c(9.583e-18)) (*
integer library_binding = "analogLib";

 *)
c2341 ( \6:I_REXT_50(1) , \4:MR_SQUELCH_RANGE_2p5(0)  );
capacitor #(.c(3.726e-18)) (*
integer library_binding = "analogLib";

 *)
c2342 ( \6:I_REXT_50(1) , \MR_SQUELCH_RANGE_2p5(0)  );
capacitor #(.c(1.973e-18)) (*
integer library_binding = "analogLib";

 *)
c2343 ( \6:I_REXT_50(1) , \5:BLW_DIS_2p5  );
capacitor #(.c(1.525e-17)) (*
integer library_binding = "analogLib";

 *)
c2344 ( \6:I_REXT_50(1) , BLW_DIS_2p5 );
capacitor #(.c(1.211e-15)) (*
integer library_binding = "analogLib";

 *)
c2345 ( \6:I_REXT_50(1) , \24:VDDTX  );
capacitor #(.c(6.359e-15)) (*
integer library_binding = "analogLib";

 *)
c2346 ( \6:I_REXT_50(1) , \25:VDDTX  );
capacitor #(.c(2.1e-14)) (*
integer library_binding = "analogLib";

 *)
c2347 ( \6:I_REXT_50(1) , GND );
capacitor #(.c(2.725e-15)) (*
integer library_binding = "analogLib";

 *)
c2348 ( \TX_AMP_TRIM(1) , GND );
capacitor #(.c(3.651e-16)) (*
integer library_binding = "analogLib";

 *)
c2349 ( \TX_AMP_TRIM(1) , \4:GND  );
capacitor #(.c(1.768e-16)) (*
integer library_binding = "analogLib";

 *)
c2350 ( \1:TX_AMP_TRIM(1) , \4:GND  );
capacitor #(.c(2.725e-15)) (*
integer library_binding = "analogLib";

 *)
c2351 ( \1:TX_AMP_TRIM(1) , GND );
capacitor #(.c(3.293e-16)) (*
integer library_binding = "analogLib";

 *)
c2352 ( \1:TX_AMP_TRIM(1) , \4:VDD  );
capacitor #(.c(1.378e-16)) (*
integer library_binding = "analogLib";

 *)
c2353 ( \AEQ_CNT_ANLG(2) , \4:GND  );
capacitor #(.c(5.133e-19)) (*
integer library_binding = "analogLib";

 *)
c2354 ( \AEQ_CNT_ANLG(2) , \7:BASEFX_DIS  );
capacitor #(.c(1.205e-18)) (*
integer library_binding = "analogLib";

 *)
c2355 ( \AEQ_CNT_ANLG(2) , \WANDER_CNT(4)  );
capacitor #(.c(7.31e-16)) (*
integer library_binding = "analogLib";

 *)
c2356 ( \AEQ_CNT_ANLG(2) , \AEQ_CNT_ANLG(1)  );
capacitor #(.c(1.971e-18)) (*
integer library_binding = "analogLib";

 *)
c2357 ( \AEQ_CNT_ANLG(2) , \AEQ_CNT_ANLG(4)  );
capacitor #(.c(4.029e-19)) (*
integer library_binding = "analogLib";

 *)
c2358 ( \AEQ_CNT_ANLG(2) , \6:I_REXT_50(0)  );
capacitor #(.c(3.907e-20)) (*
integer library_binding = "analogLib";

 *)
c2359 ( \AEQ_CNT_ANLG(2) , \2:I_REXT_50(0)  );
capacitor #(.c(1.434e-17)) (*
integer library_binding = "analogLib";

 *)
c2360 ( \AEQ_CNT_ANLG(2) , \4:PHASE_IN(9)  );
capacitor #(.c(1.309e-17)) (*
integer library_binding = "analogLib";

 *)
c2361 ( \AEQ_CNT_ANLG(2) , \2:PHASE_IN(1)  );
capacitor #(.c(1.309e-17)) (*
integer library_binding = "analogLib";

 *)
c2362 ( \AEQ_CNT_ANLG(2) , \PHASE_IN(0)  );
capacitor #(.c(7.475e-16)) (*
integer library_binding = "analogLib";

 *)
c2363 ( \AEQ_CNT_ANLG(2) , \5:BASEFX_DIS  );
capacitor #(.c(1.389e-17)) (*
integer library_binding = "analogLib";

 *)
c2364 ( \AEQ_CNT_ANLG(2) , \5:AEQ_CNT_ANLG(4)  );
capacitor #(.c(1.423e-17)) (*
integer library_binding = "analogLib";

 *)
c2365 ( \AEQ_CNT_ANLG(2) , \WANDER_CNT(3)  );
capacitor #(.c(1.417e-17)) (*
integer library_binding = "analogLib";

 *)
c2366 ( \AEQ_CNT_ANLG(2) , \5:WANDER_CNT(4)  );
capacitor #(.c(1.145e-18)) (*
integer library_binding = "analogLib";

 *)
c2367 ( \AEQ_CNT_ANLG(2) , \4:WANDER_CNT(3)  );
capacitor #(.c(4.7e-18)) (*
integer library_binding = "analogLib";

 *)
c2368 ( \AEQ_CNT_ANLG(2) , AEQ_DIS_2p5 );
capacitor #(.c(5.441e-15)) (*
integer library_binding = "analogLib";

 *)
c2369 ( \AEQ_CNT_ANLG(2) , \5:AEQ_CNT_ANLG(1)  );
capacitor #(.c(1.434e-17)) (*
integer library_binding = "analogLib";

 *)
c2370 ( \AEQ_CNT_ANLG(2) , \6:AEQ_DIS_2p5  );
capacitor #(.c(1.872e-18)) (*
integer library_binding = "analogLib";

 *)
c2371 ( \AEQ_CNT_ANLG(2) , \WANDER_CNT(6)  );
capacitor #(.c(1.548e-17)) (*
integer library_binding = "analogLib";

 *)
c2372 ( \AEQ_CNT_ANLG(2) , \5:WANDER_CNT(6)  );
capacitor #(.c(1.303e-17)) (*
integer library_binding = "analogLib";

 *)
c2373 ( \AEQ_CNT_ANLG(2) , \6:XTAL25  );
capacitor #(.c(5.429e-20)) (*
integer library_binding = "analogLib";

 *)
c2374 ( \AEQ_CNT_ANLG(2) , \3:XTAL25  );
capacitor #(.c(1.425e-17)) (*
integer library_binding = "analogLib";

 *)
c2375 ( \AEQ_CNT_ANLG(2) , \4:PLL_160_IN  );
capacitor #(.c(9.046e-20)) (*
integer library_binding = "analogLib";

 *)
c2376 ( \AEQ_CNT_ANLG(2) , \1:PLL_160_IN  );
capacitor #(.c(1.629e-18)) (*
integer library_binding = "analogLib";

 *)
c2377 ( \AEQ_CNT_ANLG(2) , \4:AEQ_CNT_ANLG(0)  );
capacitor #(.c(1.505e-17)) (*
integer library_binding = "analogLib";

 *)
c2378 ( \AEQ_CNT_ANLG(2) , \AEQ_CNT_ANLG(0)  );
capacitor #(.c(5.758e-19)) (*
integer library_binding = "analogLib";

 *)
c2379 ( \AEQ_CNT_ANLG(2) , \5:BLW_DIS_2p5  );
capacitor #(.c(2.078e-15)) (*
integer library_binding = "analogLib";

 *)
c2380 ( \AEQ_CNT_ANLG(2) , \25:VDDTX  );
capacitor #(.c(3.957e-16)) (*
integer library_binding = "analogLib";

 *)
c2381 ( \AEQ_CNT_ANLG(2) , \24:VDDTX  );
capacitor #(.c(1.091e-18)) (*
integer library_binding = "analogLib";

 *)
c2382 ( \AEQ_CNT_ANLG(2) , \4:WANDER_CNT(0)  );
capacitor #(.c(1.429e-17)) (*
integer library_binding = "analogLib";

 *)
c2383 ( \AEQ_CNT_ANLG(2) , \WANDER_CNT(0)  );
capacitor #(.c(2.135e-15)) (*
integer library_binding = "analogLib";

 *)
c2384 ( \AEQ_CNT_ANLG(2) , GND );
capacitor #(.c(9.418e-16)) (*
integer library_binding = "analogLib";

 *)
c2385 ( \AEQ_CNT_ANLG(2) , BASEFX_DIS );
capacitor #(.c(2.656e-16)) (*
integer library_binding = "analogLib";

 *)
c2386 ( \4:AEQ_CNT_ANLG(2) , \4:GND  );
capacitor #(.c(1.709e-17)) (*
integer library_binding = "analogLib";

 *)
c2387 ( \4:AEQ_CNT_ANLG(2) , \7:BASEFX_DIS  );
capacitor #(.c(1.96e-17)) (*
integer library_binding = "analogLib";

 *)
c2388 ( \4:AEQ_CNT_ANLG(2) , \WANDER_CNT(4)  );
capacitor #(.c(6.293e-15)) (*
integer library_binding = "analogLib";

 *)
c2389 ( \4:AEQ_CNT_ANLG(2) , \AEQ_CNT_ANLG(1)  );
capacitor #(.c(1.421e-17)) (*
integer library_binding = "analogLib";

 *)
c2390 ( \4:AEQ_CNT_ANLG(2) , \5:ADC_TEST_2p5  );
capacitor #(.c(1.611e-17)) (*
integer library_binding = "analogLib";

 *)
c2391 ( \4:AEQ_CNT_ANLG(2) , \AEQ_CNT_ANLG(4)  );
capacitor #(.c(1.342e-17)) (*
integer library_binding = "analogLib";

 *)
c2392 ( \4:AEQ_CNT_ANLG(2) , \6:I_REXT_50(0)  );
capacitor #(.c(1.301e-18)) (*
integer library_binding = "analogLib";

 *)
c2393 ( \4:AEQ_CNT_ANLG(2) , \2:I_REXT_50(0)  );
capacitor #(.c(1.308e-18)) (*
integer library_binding = "analogLib";

 *)
c2394 ( \4:AEQ_CNT_ANLG(2) , \4:PHASE_IN(9)  );
capacitor #(.c(1.193e-18)) (*
integer library_binding = "analogLib";

 *)
c2395 ( \4:AEQ_CNT_ANLG(2) , \2:PHASE_IN(1)  );
capacitor #(.c(1.193e-18)) (*
integer library_binding = "analogLib";

 *)
c2396 ( \4:AEQ_CNT_ANLG(2) , \PHASE_IN(0)  );
capacitor #(.c(6.857e-17)) (*
integer library_binding = "analogLib";

 *)
c2397 ( \4:AEQ_CNT_ANLG(2) , \5:BASEFX_DIS  );
capacitor #(.c(7.361e-18)) (*
integer library_binding = "analogLib";

 *)
c2398 ( \4:AEQ_CNT_ANLG(2) , BASEFX_DIS );
capacitor #(.c(1.534e-18)) (*
integer library_binding = "analogLib";

 *)
c2399 ( \4:AEQ_CNT_ANLG(2) , \5:AEQ_CNT_ANLG(4)  );
capacitor #(.c(1.356e-18)) (*
integer library_binding = "analogLib";

 *)
c2400 ( \4:AEQ_CNT_ANLG(2) , \5:WANDER_CNT(4)  );
capacitor #(.c(7.103e-16)) (*
integer library_binding = "analogLib";

 *)
c2401 ( \4:AEQ_CNT_ANLG(2) , \5:AEQ_CNT_ANLG(1)  );
capacitor #(.c(1.189e-18)) (*
integer library_binding = "analogLib";

 *)
c2402 ( \4:AEQ_CNT_ANLG(2) , \6:XTAL25  );
capacitor #(.c(1.3e-18)) (*
integer library_binding = "analogLib";

 *)
c2403 ( \4:AEQ_CNT_ANLG(2) , \4:PLL_160_IN  );
capacitor #(.c(1.894e-16)) (*
integer library_binding = "analogLib";

 *)
c2404 ( \4:AEQ_CNT_ANLG(2) , \25:VDDTX  );
capacitor #(.c(3.608e-17)) (*
integer library_binding = "analogLib";

 *)
c2405 ( \4:AEQ_CNT_ANLG(2) , \24:VDDTX  );
capacitor #(.c(1.473e-17)) (*
integer library_binding = "analogLib";

 *)
c2406 ( \4:AEQ_CNT_ANLG(2) , \5:ADC_DIS_2p5  );
capacitor #(.c(1.471e-19)) (*
integer library_binding = "analogLib";

 *)
c2407 ( \4:AEQ_CNT_ANLG(2) , ADC_DIS_2p5 );
capacitor #(.c(1.428e-18)) (*
integer library_binding = "analogLib";

 *)
c2408 ( \4:AEQ_CNT_ANLG(2) , \WANDER_CNT(0)  );
capacitor #(.c(2.7e-19)) (*
integer library_binding = "analogLib";

 *)
c2409 ( \4:AEQ_CNT_ANLG(2) , BLW_DIS_2p5 );
capacitor #(.c(4.158e-17)) (*
integer library_binding = "analogLib";

 *)
c2410 ( \4:AEQ_CNT_ANLG(2) , AEQ_DIS_2p5 );
capacitor #(.c(2.772e-17)) (*
integer library_binding = "analogLib";

 *)
c2411 ( \4:AEQ_CNT_ANLG(2) , \WANDER_CNT(6)  );
capacitor #(.c(2.627e-18)) (*
integer library_binding = "analogLib";

 *)
c2412 ( \4:AEQ_CNT_ANLG(2) , \6:AEQ_DIS_2p5  );
capacitor #(.c(1.917e-17)) (*
integer library_binding = "analogLib";

 *)
c2413 ( \4:AEQ_CNT_ANLG(2) , \5:BLW_DIS_2p5  );
capacitor #(.c(1.785e-17)) (*
integer library_binding = "analogLib";

 *)
c2414 ( \4:AEQ_CNT_ANLG(2) , \4:AEQ_CNT_ANLG(0)  );
capacitor #(.c(1.955e-18)) (*
integer library_binding = "analogLib";

 *)
c2415 ( \4:AEQ_CNT_ANLG(2) , \5:WANDER_CNT(6)  );
capacitor #(.c(2.18e-18)) (*
integer library_binding = "analogLib";

 *)
c2416 ( \4:AEQ_CNT_ANLG(2) , \AEQ_CNT_ANLG(0)  );
capacitor #(.c(2.999e-19)) (*
integer library_binding = "analogLib";

 *)
c2417 ( \4:AEQ_CNT_ANLG(2) , ADC_TEST_2p5 );
capacitor #(.c(1.403e-17)) (*
integer library_binding = "analogLib";

 *)
c2418 ( \4:AEQ_CNT_ANLG(2) , \4:WANDER_CNT(0)  );
capacitor #(.c(1.562e-17)) (*
integer library_binding = "analogLib";

 *)
c2419 ( \4:AEQ_CNT_ANLG(2) , \4:WANDER_CNT(3)  );
capacitor #(.c(1.434e-18)) (*
integer library_binding = "analogLib";

 *)
c2420 ( \4:AEQ_CNT_ANLG(2) , \WANDER_CNT(3)  );
capacitor #(.c(1.908e-17)) (*
integer library_binding = "analogLib";

 *)
c2421 ( \4:AEQ_CNT_ANLG(2) , \8:TX100_DIS_2p5  );
capacitor #(.c(3.289e-19)) (*
integer library_binding = "analogLib";

 *)
c2422 ( \4:AEQ_CNT_ANLG(2) , \2:TX100_DIS_2p5  );
capacitor #(.c(1.941e-17)) (*
integer library_binding = "analogLib";

 *)
c2423 ( \4:AEQ_CNT_ANLG(2) , \6:X10_DIS_2p5  );
capacitor #(.c(4.104e-15)) (*
integer library_binding = "analogLib";

 *)
c2424 ( \4:AEQ_CNT_ANLG(2) , GND );
capacitor #(.c(1.768e-16)) (*
integer library_binding = "analogLib";

 *)
c2425 ( \1:RXD(0) , \4:GND  );
capacitor #(.c(2.725e-15)) (*
integer library_binding = "analogLib";

 *)
c2426 ( \1:RXD(0) , GND );
capacitor #(.c(3.293e-16)) (*
integer library_binding = "analogLib";

 *)
c2427 ( \1:RXD(0) , \4:VDD  );
capacitor #(.c(2.725e-15)) (*
integer library_binding = "analogLib";

 *)
c2428 ( \RXD(0) , GND );
capacitor #(.c(3.651e-16)) (*
integer library_binding = "analogLib";

 *)
c2429 ( \RXD(0) , \4:GND  );
capacitor #(.c(2.105e-16)) (*
integer library_binding = "analogLib";

 *)
c2430 ( \TEST_MODE(1) , \4:GND  );
capacitor #(.c(2.554e-18)) (*
integer library_binding = "analogLib";

 *)
c2431 ( \TEST_MODE(1) , \TX_AMPTRIM_1p0(1)  );
capacitor #(.c(1.993e-17)) (*
integer library_binding = "analogLib";

 *)
c2432 ( \TEST_MODE(1) , \4:MLT3_TDATA_1p0(0)  );
capacitor #(.c(1.853e-17)) (*
integer library_binding = "analogLib";

 *)
c2433 ( \TEST_MODE(1) , \4:SLICER_OUT_1p0  );
capacitor #(.c(2.034e-17)) (*
integer library_binding = "analogLib";

 *)
c2434 ( \TEST_MODE(1) , \4:RX10_PRESENT_1p0  );
capacitor #(.c(1.962e-17)) (*
integer library_binding = "analogLib";

 *)
c2435 ( \TEST_MODE(1) , \4:X_125  );
capacitor #(.c(3.249e-16)) (*
integer library_binding = "analogLib";

 *)
c2436 ( \TEST_MODE(1) , \3:XTAL25_1p0  );
capacitor #(.c(2.87e-18)) (*
integer library_binding = "analogLib";

 *)
c2437 ( \TEST_MODE(1) , \MR_SQUELCH_RANGE_1p0(1)  );
capacitor #(.c(1.697e-17)) (*
integer library_binding = "analogLib";

 *)
c2438 ( \TEST_MODE(1) , X_160 );
capacitor #(.c(1.62e-17)) (*
integer library_binding = "analogLib";

 *)
c2439 ( \TEST_MODE(1) , \4:MR_SQUELCH_RANGE_1p0(1)  );
capacitor #(.c(4.957e-16)) (*
integer library_binding = "analogLib";

 *)
c2440 ( \TEST_MODE(1) , \3:NEG_DETECT_1p0  );
capacitor #(.c(5.278e-16)) (*
integer library_binding = "analogLib";

 *)
c2441 ( \TEST_MODE(1) , MR_SQUELCH_DISB_1p0 );
capacitor #(.c(3.243e-15)) (*
integer library_binding = "analogLib";

 *)
c2442 ( \TEST_MODE(1) , GND );
capacitor #(.c(5.836e-16)) (*
integer library_binding = "analogLib";

 *)
c2443 ( \TEST_MODE(1) , NEG_DETECT_1p0 );
capacitor #(.c(1.484e-15)) (*
integer library_binding = "analogLib";

 *)
c2444 ( \TEST_MODE(1) , \4:MR_SQUELCH_DISB_1p0  );
capacitor #(.c(1.712e-17)) (*
integer library_binding = "analogLib";

 *)
c2445 ( \TEST_MODE(1) , POS_DETECT_1p0 );
capacitor #(.c(6.948e-19)) (*
integer library_binding = "analogLib";

 *)
c2446 ( \TEST_MODE(1) , SLICER_OUT_1p0 );
capacitor #(.c(4.149e-19)) (*
integer library_binding = "analogLib";

 *)
c2447 ( \TEST_MODE(1) , X_125 );
capacitor #(.c(2.771e-18)) (*
integer library_binding = "analogLib";

 *)
c2448 ( \TEST_MODE(1) , \3:X_160  );
capacitor #(.c(8.103e-19)) (*
integer library_binding = "analogLib";

 *)
c2449 ( \TEST_MODE(1) , \MLT3_TDATA_1p0(0)  );
capacitor #(.c(2.62e-18)) (*
integer library_binding = "analogLib";

 *)
c2450 ( \TEST_MODE(1) , \3:POS_DETECT_1p0  );
capacitor #(.c(4.438e-19)) (*
integer library_binding = "analogLib";

 *)
c2451 ( \TEST_MODE(1) , RX10_PRESENT_1p0 );
capacitor #(.c(5.448e-16)) (*
integer library_binding = "analogLib";

 *)
c2452 ( \TEST_MODE(1) , XTAL25_1p0 );
capacitor #(.c(1.741e-17)) (*
integer library_binding = "analogLib";

 *)
c2453 ( \TEST_MODE(1) , \5:TXER  );
capacitor #(.c(1.485e-17)) (*
integer library_binding = "analogLib";

 *)
c2454 ( \TEST_MODE(1) , \4:TX_AMPTRIM_1p0(1)  );
capacitor #(.c(2.2e-17)) (*
integer library_binding = "analogLib";

 *)
c2455 ( \TEST_MODE(1) , \2:ADC_1p0(0)  );
capacitor #(.c(1.31e-17)) (*
integer library_binding = "analogLib";

 *)
c2456 ( \TEST_MODE(1) , \1:RCLK125_1p0  );
capacitor #(.c(1.778e-17)) (*
integer library_binding = "analogLib";

 *)
c2457 ( \TEST_MODE(1) , \2:ADC_1p0(3)  );
capacitor #(.c(1.835e-17)) (*
integer library_binding = "analogLib";

 *)
c2458 ( \TEST_MODE(1) , \FLASH_1p0(0)  );
capacitor #(.c(2.022e-17)) (*
integer library_binding = "analogLib";

 *)
c2459 ( \TEST_MODE(1) , \2:ADC_1p0(5)  );
capacitor #(.c(1.959e-17)) (*
integer library_binding = "analogLib";

 *)
c2460 ( \TEST_MODE(1) , \FLASH_1p0(1)  );
capacitor #(.c(1.959e-17)) (*
integer library_binding = "analogLib";

 *)
c2461 ( \TEST_MODE(1) , \1:ADC_1p0(4)  );
capacitor #(.c(1.931e-16)) (*
integer library_binding = "analogLib";

 *)
c2462 ( \3:TEST_MODE(1) , \4:GND  );
capacitor #(.c(2.176e-17)) (*
integer library_binding = "analogLib";

 *)
c2463 ( \3:TEST_MODE(1) , \TX_AMPTRIM_1p0(1)  );
capacitor #(.c(7.957e-16)) (*
integer library_binding = "analogLib";

 *)
c2464 ( \3:TEST_MODE(1) , \3:XTAL25_1p0  );
capacitor #(.c(2.097e-17)) (*
integer library_binding = "analogLib";

 *)
c2465 ( \3:TEST_MODE(1) , \MR_SQUELCH_RANGE_1p0(1)  );
capacitor #(.c(2.717e-18)) (*
integer library_binding = "analogLib";

 *)
c2466 ( \3:TEST_MODE(1) , X_160 );
capacitor #(.c(3.172e-18)) (*
integer library_binding = "analogLib";

 *)
c2467 ( \3:TEST_MODE(1) , \4:MR_SQUELCH_RANGE_1p0(1)  );
capacitor #(.c(8.328e-16)) (*
integer library_binding = "analogLib";

 *)
c2468 ( \3:TEST_MODE(1) , \3:NEG_DETECT_1p0  );
capacitor #(.c(1.989e-15)) (*
integer library_binding = "analogLib";

 *)
c2469 ( \3:TEST_MODE(1) , MR_SQUELCH_DISB_1p0 );
capacitor #(.c(2.975e-15)) (*
integer library_binding = "analogLib";

 *)
c2470 ( \3:TEST_MODE(1) , GND );
capacitor #(.c(1.111e-16)) (*
integer library_binding = "analogLib";

 *)
c2471 ( \3:TEST_MODE(1) , NEG_DETECT_1p0 );
capacitor #(.c(2.734e-16)) (*
integer library_binding = "analogLib";

 *)
c2472 ( \3:TEST_MODE(1) , \4:MR_SQUELCH_DISB_1p0  );
capacitor #(.c(2.741e-18)) (*
integer library_binding = "analogLib";

 *)
c2473 ( \3:TEST_MODE(1) , POS_DETECT_1p0 );
capacitor #(.c(1.978e-17)) (*
integer library_binding = "analogLib";

 *)
c2474 ( \3:TEST_MODE(1) , SLICER_OUT_1p0 );
capacitor #(.c(1.978e-17)) (*
integer library_binding = "analogLib";

 *)
c2475 ( \3:TEST_MODE(1) , X_125 );
capacitor #(.c(2.016e-17)) (*
integer library_binding = "analogLib";

 *)
c2476 ( \3:TEST_MODE(1) , \3:X_160  );
capacitor #(.c(1.978e-17)) (*
integer library_binding = "analogLib";

 *)
c2477 ( \3:TEST_MODE(1) , \MLT3_TDATA_1p0(0)  );
capacitor #(.c(2.014e-17)) (*
integer library_binding = "analogLib";

 *)
c2478 ( \3:TEST_MODE(1) , \3:POS_DETECT_1p0  );
capacitor #(.c(2.116e-17)) (*
integer library_binding = "analogLib";

 *)
c2479 ( \3:TEST_MODE(1) , RX10_PRESENT_1p0 );
capacitor #(.c(2.632e-18)) (*
integer library_binding = "analogLib";

 *)
c2480 ( \3:TEST_MODE(1) , \4:TX_AMPTRIM_1p0(1)  );
capacitor #(.c(2.787e-18)) (*
integer library_binding = "analogLib";

 *)
c2481 ( \3:TEST_MODE(1) , \5:TXER  );
capacitor #(.c(1.055e-16)) (*
integer library_binding = "analogLib";

 *)
c2482 ( \3:TEST_MODE(1) , XTAL25_1p0 );
capacitor #(.c(8.424e-17)) (*
integer library_binding = "analogLib";

 *)
c2483 ( NEG_DETECT_2p5, \4:GND  );
capacitor #(.c(4.113e-18)) (*
integer library_binding = "analogLib";

 *)
c2484 ( NEG_DETECT_2p5, \I_RPOLY_100(0)  );
capacitor #(.c(1.223e-18)) (*
integer library_binding = "analogLib";

 *)
c2485 ( NEG_DETECT_2p5, \2:I_RPOLY_100(0)  );
capacitor #(.c(1.215e-18)) (*
integer library_binding = "analogLib";

 *)
c2486 ( NEG_DETECT_2p5, \2:I_REXT_100(6)  );
capacitor #(.c(4.12e-18)) (*
integer library_binding = "analogLib";

 *)
c2487 ( NEG_DETECT_2p5, \I_REXT_100(6)  );
capacitor #(.c(1.426e-16)) (*
integer library_binding = "analogLib";

 *)
c2488 ( NEG_DETECT_2p5, \5:POS_DETECT_2p5  );
capacitor #(.c(1.781e-18)) (*
integer library_binding = "analogLib";

 *)
c2489 ( NEG_DETECT_2p5, \2:I_RPOLY_100(5)  );
capacitor #(.c(5.762e-18)) (*
integer library_binding = "analogLib";

 *)
c2490 ( NEG_DETECT_2p5, \I_RPOLY_100(5)  );
capacitor #(.c(9.132e-18)) (*
integer library_binding = "analogLib";

 *)
c2491 ( NEG_DETECT_2p5, \I_REXT_50(0)  );
capacitor #(.c(7.358e-18)) (*
integer library_binding = "analogLib";

 *)
c2492 ( NEG_DETECT_2p5, \4:I_RPOLY_REF100  );
capacitor #(.c(3.413e-20)) (*
integer library_binding = "analogLib";

 *)
c2493 ( NEG_DETECT_2p5, \25:GND  );
capacitor #(.c(1.238e-18)) (*
integer library_binding = "analogLib";

 *)
c2494 ( NEG_DETECT_2p5, \I_RPOLY_100(2)  );
capacitor #(.c(4.097e-18)) (*
integer library_binding = "analogLib";

 *)
c2495 ( NEG_DETECT_2p5, \3:I_RPOLY_100(2)  );
capacitor #(.c(4.153e-18)) (*
integer library_binding = "analogLib";

 *)
c2496 ( NEG_DETECT_2p5, \I_REXT_100(2)  );
capacitor #(.c(1.182e-18)) (*
integer library_binding = "analogLib";

 *)
c2497 ( NEG_DETECT_2p5, \2:I_REXT_100(2)  );
capacitor #(.c(2.804e-16)) (*
integer library_binding = "analogLib";

 *)
c2498 ( NEG_DETECT_2p5, POS_DETECT_2p5 );
capacitor #(.c(1.245e-18)) (*
integer library_binding = "analogLib";

 *)
c2499 ( NEG_DETECT_2p5, \2:I_RPOLY_100(3)  );
capacitor #(.c(4.09e-18)) (*
integer library_binding = "analogLib";

 *)
c2500 ( NEG_DETECT_2p5, \I_RPOLY_100(3)  );
capacitor #(.c(1.191e-18)) (*
integer library_binding = "analogLib";

 *)
c2501 ( NEG_DETECT_2p5, \2:I_REXT_100(3)  );
capacitor #(.c(4.144e-18)) (*
integer library_binding = "analogLib";

 *)
c2502 ( NEG_DETECT_2p5, \I_REXT_100(3)  );
capacitor #(.c(1.264e-18)) (*
integer library_binding = "analogLib";

 *)
c2503 ( NEG_DETECT_2p5, \2:I_RPOLY_100(4)  );
capacitor #(.c(4.12e-18)) (*
integer library_binding = "analogLib";

 *)
c2504 ( NEG_DETECT_2p5, \3:I_RPOLY_100(4)  );
capacitor #(.c(1.199e-18)) (*
integer library_binding = "analogLib";

 *)
c2505 ( NEG_DETECT_2p5, \2:I_REXT_100(4)  );
capacitor #(.c(4.136e-18)) (*
integer library_binding = "analogLib";

 *)
c2506 ( NEG_DETECT_2p5, \I_REXT_100(4)  );
capacitor #(.c(1.3e-15)) (*
integer library_binding = "analogLib";

 *)
c2507 ( NEG_DETECT_2p5, GND );
capacitor #(.c(7.32e-17)) (*
integer library_binding = "analogLib";

 *)
c2508 ( \4:NEG_DETECT_2p5 , \4:GND  );
capacitor #(.c(5.618e-18)) (*
integer library_binding = "analogLib";

 *)
c2509 ( \4:NEG_DETECT_2p5 , \I_RPOLY_100(0)  );
capacitor #(.c(1.67e-18)) (*
integer library_binding = "analogLib";

 *)
c2510 ( \4:NEG_DETECT_2p5 , \2:I_RPOLY_100(0)  );
capacitor #(.c(1.659e-18)) (*
integer library_binding = "analogLib";

 *)
c2511 ( \4:NEG_DETECT_2p5 , \2:I_REXT_100(6)  );
capacitor #(.c(5.629e-18)) (*
integer library_binding = "analogLib";

 *)
c2512 ( \4:NEG_DETECT_2p5 , \I_REXT_100(6)  );
capacitor #(.c(1.954e-16)) (*
integer library_binding = "analogLib";

 *)
c2513 ( \4:NEG_DETECT_2p5 , \5:POS_DETECT_2p5  );
capacitor #(.c(2.434e-18)) (*
integer library_binding = "analogLib";

 *)
c2514 ( \4:NEG_DETECT_2p5 , \2:I_RPOLY_100(5)  );
capacitor #(.c(7.872e-18)) (*
integer library_binding = "analogLib";

 *)
c2515 ( \4:NEG_DETECT_2p5 , \I_RPOLY_100(5)  );
capacitor #(.c(1.247e-17)) (*
integer library_binding = "analogLib";

 *)
c2516 ( \4:NEG_DETECT_2p5 , \I_REXT_50(0)  );
capacitor #(.c(1.005e-17)) (*
integer library_binding = "analogLib";

 *)
c2517 ( \4:NEG_DETECT_2p5 , \4:I_RPOLY_REF100  );
capacitor #(.c(1.691e-18)) (*
integer library_binding = "analogLib";

 *)
c2518 ( \4:NEG_DETECT_2p5 , \I_RPOLY_100(2)  );
capacitor #(.c(5.598e-18)) (*
integer library_binding = "analogLib";

 *)
c2519 ( \4:NEG_DETECT_2p5 , \3:I_RPOLY_100(2)  );
capacitor #(.c(5.673e-18)) (*
integer library_binding = "analogLib";

 *)
c2520 ( \4:NEG_DETECT_2p5 , \I_REXT_100(2)  );
capacitor #(.c(1.615e-18)) (*
integer library_binding = "analogLib";

 *)
c2521 ( \4:NEG_DETECT_2p5 , \2:I_REXT_100(2)  );
capacitor #(.c(1.701e-18)) (*
integer library_binding = "analogLib";

 *)
c2522 ( \4:NEG_DETECT_2p5 , \2:I_RPOLY_100(3)  );
capacitor #(.c(5.587e-18)) (*
integer library_binding = "analogLib";

 *)
c2523 ( \4:NEG_DETECT_2p5 , \I_RPOLY_100(3)  );
capacitor #(.c(1.626e-18)) (*
integer library_binding = "analogLib";

 *)
c2524 ( \4:NEG_DETECT_2p5 , \2:I_REXT_100(3)  );
capacitor #(.c(5.662e-18)) (*
integer library_binding = "analogLib";

 *)
c2525 ( \4:NEG_DETECT_2p5 , \I_REXT_100(3)  );
capacitor #(.c(1.727e-18)) (*
integer library_binding = "analogLib";

 *)
c2526 ( \4:NEG_DETECT_2p5 , \2:I_RPOLY_100(4)  );
capacitor #(.c(5.628e-18)) (*
integer library_binding = "analogLib";

 *)
c2527 ( \4:NEG_DETECT_2p5 , \3:I_RPOLY_100(4)  );
capacitor #(.c(1.638e-18)) (*
integer library_binding = "analogLib";

 *)
c2528 ( \4:NEG_DETECT_2p5 , \2:I_REXT_100(4)  );
capacitor #(.c(5.651e-18)) (*
integer library_binding = "analogLib";

 *)
c2529 ( \4:NEG_DETECT_2p5 , \I_REXT_100(4)  );
capacitor #(.c(7.862e-16)) (*
integer library_binding = "analogLib";

 *)
c2530 ( \4:NEG_DETECT_2p5 , POS_DETECT_2p5 );
capacitor #(.c(3.437e-17)) (*
integer library_binding = "analogLib";

 *)
c2531 ( \4:NEG_DETECT_2p5 , \25:GND  );
capacitor #(.c(1.14e-15)) (*
integer library_binding = "analogLib";

 *)
c2532 ( \4:NEG_DETECT_2p5 , GND );
capacitor #(.c(4.159e-18)) (*
integer library_binding = "analogLib";

 *)
c2533 ( \4:VDD , \2:PHASE_IN(9)  );
capacitor #(.c(2.311e-19)) (*
integer library_binding = "analogLib";

 *)
c2534 ( \4:VDD , \3:PHASE_IN(7)  );
capacitor #(.c(2.19e-19)) (*
integer library_binding = "analogLib";

 *)
c2535 ( \4:VDD , \PHASE_IN(8)  );
capacitor #(.c(2.75e-18)) (*
integer library_binding = "analogLib";

 *)
c2536 ( \4:VDD , \1:PHASE_IN(1)  );
capacitor #(.c(2.378e-19)) (*
integer library_binding = "analogLib";

 *)
c2537 ( \4:VDD , \2:PHASE_IN(2)  );
capacitor #(.c(2.912e-18)) (*
integer library_binding = "analogLib";

 *)
c2538 ( \4:VDD , \1:PLL_160_IN  );
capacitor #(.c(6.584e-19)) (*
integer library_binding = "analogLib";

 *)
c2539 ( \4:VDD , \2:PHASE_IN(3)  );
capacitor #(.c(2.38e-18)) (*
integer library_binding = "analogLib";

 *)
c2540 ( \4:VDD , \3:XTAL25  );
capacitor #(.c(3.737e-18)) (*
integer library_binding = "analogLib";

 *)
c2541 ( \4:VDD , \2:PHASE_IN(0)  );
capacitor #(.c(1.39e-18)) (*
integer library_binding = "analogLib";

 *)
c2542 ( \4:VDD , I_RPOLY_REF100 );
capacitor #(.c(2.306e-19)) (*
integer library_binding = "analogLib";

 *)
c2543 ( \4:VDD , \1:PHASE_IN(5)  );
capacitor #(.c(3.706e-17)) (*
integer library_binding = "analogLib";

 *)
c2544 ( \4:VDD , \PHASE_IN(10)  );
capacitor #(.c(1.826e-17)) (*
integer library_binding = "analogLib";

 *)
c2545 ( \4:VDD , \24:VDDTX  );
capacitor #(.c(2.24e-17)) (*
integer library_binding = "analogLib";

 *)
c2546 ( \4:VDD , \6:PHASE_IN(10)  );
capacitor #(.c(4.918e-16)) (*
integer library_binding = "analogLib";

 *)
c2547 ( \4:VDD , \26:GND  );
capacitor #(.c(1.029e-14)) (*
integer library_binding = "analogLib";

 *)
c2548 ( \4:VDD , \4:GND  );
capacitor #(.c(1.619e-16)) (*
integer library_binding = "analogLib";

 *)
c2549 ( \4:VDD , \1:B10_DIS  );
capacitor #(.c(8.587e-18)) (*
integer library_binding = "analogLib";

 *)
c2550 ( \4:VDD , \2:ADC_1p0(5)  );
capacitor #(.c(6.958e-18)) (*
integer library_binding = "analogLib";

 *)
c2551 ( \4:VDD , \2:ADC_1p0(3)  );
capacitor #(.c(8.566e-18)) (*
integer library_binding = "analogLib";

 *)
c2552 ( \4:VDD , \2:ADC_1p0(0)  );
capacitor #(.c(1.502e-16)) (*
integer library_binding = "analogLib";

 *)
c2553 ( \4:VDD , \3:TXER  );
capacitor #(.c(1.165e-17)) (*
integer library_binding = "analogLib";

 *)
c2554 ( \4:VDD , \5:TXER  );
capacitor #(.c(5.479e-14)) (*
integer library_binding = "analogLib";

 *)
c2555 ( \4:VDD , GND );
capacitor #(.c(3.293e-16)) (*
integer library_binding = "analogLib";

 *)
c2556 ( \4:VDD , \1:RXD(3)  );
capacitor #(.c(3.293e-16)) (*
integer library_binding = "analogLib";

 *)
c2557 ( \4:VDD , \1:LEDC  );
capacitor #(.c(3.293e-16)) (*
integer library_binding = "analogLib";

 *)
c2558 ( \4:VDD , \1:TXD(1)  );
capacitor #(.c(3.293e-16)) (*
integer library_binding = "analogLib";

 *)
c2559 ( \4:VDD , \1:RXD(2)  );
capacitor #(.c(3.293e-16)) (*
integer library_binding = "analogLib";

 *)
c2560 ( \4:VDD , \1:MDIO_IN  );
capacitor #(.c(3.293e-16)) (*
integer library_binding = "analogLib";

 *)
c2561 ( \4:VDD , \1:TX_AMP_TRIM(0)  );
capacitor #(.c(3.293e-16)) (*
integer library_binding = "analogLib";

 *)
c2562 ( \4:VDD , \1:RXD(1)  );
capacitor #(.c(3.293e-16)) (*
integer library_binding = "analogLib";

 *)
c2563 ( \4:VDD , \1:MDINT  );
capacitor #(.c(3.293e-16)) (*
integer library_binding = "analogLib";

 *)
c2564 ( \4:VDD , \4:B10_DIS  );
capacitor #(.c(3.293e-16)) (*
integer library_binding = "analogLib";

 *)
c2565 ( \4:VDD , \1:TXC  );
capacitor #(.c(3.293e-16)) (*
integer library_binding = "analogLib";

 *)
c2566 ( \4:VDD , \1:MDC  );
capacitor #(.c(3.293e-16)) (*
integer library_binding = "analogLib";

 *)
c2567 ( \4:VDD , \1:SCAN_MODE  );
capacitor #(.c(3.293e-16)) (*
integer library_binding = "analogLib";

 *)
c2568 ( \4:VDD , \1:PHY(3)  );
capacitor #(.c(3.293e-16)) (*
integer library_binding = "analogLib";

 *)
c2569 ( \4:VDD , \1:TRISTATE  );
capacitor #(.c(3.293e-16)) (*
integer library_binding = "analogLib";

 *)
c2570 ( \4:VDD , \1:LEDT  );
capacitor #(.c(2.55e-16)) (*
integer library_binding = "analogLib";

 *)
c2571 ( \4:VDD , \4:TXER  );
capacitor #(.c(3.293e-16)) (*
integer library_binding = "analogLib";

 *)
c2572 ( \4:VDD , \1:ANLG_TST  );
capacitor #(.c(3.293e-16)) (*
integer library_binding = "analogLib";

 *)
c2573 ( \4:VDD , \1:TX_SLP_TRIM(1)  );
capacitor #(.c(3.293e-16)) (*
integer library_binding = "analogLib";

 *)
c2574 ( \4:VDD , \1:PHY(2)  );
capacitor #(.c(3.293e-16)) (*
integer library_binding = "analogLib";

 *)
c2575 ( \4:VDD , \1:CRS  );
capacitor #(.c(3.293e-16)) (*
integer library_binding = "analogLib";

 *)
c2576 ( \4:VDD , \1:TXEN  );
capacitor #(.c(3.293e-16)) (*
integer library_binding = "analogLib";

 *)
c2577 ( \4:VDD , \1:RXER  );
capacitor #(.c(3.293e-16)) (*
integer library_binding = "analogLib";

 *)
c2578 ( \4:VDD , \1:ANDIS  );
capacitor #(.c(3.293e-16)) (*
integer library_binding = "analogLib";

 *)
c2579 ( \4:VDD , \1:TX_SLP_TRIM(0)  );
capacitor #(.c(3.293e-16)) (*
integer library_binding = "analogLib";

 *)
c2580 ( \4:VDD , \1:PHY(1)  );
capacitor #(.c(3.293e-16)) (*
integer library_binding = "analogLib";

 *)
c2581 ( \4:VDD , \1:COL  );
capacitor #(.c(3.293e-16)) (*
integer library_binding = "analogLib";

 *)
c2582 ( \4:VDD , \1:LEDR  );
capacitor #(.c(3.293e-16)) (*
integer library_binding = "analogLib";

 *)
c2583 ( \4:VDD , \1:TXD(4)  );
capacitor #(.c(3.293e-16)) (*
integer library_binding = "analogLib";

 *)
c2584 ( \4:VDD , \1:RXDV  );
capacitor #(.c(3.293e-16)) (*
integer library_binding = "analogLib";

 *)
c2585 ( \4:VDD , \1:PHY(0)  );
capacitor #(.c(3.293e-16)) (*
integer library_binding = "analogLib";

 *)
c2586 ( \4:VDD , \1:LEDL  );
capacitor #(.c(3.293e-16)) (*
integer library_binding = "analogLib";

 *)
c2587 ( \4:VDD , \1:TXD(3)  );
capacitor #(.c(3.293e-16)) (*
integer library_binding = "analogLib";

 *)
c2588 ( \4:VDD , \1:RXD(4)  );
capacitor #(.c(3.293e-16)) (*
integer library_binding = "analogLib";

 *)
c2589 ( \4:VDD , \1:MDIO_OUT  );
capacitor #(.c(3.293e-16)) (*
integer library_binding = "analogLib";

 *)
c2590 ( \4:VDD , \1:LEDD  );
capacitor #(.c(2.813e-17)) (*
integer library_binding = "analogLib";

 *)
c2591 ( \11:VDD , \4:GND  );
capacitor #(.c(4.334e-16)) (*
integer library_binding = "analogLib";

 *)
c2592 ( \11:VDD , GND );
capacitor #(.c(1.066e-16)) (*
integer library_binding = "analogLib";

 *)
c2593 ( \7:VDD , \1:B10_DIS  );
capacitor #(.c(4.583e-18)) (*
integer library_binding = "analogLib";

 *)
c2594 ( \7:VDD , \2:ADC_1p0(3)  );
capacitor #(.c(5.643e-18)) (*
integer library_binding = "analogLib";

 *)
c2595 ( \7:VDD , \2:ADC_1p0(0)  );
capacitor #(.c(9.897e-17)) (*
integer library_binding = "analogLib";

 *)
c2596 ( \7:VDD , \3:TXER  );
capacitor #(.c(7.674e-18)) (*
integer library_binding = "analogLib";

 *)
c2597 ( \7:VDD , \5:TXER  );
capacitor #(.c(9.833e-16)) (*
integer library_binding = "analogLib";

 *)
c2598 ( \7:VDD , \1:RCLK125_1p0  );
capacitor #(.c(9.097e-16)) (*
integer library_binding = "analogLib";

 *)
c2599 ( \7:VDD , \4:RCLK125_1p0  );
capacitor #(.c(3.675e-17)) (*
integer library_binding = "analogLib";

 *)
c2600 ( \7:VDD , \ADC_1p0(3)  );
capacitor #(.c(2.376e-17)) (*
integer library_binding = "analogLib";

 *)
c2601 ( \7:VDD , \3:ADC_1p0(5)  );
capacitor #(.c(1.829e-17)) (*
integer library_binding = "analogLib";

 *)
c2602 ( \7:VDD , \2:ADC_1p0(5)  );
capacitor #(.c(2.187e-15)) (*
integer library_binding = "analogLib";

 *)
c2603 ( \7:VDD , \3:FLASH_1p0(0)  );
capacitor #(.c(8.667e-15)) (*
integer library_binding = "analogLib";

 *)
c2604 ( \7:VDD , GND );
capacitor #(.c(3.049e-15)) (*
integer library_binding = "analogLib";

 *)
c2605 ( \7:VDD , \3:ADC_1p0(0)  );
capacitor #(.c(1.605e-14)) (*
integer library_binding = "analogLib";

 *)
c2606 ( \7:VDD , \4:GND  );
capacitor #(.c(8.319e-17)) (*
integer library_binding = "analogLib";

 *)
c2607 ( VDD, \4:GND  );
capacitor #(.c(1.282e-15)) (*
integer library_binding = "analogLib";

 *)
c2608 ( VDD, GND );
capacitor #(.c(2.84e-16)) (*
integer library_binding = "analogLib";

 *)
c2609 ( \6:VDD , \4:GND  );
capacitor #(.c(2.15e-16)) (*
integer library_binding = "analogLib";

 *)
c2610 ( \6:VDD , \12:I_RPOLY_REF100  );
capacitor #(.c(2.119e-17)) (*
integer library_binding = "analogLib";

 *)
c2611 ( \6:VDD , \4:I_RPOLY_REF100  );
capacitor #(.c(4.547e-17)) (*
integer library_binding = "analogLib";

 *)
c2612 ( \6:VDD , \1:RCLK125_1p0  );
capacitor #(.c(1.815e-16)) (*
integer library_binding = "analogLib";

 *)
c2613 ( \6:VDD , \7:I_REXT_50(0)  );
capacitor #(.c(2.547e-17)) (*
integer library_binding = "analogLib";

 *)
c2614 ( \6:VDD , \I_REXT_50(0)  );
capacitor #(.c(4.376e-15)) (*
integer library_binding = "analogLib";

 *)
c2615 ( \6:VDD , GND );
capacitor #(.c(9.746e-17)) (*
integer library_binding = "analogLib";

 *)
c2616 ( \6:VDD , \4:I_RPOLY_100(0)  );
capacitor #(.c(1.736e-16)) (*
integer library_binding = "analogLib";

 *)
c2617 ( \6:VDD , \4:I_RPOLY_100(5)  );
capacitor #(.c(9.746e-17)) (*
integer library_binding = "analogLib";

 *)
c2618 ( \6:VDD , \I_RPOLY_100(4)  );
capacitor #(.c(9.746e-17)) (*
integer library_binding = "analogLib";

 *)
c2619 ( \6:VDD , \4:I_RPOLY_100(3)  );
capacitor #(.c(9.746e-17)) (*
integer library_binding = "analogLib";

 *)
c2620 ( \6:VDD , \4:I_RPOLY_100(2)  );
capacitor #(.c(1.594e-15)) (*
integer library_binding = "analogLib";

 *)
c2621 ( \6:VDD , \6:GNDRX  );
capacitor #(.c(2.084e-15)) (*
integer library_binding = "analogLib";

 *)
c2622 ( \6:VDD , \4:FLASH_1p0(0)  );
capacitor #(.c(2.411e-17)) (*
integer library_binding = "analogLib";

 *)
c2623 ( \6:VDD , \3:FLASH_1p0(0)  );
capacitor #(.c(3.473e-16)) (*
integer library_binding = "analogLib";

 *)
c2624 ( \6:VDD , \4:FLASH_1p0(1)  );
capacitor #(.c(3.117e-15)) (*
integer library_binding = "analogLib";

 *)
c2625 ( \6:VDD , \ADC_1p0(0)  );
capacitor #(.c(7.48e-17)) (*
integer library_binding = "analogLib";

 *)
c2626 ( \6:VDD , \3:ADC_1p0(0)  );
capacitor #(.c(5.219e-16)) (*
integer library_binding = "analogLib";

 *)
c2627 ( \6:VDD , \ADC_1p0(5)  );
capacitor #(.c(2.093e-15)) (*
integer library_binding = "analogLib";

 *)
c2628 ( \6:VDD , \4:RCLK125_1p0  );
capacitor #(.c(3.772e-17)) (*
integer library_binding = "analogLib";

 *)
c2629 ( \12:VDD , \4:GND  );
capacitor #(.c(2.809e-16)) (*
integer library_binding = "analogLib";

 *)
c2630 ( \12:VDD , \7:I_REXT_50(0)  );
capacitor #(.c(3.942e-17)) (*
integer library_binding = "analogLib";

 *)
c2631 ( \12:VDD , \I_REXT_50(0)  );
capacitor #(.c(5.813e-16)) (*
integer library_binding = "analogLib";

 *)
c2632 ( \12:VDD , GND );
capacitor #(.c(1.561e-15)) (*
integer library_binding = "analogLib";

 *)
c2633 ( \12:VDD , \5:GND  );
capacitor #(.c(7.809e-17)) (*
integer library_binding = "analogLib";

 *)
c2634 ( \10:VDD , \4:GND  );
capacitor #(.c(1.203e-15)) (*
integer library_binding = "analogLib";

 *)
c2635 ( \10:VDD , GND );
capacitor #(.c(1.288e-16)) (*
integer library_binding = "analogLib";

 *)
c2636 ( \10:VDD , \25:GND  );
capacitor #(.c(9.746e-17)) (*
integer library_binding = "analogLib";

 *)
c2637 ( \10:VDD , \4:I_REXT_100(6)  );
capacitor #(.c(9.746e-17)) (*
integer library_binding = "analogLib";

 *)
c2638 ( \10:VDD , \4:I_REXT_100(4)  );
capacitor #(.c(9.746e-17)) (*
integer library_binding = "analogLib";

 *)
c2639 ( \10:VDD , \4:I_REXT_100(3)  );
capacitor #(.c(9.746e-17)) (*
integer library_binding = "analogLib";

 *)
c2640 ( \10:VDD , \4:I_REXT_100(2)  );
capacitor #(.c(2.793e-15)) (*
integer library_binding = "analogLib";

 *)
c2641 ( \9:VDD , \4:GND  );
capacitor #(.c(1.995e-16)) (*
integer library_binding = "analogLib";

 *)
c2642 ( \9:VDD , \2:PHASE_IN(9)  );
capacitor #(.c(1.108e-17)) (*
integer library_binding = "analogLib";

 *)
c2643 ( \9:VDD , \3:PHASE_IN(7)  );
capacitor #(.c(1.051e-17)) (*
integer library_binding = "analogLib";

 *)
c2644 ( \9:VDD , \PHASE_IN(8)  );
capacitor #(.c(1.319e-16)) (*
integer library_binding = "analogLib";

 *)
c2645 ( \9:VDD , \1:PHASE_IN(1)  );
capacitor #(.c(1.141e-17)) (*
integer library_binding = "analogLib";

 *)
c2646 ( \9:VDD , \2:PHASE_IN(2)  );
capacitor #(.c(1.397e-16)) (*
integer library_binding = "analogLib";

 *)
c2647 ( \9:VDD , \1:PLL_160_IN  );
capacitor #(.c(3.158e-17)) (*
integer library_binding = "analogLib";

 *)
c2648 ( \9:VDD , \2:PHASE_IN(3)  );
capacitor #(.c(1.142e-16)) (*
integer library_binding = "analogLib";

 *)
c2649 ( \9:VDD , \3:XTAL25  );
capacitor #(.c(1.792e-16)) (*
integer library_binding = "analogLib";

 *)
c2650 ( \9:VDD , \2:PHASE_IN(0)  );
capacitor #(.c(6.665e-17)) (*
integer library_binding = "analogLib";

 *)
c2651 ( \9:VDD , I_RPOLY_REF100 );
capacitor #(.c(1.106e-17)) (*
integer library_binding = "analogLib";

 *)
c2652 ( \9:VDD , \1:PHASE_IN(5)  );
capacitor #(.c(1.778e-15)) (*
integer library_binding = "analogLib";

 *)
c2653 ( \9:VDD , \PHASE_IN(10)  );
capacitor #(.c(1.074e-15)) (*
integer library_binding = "analogLib";

 *)
c2654 ( \9:VDD , \6:PHASE_IN(10)  );
capacitor #(.c(1.131e-15)) (*
integer library_binding = "analogLib";

 *)
c2655 ( \9:VDD , \26:GND  );
capacitor #(.c(4.304e-14)) (*
integer library_binding = "analogLib";

 *)
c2656 ( \9:VDD , GND );
capacitor #(.c(3.355e-15)) (*
integer library_binding = "analogLib";

 *)
c2657 ( \9:VDD , \24:VDDTX  );
capacitor #(.c(1.768e-16)) (*
integer library_binding = "analogLib";

 *)
c2658 ( \1:LEDR , \4:GND  );
capacitor #(.c(2.725e-15)) (*
integer library_binding = "analogLib";

 *)
c2659 ( \1:LEDR , GND );
capacitor #(.c(2.725e-15)) (*
integer library_binding = "analogLib";

 *)
c2660 ( LEDR, GND );
capacitor #(.c(3.651e-16)) (*
integer library_binding = "analogLib";

 *)
c2661 ( LEDR, \4:GND  );
capacitor #(.c(4.874e-16)) (*
integer library_binding = "analogLib";

 *)
c2662 ( \PHASE_IN(0) , \4:GND  );
capacitor #(.c(1.268e-18)) (*
integer library_binding = "analogLib";

 *)
c2663 ( \PHASE_IN(0) , \WANDER_CNT(4)  );
capacitor #(.c(1.114e-18)) (*
integer library_binding = "analogLib";

 *)
c2664 ( \PHASE_IN(0) , \AEQ_CNT_ANLG(1)  );
capacitor #(.c(1.508e-17)) (*
integer library_binding = "analogLib";

 *)
c2665 ( \PHASE_IN(0) , \MLT3_TDATA_2p5(1)  );
capacitor #(.c(1.132e-18)) (*
integer library_binding = "analogLib";

 *)
c2666 ( \PHASE_IN(0) , \4:MLT3_TDATA_2p5(1)  );
capacitor #(.c(6.828e-19)) (*
integer library_binding = "analogLib";

 *)
c2667 ( \PHASE_IN(0) , \WANDER_CNT(2)  );
capacitor #(.c(1.385e-17)) (*
integer library_binding = "analogLib";

 *)
c2668 ( \PHASE_IN(0) , \5:WANDER_CNT(2)  );
capacitor #(.c(1.267e-18)) (*
integer library_binding = "analogLib";

 *)
c2669 ( \PHASE_IN(0) , \AEQ_CNT_ANLG(4)  );
capacitor #(.c(3.362e-16)) (*
integer library_binding = "analogLib";

 *)
c2670 ( \PHASE_IN(0) , TP_DISC_2p5 );
capacitor #(.c(6.55e-18)) (*
integer library_binding = "analogLib";

 *)
c2671 ( \PHASE_IN(0) , \9:TX100_DIS_2p5  );
capacitor #(.c(2.528e-17)) (*
integer library_binding = "analogLib";

 *)
c2672 ( \PHASE_IN(0) , \2:TX100_DIS_2p5  );
capacitor #(.c(8.015e-17)) (*
integer library_binding = "analogLib";

 *)
c2673 ( \PHASE_IN(0) , \WANDER_CNT(0)  );
capacitor #(.c(6.123e-18)) (*
integer library_binding = "analogLib";

 *)
c2674 ( \PHASE_IN(0) , \4:WANDER_CNT(0)  );
capacitor #(.c(3.08e-18)) (*
integer library_binding = "analogLib";

 *)
c2675 ( \PHASE_IN(0) , \5:PHASE_IN(5)  );
capacitor #(.c(8.095e-17)) (*
integer library_binding = "analogLib";

 *)
c2676 ( \PHASE_IN(0) , \24:VDDTX  );
capacitor #(.c(4.25e-16)) (*
integer library_binding = "analogLib";

 *)
c2677 ( \PHASE_IN(0) , \25:VDDTX  );
capacitor #(.c(3.653e-18)) (*
integer library_binding = "analogLib";

 *)
c2678 ( \PHASE_IN(0) , \7:PHASE_IN(9)  );
capacitor #(.c(2.874e-16)) (*
integer library_binding = "analogLib";

 *)
c2679 ( \PHASE_IN(0) , \5:PHASE_IN(1)  );
capacitor #(.c(8.44e-18)) (*
integer library_binding = "analogLib";

 *)
c2680 ( \PHASE_IN(0) , \PHASE_IN(2)  );
capacitor #(.c(1.897e-18)) (*
integer library_binding = "analogLib";

 *)
c2681 ( \PHASE_IN(0) , \4:PHASE_IN(8)  );
capacitor #(.c(2.973e-18)) (*
integer library_binding = "analogLib";

 *)
c2682 ( \PHASE_IN(0) , \7:PHASE_IN(8)  );
capacitor #(.c(1.965e-18)) (*
integer library_binding = "analogLib";

 *)
c2683 ( \PHASE_IN(0) , \4:PHASE_IN(3)  );
capacitor #(.c(4.088e-18)) (*
integer library_binding = "analogLib";

 *)
c2684 ( \PHASE_IN(0) , \7:PHASE_IN(3)  );
capacitor #(.c(1.355e-17)) (*
integer library_binding = "analogLib";

 *)
c2685 ( \PHASE_IN(0) , \AEQ_CNT_ANLG(0)  );
capacitor #(.c(9.887e-19)) (*
integer library_binding = "analogLib";

 *)
c2686 ( \PHASE_IN(0) , \4:AEQ_CNT_ANLG(0)  );
capacitor #(.c(1.074e-19)) (*
integer library_binding = "analogLib";

 *)
c2687 ( \PHASE_IN(0) , \1:PLL_160_IN  );
capacitor #(.c(1.692e-17)) (*
integer library_binding = "analogLib";

 *)
c2688 ( \PHASE_IN(0) , \4:PLL_160_IN  );
capacitor #(.c(7.033e-20)) (*
integer library_binding = "analogLib";

 *)
c2689 ( \PHASE_IN(0) , \3:XTAL25  );
capacitor #(.c(1.688e-17)) (*
integer library_binding = "analogLib";

 *)
c2690 ( \PHASE_IN(0) , \6:XTAL25  );
capacitor #(.c(1.487e-17)) (*
integer library_binding = "analogLib";

 *)
c2691 ( \PHASE_IN(0) , \5:WANDER_CNT(6)  );
capacitor #(.c(1.002e-18)) (*
integer library_binding = "analogLib";

 *)
c2692 ( \PHASE_IN(0) , \WANDER_CNT(6)  );
capacitor #(.c(4.407e-16)) (*
integer library_binding = "analogLib";

 *)
c2693 ( \PHASE_IN(0) , \3:TP_DISC_2p5  );
capacitor #(.c(1.266e-17)) (*
integer library_binding = "analogLib";

 *)
c2694 ( \PHASE_IN(0) , \5:AEQ_CNT_ANLG(1)  );
capacitor #(.c(1.375e-17)) (*
integer library_binding = "analogLib";

 *)
c2695 ( \PHASE_IN(0) , \4:WANDER_CNT(3)  );
capacitor #(.c(1.492e-17)) (*
integer library_binding = "analogLib";

 *)
c2696 ( \PHASE_IN(0) , \5:WANDER_CNT(4)  );
capacitor #(.c(1.709e-16)) (*
integer library_binding = "analogLib";

 *)
c2697 ( \PHASE_IN(0) , \WANDER_CNT(3)  );
capacitor #(.c(1.179e-17)) (*
integer library_binding = "analogLib";

 *)
c2698 ( \PHASE_IN(0) , \5:AEQ_CNT_ANLG(4)  );
capacitor #(.c(3.519e-17)) (*
integer library_binding = "analogLib";

 *)
c2699 ( \PHASE_IN(0) , \5:BASEFX_DIS  );
capacitor #(.c(1.013e-17)) (*
integer library_binding = "analogLib";

 *)
c2700 ( \PHASE_IN(0) , \5:PHASE_IN(7)  );
capacitor #(.c(1.774e-16)) (*
integer library_binding = "analogLib";

 *)
c2701 ( \PHASE_IN(0) , \6:AEQ_BYPASS  );
capacitor #(.c(1.215e-17)) (*
integer library_binding = "analogLib";

 *)
c2702 ( \PHASE_IN(0) , \2:PHASE_IN(5)  );
capacitor #(.c(2.155e-17)) (*
integer library_binding = "analogLib";

 *)
c2703 ( \PHASE_IN(0) , \4:PHASE_IN(2)  );
capacitor #(.c(1.141e-15)) (*
integer library_binding = "analogLib";

 *)
c2704 ( \PHASE_IN(0) , \2:PHASE_IN(1)  );
capacitor #(.c(7.559e-15)) (*
integer library_binding = "analogLib";

 *)
c2705 ( \PHASE_IN(0) , GND );
capacitor #(.c(1.157e-17)) (*
integer library_binding = "analogLib";

 *)
c2706 ( \PHASE_IN(0) , \4:PHASE_IN(10)  );
capacitor #(.c(1.92e-17)) (*
integer library_binding = "analogLib";

 *)
c2707 ( \PHASE_IN(0) , \4:PHASE_IN(9)  );
capacitor #(.c(6.846e-16)) (*
integer library_binding = "analogLib";

 *)
c2708 ( \2:PHASE_IN(0) , \4:GND  );
capacitor #(.c(1.212e-18)) (*
integer library_binding = "analogLib";

 *)
c2709 ( \2:PHASE_IN(0) , \5:TENBT_FILTER_1p0(3)  );
capacitor #(.c(1.373e-17)) (*
integer library_binding = "analogLib";

 *)
c2710 ( \2:PHASE_IN(0) , \TENBT_FILTER_1p0(3)  );
capacitor #(.c(1.369e-17)) (*
integer library_binding = "analogLib";

 *)
c2711 ( \2:PHASE_IN(0) , \6:TENBT_FILTER_1p0(4)  );
capacitor #(.c(1.407e-17)) (*
integer library_binding = "analogLib";

 *)
c2712 ( \2:PHASE_IN(0) , RESET_10BT );
capacitor #(.c(2.329e-18)) (*
integer library_binding = "analogLib";

 *)
c2713 ( \2:PHASE_IN(0) , \TENBT_FILTER_1p0(2)  );
capacitor #(.c(1.261e-17)) (*
integer library_binding = "analogLib";

 *)
c2714 ( \2:PHASE_IN(0) , \6:TENBT_FILTER_1p0(2)  );
capacitor #(.c(1.375e-17)) (*
integer library_binding = "analogLib";

 *)
c2715 ( \2:PHASE_IN(0) , \TENBT_FILTER_1p0(1)  );
capacitor #(.c(1.193e-18)) (*
integer library_binding = "analogLib";

 *)
c2716 ( \2:PHASE_IN(0) , \5:TENBT_FILTER_1p0(1)  );
capacitor #(.c(1.51e-18)) (*
integer library_binding = "analogLib";

 *)
c2717 ( \2:PHASE_IN(0) , \6:PHASE_IN(10)  );
capacitor #(.c(1.656e-18)) (*
integer library_binding = "analogLib";

 *)
c2718 ( \2:PHASE_IN(0) , \TENBT_FILTER_1p0(0)  );
capacitor #(.c(1.329e-17)) (*
integer library_binding = "analogLib";

 *)
c2719 ( \2:PHASE_IN(0) , \6:TENBT_FILTER_1p0(0)  );
capacitor #(.c(2.518e-18)) (*
integer library_binding = "analogLib";

 *)
c2720 ( \2:PHASE_IN(0) , TENBT_CLK160_1p0 );
capacitor #(.c(1.369e-17)) (*
integer library_binding = "analogLib";

 *)
c2721 ( \2:PHASE_IN(0) , \6:TENBT_CLK160_1p0  );
capacitor #(.c(2.137e-18)) (*
integer library_binding = "analogLib";

 *)
c2722 ( \2:PHASE_IN(0) , \5:RESET_10BT  );
capacitor #(.c(2.524e-18)) (*
integer library_binding = "analogLib";

 *)
c2723 ( \2:PHASE_IN(0) , \TENBT_FILTER_1p0(4)  );
capacitor #(.c(1.684e-17)) (*
integer library_binding = "analogLib";

 *)
c2724 ( \2:PHASE_IN(0) , \3:XTAL25  );
capacitor #(.c(1.849e-17)) (*
integer library_binding = "analogLib";

 *)
c2725 ( \2:PHASE_IN(0) , \2:PHASE_IN(9)  );
capacitor #(.c(1.741e-17)) (*
integer library_binding = "analogLib";

 *)
c2726 ( \2:PHASE_IN(0) , \2:PHASE_IN(3)  );
capacitor #(.c(1.82e-16)) (*
integer library_binding = "analogLib";

 *)
c2727 ( \2:PHASE_IN(0) , \26:GND  );
capacitor #(.c(1.515e-17)) (*
integer library_binding = "analogLib";

 *)
c2728 ( \2:PHASE_IN(0) , \2:PHASE_IN(2)  );
capacitor #(.c(1.362e-17)) (*
integer library_binding = "analogLib";

 *)
c2729 ( \2:PHASE_IN(0) , \PHASE_IN(8)  );
capacitor #(.c(1.492e-17)) (*
integer library_binding = "analogLib";

 *)
c2730 ( \2:PHASE_IN(0) , \3:PHASE_IN(7)  );
capacitor #(.c(1.849e-17)) (*
integer library_binding = "analogLib";

 *)
c2731 ( \2:PHASE_IN(0) , \1:PLL_160_IN  );
capacitor #(.c(1.055e-14)) (*
integer library_binding = "analogLib";

 *)
c2732 ( \2:PHASE_IN(0) , GND );
capacitor #(.c(1.685e-17)) (*
integer library_binding = "analogLib";

 *)
c2733 ( \2:PHASE_IN(0) , \1:PHASE_IN(1)  );
capacitor #(.c(1.339e-17)) (*
integer library_binding = "analogLib";

 *)
c2734 ( \2:PHASE_IN(0) , \1:PHASE_IN(5)  );
capacitor #(.c(2.405e-16)) (*
integer library_binding = "analogLib";

 *)
c2735 ( \6:PHASE_IN(0) , \4:GND  );
capacitor #(.c(2.01e-17)) (*
integer library_binding = "analogLib";

 *)
c2736 ( \6:PHASE_IN(0) , \6:PHASE_IN(10)  );
capacitor #(.c(3.706e-15)) (*
integer library_binding = "analogLib";

 *)
c2737 ( \6:PHASE_IN(0) , GND );
capacitor #(.c(3.382e-17)) (*
integer library_binding = "analogLib";

 *)
c2738 ( \6:PHASE_IN(0) , \PHASE_IN(1)  );
capacitor #(.c(9.228e-17)) (*
integer library_binding = "analogLib";

 *)
c2739 ( \7:PHASE_IN(0) , \4:GND  );
capacitor #(.c(2.807e-18)) (*
integer library_binding = "analogLib";

 *)
c2740 ( \7:PHASE_IN(0) , \2:PHASE_IN(5)  );
capacitor #(.c(4.157e-18)) (*
integer library_binding = "analogLib";

 *)
c2741 ( \7:PHASE_IN(0) , \5:PHASE_IN(5)  );
capacitor #(.c(1.072e-17)) (*
integer library_binding = "analogLib";

 *)
c2742 ( \7:PHASE_IN(0) , \24:VDDTX  );
capacitor #(.c(5.628e-17)) (*
integer library_binding = "analogLib";

 *)
c2743 ( \7:PHASE_IN(0) , \25:VDDTX  );
capacitor #(.c(3.645e-16)) (*
integer library_binding = "analogLib";

 *)
c2744 ( \7:PHASE_IN(0) , \2:PHASE_IN(1)  );
capacitor #(.c(9.332e-17)) (*
integer library_binding = "analogLib";

 *)
c2745 ( \7:PHASE_IN(0) , \6:AEQ_BYPASS  );
capacitor #(.c(2.907e-18)) (*
integer library_binding = "analogLib";

 *)
c2746 ( \7:PHASE_IN(0) , \4:PHASE_IN(9)  );
capacitor #(.c(4.929e-18)) (*
integer library_binding = "analogLib";

 *)
c2747 ( \7:PHASE_IN(0) , \7:PHASE_IN(9)  );
capacitor #(.c(1.139e-17)) (*
integer library_binding = "analogLib";

 *)
c2748 ( \7:PHASE_IN(0) , \PHASE_IN(2)  );
capacitor #(.c(8.534e-18)) (*
integer library_binding = "analogLib";

 *)
c2749 ( \7:PHASE_IN(0) , \4:PHASE_IN(2)  );
capacitor #(.c(2.56e-18)) (*
integer library_binding = "analogLib";

 *)
c2750 ( \7:PHASE_IN(0) , \4:PHASE_IN(8)  );
capacitor #(.c(4.012e-18)) (*
integer library_binding = "analogLib";

 *)
c2751 ( \7:PHASE_IN(0) , \7:PHASE_IN(8)  );
capacitor #(.c(2.652e-18)) (*
integer library_binding = "analogLib";

 *)
c2752 ( \7:PHASE_IN(0) , \4:PHASE_IN(3)  );
capacitor #(.c(5.516e-18)) (*
integer library_binding = "analogLib";

 *)
c2753 ( \7:PHASE_IN(0) , \7:PHASE_IN(3)  );
capacitor #(.c(2.024e-18)) (*
integer library_binding = "analogLib";

 *)
c2754 ( \7:PHASE_IN(0) , \5:PHASE_IN(7)  );
capacitor #(.c(9.845e-18)) (*
integer library_binding = "analogLib";

 *)
c2755 ( \7:PHASE_IN(0) , \7:PHASE_IN(7)  );
capacitor #(.c(6.192e-16)) (*
integer library_binding = "analogLib";

 *)
c2756 ( \7:PHASE_IN(0) , \5:PHASE_IN(1)  );
capacitor #(.c(1.466e-15)) (*
integer library_binding = "analogLib";

 *)
c2757 ( \7:PHASE_IN(0) , GND );
capacitor #(.c(9.787e-17)) (*
integer library_binding = "analogLib";

 *)
c2758 ( ADC_TEST_2p5, \4:GND  );
capacitor #(.c(3.903e-16)) (*
integer library_binding = "analogLib";

 *)
c2759 ( ADC_TEST_2p5, \WANDER_CNT(4)  );
capacitor #(.c(1.759e-17)) (*
integer library_binding = "analogLib";

 *)
c2760 ( ADC_TEST_2p5, \4:PHASE_250(8)  );
capacitor #(.c(1.544e-17)) (*
integer library_binding = "analogLib";

 *)
c2761 ( ADC_TEST_2p5, \PHASE_250(8)  );
capacitor #(.c(3.572e-16)) (*
integer library_binding = "analogLib";

 *)
c2762 ( ADC_TEST_2p5, MR_SQUELCH_DISB_2p5 );
capacitor #(.c(3.601e-18)) (*
integer library_binding = "analogLib";

 *)
c2763 ( ADC_TEST_2p5, TIMING_DN_ANLG );
capacitor #(.c(2.216e-18)) (*
integer library_binding = "analogLib";

 *)
c2764 ( ADC_TEST_2p5, \5:TIMING_DN_ANLG  );
capacitor #(.c(3.24e-19)) (*
integer library_binding = "analogLib";

 *)
c2765 ( ADC_TEST_2p5, AEQ_BYPASS );
capacitor #(.c(2.03e-18)) (*
integer library_binding = "analogLib";

 *)
c2766 ( ADC_TEST_2p5, \5:ADC_DIS_2p5  );
capacitor #(.c(8.611e-18)) (*
integer library_binding = "analogLib";

 *)
c2767 ( ADC_TEST_2p5, \6:RX10_PRESENT_2p5  );
capacitor #(.c(4.462e-18)) (*
integer library_binding = "analogLib";

 *)
c2768 ( ADC_TEST_2p5, \1:PLL_160_IN  );
capacitor #(.c(7.031e-16)) (*
integer library_binding = "analogLib";

 *)
c2769 ( ADC_TEST_2p5, \4:PLL_160_IN  );
capacitor #(.c(5.428e-18)) (*
integer library_binding = "analogLib";

 *)
c2770 ( ADC_TEST_2p5, \3:XTAL25  );
capacitor #(.c(1.303e-15)) (*
integer library_binding = "analogLib";

 *)
c2771 ( ADC_TEST_2p5, \6:XTAL25  );
capacitor #(.c(1.993e-18)) (*
integer library_binding = "analogLib";

 *)
c2772 ( ADC_TEST_2p5, TIMING_UP_ANLG );
capacitor #(.c(3.209e-18)) (*
integer library_binding = "analogLib";

 *)
c2773 ( ADC_TEST_2p5, \6:TIMING_UP_ANLG  );
capacitor #(.c(2.128e-16)) (*
integer library_binding = "analogLib";

 *)
c2774 ( ADC_TEST_2p5, \3:MR_SQUELCH_DISB_2p5  );
capacitor #(.c(2.999e-19)) (*
integer library_binding = "analogLib";

 *)
c2775 ( ADC_TEST_2p5, \4:AEQ_CNT_ANLG(0)  );
capacitor #(.c(2.999e-19)) (*
integer library_binding = "analogLib";

 *)
c2776 ( ADC_TEST_2p5, \AEQ_CNT_ANLG(1)  );
capacitor #(.c(6.868e-18)) (*
integer library_binding = "analogLib";

 *)
c2777 ( ADC_TEST_2p5, \6:X10_DIS_2p5  );
capacitor #(.c(2.397e-18)) (*
integer library_binding = "analogLib";

 *)
c2778 ( ADC_TEST_2p5, RX10_PRESENT_2p5 );
capacitor #(.c(2.646e-19)) (*
integer library_binding = "analogLib";

 *)
c2779 ( ADC_TEST_2p5, T2_MODE );
capacitor #(.c(2.646e-19)) (*
integer library_binding = "analogLib";

 *)
c2780 ( ADC_TEST_2p5, \AEQ_CNT_ANLG(4)  );
capacitor #(.c(5.144e-19)) (*
integer library_binding = "analogLib";

 *)
c2781 ( ADC_TEST_2p5, \8:TX100_DIS_2p5  );
capacitor #(.c(1.02e-17)) (*
integer library_binding = "analogLib";

 *)
c2782 ( ADC_TEST_2p5, \4:MLT3_TDATA_2p5(1)  );
capacitor #(.c(2.37e-17)) (*
integer library_binding = "analogLib";

 *)
c2783 ( ADC_TEST_2p5, \6:AEQ_DIS_2p5  );
capacitor #(.c(1.377e-17)) (*
integer library_binding = "analogLib";

 *)
c2784 ( ADC_TEST_2p5, BLW_DIS_2p5 );
capacitor #(.c(1.685e-17)) (*
integer library_binding = "analogLib";

 *)
c2785 ( ADC_TEST_2p5, TP_DISC_2p5 );
capacitor #(.c(2.548e-17)) (*
integer library_binding = "analogLib";

 *)
c2786 ( ADC_TEST_2p5, ADC_DIS_2p5 );
capacitor #(.c(2.404e-18)) (*
integer library_binding = "analogLib";

 *)
c2787 ( ADC_TEST_2p5, AEQ_DIS_2p5 );
capacitor #(.c(3.886e-15)) (*
integer library_binding = "analogLib";

 *)
c2788 ( ADC_TEST_2p5, \5:WANDER_CNT(4)  );
capacitor #(.c(2.84e-17)) (*
integer library_binding = "analogLib";

 *)
c2789 ( ADC_TEST_2p5, \2:PHASE_IN(5)  );
capacitor #(.c(1.323e-17)) (*
integer library_binding = "analogLib";

 *)
c2790 ( ADC_TEST_2p5, \4:PHASE_IN(2)  );
capacitor #(.c(2.193e-17)) (*
integer library_binding = "analogLib";

 *)
c2791 ( ADC_TEST_2p5, \4:PHASE_IN(9)  );
capacitor #(.c(1.071e-17)) (*
integer library_binding = "analogLib";

 *)
c2792 ( ADC_TEST_2p5, \5:PHASE_IN(7)  );
capacitor #(.c(2.7e-16)) (*
integer library_binding = "analogLib";

 *)
c2793 ( ADC_TEST_2p5, \3:X10_DIS_2p5  );
capacitor #(.c(1.338e-17)) (*
integer library_binding = "analogLib";

 *)
c2794 ( ADC_TEST_2p5, RESET_DSP );
capacitor #(.c(2.537e-17)) (*
integer library_binding = "analogLib";

 *)
c2795 ( ADC_TEST_2p5, \4:PHASE_IN(8)  );
capacitor #(.c(1.193e-17)) (*
integer library_binding = "analogLib";

 *)
c2796 ( ADC_TEST_2p5, \2:I_REXT_50(0)  );
capacitor #(.c(1.846e-17)) (*
integer library_binding = "analogLib";

 *)
c2797 ( ADC_TEST_2p5, \4:PHASE_IN(3)  );
capacitor #(.c(1.554e-15)) (*
integer library_binding = "analogLib";

 *)
c2798 ( ADC_TEST_2p5, GND );
capacitor #(.c(9.716e-17)) (*
integer library_binding = "analogLib";

 *)
c2799 ( \5:ADC_TEST_2p5 , \4:GND  );
capacitor #(.c(3.063e-15)) (*
integer library_binding = "analogLib";

 *)
c2800 ( \5:ADC_TEST_2p5 , \WANDER_CNT(4)  );
capacitor #(.c(1.08e-19)) (*
integer library_binding = "analogLib";

 *)
c2801 ( \5:ADC_TEST_2p5 , \4:PHASE_250(8)  );
capacitor #(.c(9.478e-20)) (*
integer library_binding = "analogLib";

 *)
c2802 ( \5:ADC_TEST_2p5 , \PHASE_250(8)  );
capacitor #(.c(3.419e-16)) (*
integer library_binding = "analogLib";

 *)
c2803 ( \5:ADC_TEST_2p5 , \6:X10_DIS_2p5  );
capacitor #(.c(6.49e-19)) (*
integer library_binding = "analogLib";

 *)
c2804 ( \5:ADC_TEST_2p5 , \2:TX100_DIS_2p5  );
capacitor #(.c(1.343e-19)) (*
integer library_binding = "analogLib";

 *)
c2805 ( \5:ADC_TEST_2p5 , \4:MLT3_TDATA_2p5(1)  );
capacitor #(.c(1.93e-18)) (*
integer library_binding = "analogLib";

 *)
c2806 ( \5:ADC_TEST_2p5 , \6:AEQ_DIS_2p5  );
capacitor #(.c(1.813e-19)) (*
integer library_binding = "analogLib";

 *)
c2807 ( \5:ADC_TEST_2p5 , BLW_DIS_2p5 );
capacitor #(.c(2.219e-19)) (*
integer library_binding = "analogLib";

 *)
c2808 ( \5:ADC_TEST_2p5 , TP_DISC_2p5 );
capacitor #(.c(2.348e-18)) (*
integer library_binding = "analogLib";

 *)
c2809 ( \5:ADC_TEST_2p5 , ADC_DIS_2p5 );
capacitor #(.c(3.252e-18)) (*
integer library_binding = "analogLib";

 *)
c2810 ( \5:ADC_TEST_2p5 , \4:PHASE_IN(3)  );
capacitor #(.c(2.102e-18)) (*
integer library_binding = "analogLib";

 *)
c2811 ( \5:ADC_TEST_2p5 , \2:I_REXT_50(0)  );
capacitor #(.c(4.468e-18)) (*
integer library_binding = "analogLib";

 *)
c2812 ( \5:ADC_TEST_2p5 , \4:PHASE_IN(8)  );
capacitor #(.c(2.357e-18)) (*
integer library_binding = "analogLib";

 *)
c2813 ( \5:ADC_TEST_2p5 , RESET_DSP );
capacitor #(.c(1.887e-18)) (*
integer library_binding = "analogLib";

 *)
c2814 ( \5:ADC_TEST_2p5 , \5:PHASE_IN(7)  );
capacitor #(.c(3.862e-18)) (*
integer library_binding = "analogLib";

 *)
c2815 ( \5:ADC_TEST_2p5 , \4:PHASE_IN(9)  );
capacitor #(.c(2.33e-18)) (*
integer library_binding = "analogLib";

 *)
c2816 ( \5:ADC_TEST_2p5 , \4:PHASE_IN(2)  );
capacitor #(.c(5.001e-18)) (*
integer library_binding = "analogLib";

 *)
c2817 ( \5:ADC_TEST_2p5 , \2:PHASE_IN(5)  );
capacitor #(.c(4.234e-19)) (*
integer library_binding = "analogLib";

 *)
c2818 ( \5:ADC_TEST_2p5 , AEQ_DIS_2p5 );
capacitor #(.c(2.453e-15)) (*
integer library_binding = "analogLib";

 *)
c2819 ( \5:ADC_TEST_2p5 , \5:WANDER_CNT(4)  );
capacitor #(.c(1.253e-17)) (*
integer library_binding = "analogLib";

 *)
c2820 ( \5:ADC_TEST_2p5 , \AEQ_CNT_ANLG(4)  );
capacitor #(.c(1.253e-17)) (*
integer library_binding = "analogLib";

 *)
c2821 ( \5:ADC_TEST_2p5 , T2_MODE );
capacitor #(.c(1.458e-17)) (*
integer library_binding = "analogLib";

 *)
c2822 ( \5:ADC_TEST_2p5 , RX10_PRESENT_2p5 );
capacitor #(.c(1.421e-17)) (*
integer library_binding = "analogLib";

 *)
c2823 ( \5:ADC_TEST_2p5 , \AEQ_CNT_ANLG(1)  );
capacitor #(.c(1.421e-17)) (*
integer library_binding = "analogLib";

 *)
c2824 ( \5:ADC_TEST_2p5 , \4:AEQ_CNT_ANLG(0)  );
capacitor #(.c(1.309e-16)) (*
integer library_binding = "analogLib";

 *)
c2825 ( \5:ADC_TEST_2p5 , \3:X10_DIS_2p5  );
capacitor #(.c(7.556e-16)) (*
integer library_binding = "analogLib";

 *)
c2826 ( \5:ADC_TEST_2p5 , \3:MR_SQUELCH_DISB_2p5  );
capacitor #(.c(5.652e-19)) (*
integer library_binding = "analogLib";

 *)
c2827 ( \5:ADC_TEST_2p5 , \6:TIMING_UP_ANLG  );
capacitor #(.c(3.511e-19)) (*
integer library_binding = "analogLib";

 *)
c2828 ( \5:ADC_TEST_2p5 , TIMING_UP_ANLG );
capacitor #(.c(1.104e-16)) (*
integer library_binding = "analogLib";

 *)
c2829 ( \5:ADC_TEST_2p5 , \6:XTAL25  );
capacitor #(.c(4.599e-19)) (*
integer library_binding = "analogLib";

 *)
c2830 ( \5:ADC_TEST_2p5 , \3:XTAL25  );
capacitor #(.c(1.051e-16)) (*
integer library_binding = "analogLib";

 *)
c2831 ( \5:ADC_TEST_2p5 , \4:PLL_160_IN  );
capacitor #(.c(6.673e-19)) (*
integer library_binding = "analogLib";

 *)
c2832 ( \5:ADC_TEST_2p5 , \1:PLL_160_IN  );
capacitor #(.c(1.517e-18)) (*
integer library_binding = "analogLib";

 *)
c2833 ( \5:ADC_TEST_2p5 , \6:RX10_PRESENT_2p5  );
capacitor #(.c(1.071e-17)) (*
integer library_binding = "analogLib";

 *)
c2834 ( \5:ADC_TEST_2p5 , \5:ADC_DIS_2p5  );
capacitor #(.c(1.535e-17)) (*
integer library_binding = "analogLib";

 *)
c2835 ( \5:ADC_TEST_2p5 , AEQ_BYPASS );
capacitor #(.c(3.11e-19)) (*
integer library_binding = "analogLib";

 *)
c2836 ( \5:ADC_TEST_2p5 , \6:AEQ_BYPASS  );
capacitor #(.c(3.903e-19)) (*
integer library_binding = "analogLib";

 *)
c2837 ( \5:ADC_TEST_2p5 , \5:TIMING_DN_ANLG  );
capacitor #(.c(6.343e-19)) (*
integer library_binding = "analogLib";

 *)
c2838 ( \5:ADC_TEST_2p5 , TIMING_DN_ANLG );
capacitor #(.c(1.094e-16)) (*
integer library_binding = "analogLib";

 *)
c2839 ( \5:ADC_TEST_2p5 , MR_SQUELCH_DISB_2p5 );
capacitor #(.c(1.502e-15)) (*
integer library_binding = "analogLib";

 *)
c2840 ( \5:ADC_TEST_2p5 , GND );
capacitor #(.c(7.547e-17)) (*
integer library_binding = "analogLib";

 *)
c2841 ( \5:ADC_TEST_2p5 , \8:TX100_DIS_2p5  );
capacitor #(.c(3.6e-15)) (*
integer library_binding = "analogLib";

 *)
c2842 ( I_RPOLY_REF100, \4:GND  );
capacitor #(.c(1.619e-17)) (*
integer library_binding = "analogLib";

 *)
c2843 ( I_RPOLY_REF100, \MLT3_TDATA_2p5(1)  );
capacitor #(.c(1.216e-18)) (*
integer library_binding = "analogLib";

 *)
c2844 ( I_RPOLY_REF100, \4:MLT3_TDATA_2p5(1)  );
capacitor #(.c(1.23e-18)) (*
integer library_binding = "analogLib";

 *)
c2845 ( I_RPOLY_REF100, \5:TENBT_FILTER_1p0(3)  );
capacitor #(.c(1.394e-17)) (*
integer library_binding = "analogLib";

 *)
c2846 ( I_RPOLY_REF100, \TENBT_FILTER_1p0(3)  );
capacitor #(.c(1.47e-17)) (*
integer library_binding = "analogLib";

 *)
c2847 ( I_RPOLY_REF100, \6:TENBT_FILTER_1p0(4)  );
capacitor #(.c(1.511e-17)) (*
integer library_binding = "analogLib";

 *)
c2848 ( I_RPOLY_REF100, RESET_10BT );
capacitor #(.c(1.482e-18)) (*
integer library_binding = "analogLib";

 *)
c2849 ( I_RPOLY_REF100, TP_DISC_2p5 );
capacitor #(.c(2.365e-18)) (*
integer library_binding = "analogLib";

 *)
c2850 ( I_RPOLY_REF100, \TENBT_FILTER_1p0(2)  );
capacitor #(.c(1.281e-17)) (*
integer library_binding = "analogLib";

 *)
c2851 ( I_RPOLY_REF100, \6:TENBT_FILTER_1p0(2)  );
capacitor #(.c(1.396e-17)) (*
integer library_binding = "analogLib";

 *)
c2852 ( I_RPOLY_REF100, \TENBT_FILTER_1p0(1)  );
capacitor #(.c(1.211e-18)) (*
integer library_binding = "analogLib";

 *)
c2853 ( I_RPOLY_REF100, \5:TENBT_FILTER_1p0(1)  );
capacitor #(.c(1.593e-17)) (*
integer library_binding = "analogLib";

 *)
c2854 ( I_RPOLY_REF100, \3:TP_DISC_2p5  );
capacitor #(.c(1.681e-18)) (*
integer library_binding = "analogLib";

 *)
c2855 ( I_RPOLY_REF100, \TENBT_FILTER_1p0(0)  );
capacitor #(.c(1.349e-17)) (*
integer library_binding = "analogLib";

 *)
c2856 ( I_RPOLY_REF100, \6:TENBT_FILTER_1p0(0)  );
capacitor #(.c(2.705e-18)) (*
integer library_binding = "analogLib";

 *)
c2857 ( I_RPOLY_REF100, TENBT_CLK160_1p0 );
capacitor #(.c(1.47e-17)) (*
integer library_binding = "analogLib";

 *)
c2858 ( I_RPOLY_REF100, \6:TENBT_CLK160_1p0  );
capacitor #(.c(2.295e-18)) (*
integer library_binding = "analogLib";

 *)
c2859 ( I_RPOLY_REF100, \5:RESET_10BT  );
capacitor #(.c(2.711e-18)) (*
integer library_binding = "analogLib";

 *)
c2860 ( I_RPOLY_REF100, \TENBT_FILTER_1p0(4)  );
capacitor #(.c(6.739e-17)) (*
integer library_binding = "analogLib";

 *)
c2861 ( I_RPOLY_REF100, \26:GND  );
capacitor #(.c(5.548e-14)) (*
integer library_binding = "analogLib";

 *)
c2862 ( I_RPOLY_REF100, GND );
capacitor #(.c(1.025e-15)) (*
integer library_binding = "analogLib";

 *)
c2863 ( \11:I_RPOLY_REF100 , \4:GND  );
capacitor #(.c(1.58e-14)) (*
integer library_binding = "analogLib";

 *)
c2864 ( \11:I_RPOLY_REF100 , GND );
capacitor #(.c(1.329e-15)) (*
integer library_binding = "analogLib";

 *)
c2865 ( \4:I_RPOLY_REF100 , \4:GND  );
capacitor #(.c(9.213e-18)) (*
integer library_binding = "analogLib";

 *)
c2866 ( \4:I_RPOLY_REF100 , \PHASE_250(2)  );
capacitor #(.c(6.705e-18)) (*
integer library_binding = "analogLib";

 *)
c2867 ( \4:I_RPOLY_REF100 , \4:PHASE_250(2)  );
capacitor #(.c(8.478e-18)) (*
integer library_binding = "analogLib";

 *)
c2868 ( \4:I_RPOLY_REF100 , \4:PHASE_250(8)  );
capacitor #(.c(7.44e-18)) (*
integer library_binding = "analogLib";

 *)
c2869 ( \4:I_RPOLY_REF100 , \PHASE_250(8)  );
capacitor #(.c(1.009e-17)) (*
integer library_binding = "analogLib";

 *)
c2870 ( \4:I_RPOLY_REF100 , \5:GND  );
capacitor #(.c(1.009e-17)) (*
integer library_binding = "analogLib";

 *)
c2871 ( \4:I_RPOLY_REF100 , \6:GNDRX  );
capacitor #(.c(1.411e-18)) (*
integer library_binding = "analogLib";

 *)
c2872 ( \4:I_RPOLY_REF100 , \ADC_1p0(5)  );
capacitor #(.c(9.404e-19)) (*
integer library_binding = "analogLib";

 *)
c2873 ( \4:I_RPOLY_REF100 , \3:ADC_1p0(4)  );
capacitor #(.c(1.034e-18)) (*
integer library_binding = "analogLib";

 *)
c2874 ( \4:I_RPOLY_REF100 , \4:RCLK125_1p0  );
capacitor #(.c(1.152e-18)) (*
integer library_binding = "analogLib";

 *)
c2875 ( \4:I_RPOLY_REF100 , \ADC_1p0(0)  );
capacitor #(.c(9.404e-19)) (*
integer library_binding = "analogLib";

 *)
c2876 ( \4:I_RPOLY_REF100 , \4:I_RPOLY_100(5)  );
capacitor #(.c(1.233e-18)) (*
integer library_binding = "analogLib";

 *)
c2877 ( \4:I_RPOLY_REF100 , \4:FLASH_1p0(0)  );
capacitor #(.c(9.404e-19)) (*
integer library_binding = "analogLib";

 *)
c2878 ( \4:I_RPOLY_REF100 , \3:ADC_1p0(3)  );
capacitor #(.c(1.622e-16)) (*
integer library_binding = "analogLib";

 *)
c2879 ( \4:I_RPOLY_REF100 , \3:PHASE_250(1)  );
capacitor #(.c(2.968e-18)) (*
integer library_binding = "analogLib";

 *)
c2880 ( \4:I_RPOLY_REF100 , \9:TX100_DIS_2p5  );
capacitor #(.c(1.146e-17)) (*
integer library_binding = "analogLib";

 *)
c2881 ( \4:I_RPOLY_REF100 , \2:TX100_DIS_2p5  );
capacitor #(.c(3.724e-16)) (*
integer library_binding = "analogLib";

 *)
c2882 ( \4:I_RPOLY_REF100 , \PHASE_250(1)  );
capacitor #(.c(2.23e-17)) (*
integer library_binding = "analogLib";

 *)
c2883 ( \4:I_RPOLY_REF100 , \5:ADC_DIS_2p5  );
capacitor #(.c(7.146e-17)) (*
integer library_binding = "analogLib";

 *)
c2884 ( \4:I_RPOLY_REF100 , \24:VDDTX  );
capacitor #(.c(3.752e-16)) (*
integer library_binding = "analogLib";

 *)
c2885 ( \4:I_RPOLY_REF100 , \25:VDDTX  );
capacitor #(.c(5.638e-19)) (*
integer library_binding = "analogLib";

 *)
c2886 ( \4:I_RPOLY_REF100 , RX10_PRESENT_2p5 );
capacitor #(.c(1.777e-17)) (*
integer library_binding = "analogLib";

 *)
c2887 ( \4:I_RPOLY_REF100 , \PHASE_250(6)  );
capacitor #(.c(1.598e-17)) (*
integer library_binding = "analogLib";

 *)
c2888 ( \4:I_RPOLY_REF100 , \4:PHASE_250(6)  );
capacitor #(.c(1.025e-17)) (*
integer library_binding = "analogLib";

 *)
c2889 ( \4:I_RPOLY_REF100 , POS_DETECT_2p5 );
capacitor #(.c(7.16e-18)) (*
integer library_binding = "analogLib";

 *)
c2890 ( \4:I_RPOLY_REF100 , \5:POS_DETECT_2p5  );
capacitor #(.c(4.369e-19)) (*
integer library_binding = "analogLib";

 *)
c2891 ( \4:I_RPOLY_REF100 , \MR_SQUELCH_RANGE_2p5(0)  );
capacitor #(.c(2.14e-16)) (*
integer library_binding = "analogLib";

 *)
c2892 ( \4:I_RPOLY_REF100 , ADC_DIS_2p5 );
capacitor #(.c(1.548e-17)) (*
integer library_binding = "analogLib";

 *)
c2893 ( \4:I_RPOLY_REF100 , \4:MR_SQUELCH_RANGE_2p5(0)  );
capacitor #(.c(4.726e-18)) (*
integer library_binding = "analogLib";

 *)
c2894 ( \4:I_RPOLY_REF100 , \4:RCLK125_TST  );
capacitor #(.c(8.955e-18)) (*
integer library_binding = "analogLib";

 *)
c2895 ( \4:I_RPOLY_REF100 , RCLK125_TST );
capacitor #(.c(5.992e-18)) (*
integer library_binding = "analogLib";

 *)
c2896 ( \4:I_RPOLY_REF100 , \PHASE_250(5)  );
capacitor #(.c(8.318e-18)) (*
integer library_binding = "analogLib";

 *)
c2897 ( \4:I_RPOLY_REF100 , \4:PHASE_250(10)  );
capacitor #(.c(7.6e-18)) (*
integer library_binding = "analogLib";

 *)
c2898 ( \4:I_RPOLY_REF100 , \PHASE_250(10)  );
capacitor #(.c(3.231e-17)) (*
integer library_binding = "analogLib";

 *)
c2899 ( \4:I_RPOLY_REF100 , \4:PHASE_250(5)  );
capacitor #(.c(1.32e-15)) (*
integer library_binding = "analogLib";

 *)
c2900 ( \4:I_RPOLY_REF100 , \MR_SQUELCH_RANGE_2p5(1)  );
capacitor #(.c(1.702e-17)) (*
integer library_binding = "analogLib";

 *)
c2901 ( \4:I_RPOLY_REF100 , \4:PHASE_250(4)  );
capacitor #(.c(2.032e-17)) (*
integer library_binding = "analogLib";

 *)
c2902 ( \4:I_RPOLY_REF100 , \PHASE_250(4)  );
capacitor #(.c(2.321e-16)) (*
integer library_binding = "analogLib";

 *)
c2903 ( \4:I_RPOLY_REF100 , \3:MR_SQUELCH_RANGE_2p5(1)  );
capacitor #(.c(1.535e-17)) (*
integer library_binding = "analogLib";

 *)
c2904 ( \4:I_RPOLY_REF100 , \6:RX10_PRESENT_2p5  );
capacitor #(.c(4.031e-18)) (*
integer library_binding = "analogLib";

 *)
c2905 ( \4:I_RPOLY_REF100 , \PHASE_250(3)  );
capacitor #(.c(2.815e-17)) (*
integer library_binding = "analogLib";

 *)
c2906 ( \4:I_RPOLY_REF100 , \4:PHASE_250(3)  );
capacitor #(.c(1.174e-17)) (*
integer library_binding = "analogLib";

 *)
c2907 ( \4:I_RPOLY_REF100 , \5:TIMING_DN_ANLG  );
capacitor #(.c(1.741e-17)) (*
integer library_binding = "analogLib";

 *)
c2908 ( \4:I_RPOLY_REF100 , \7:X10_DIS_2p5  );
capacitor #(.c(1.592e-17)) (*
integer library_binding = "analogLib";

 *)
c2909 ( \4:I_RPOLY_REF100 , \6:AEQ_DIS_2p5  );
capacitor #(.c(2.291e-15)) (*
integer library_binding = "analogLib";

 *)
c2910 ( \4:I_RPOLY_REF100 , \2:I_REXT_50(0)  );
capacitor #(.c(1.741e-17)) (*
integer library_binding = "analogLib";

 *)
c2911 ( \4:I_RPOLY_REF100 , \PHASE_250(9)  );
capacitor #(.c(2.052e-14)) (*
integer library_binding = "analogLib";

 *)
c2912 ( \4:I_RPOLY_REF100 , GND );
capacitor #(.c(1.592e-17)) (*
integer library_binding = "analogLib";

 *)
c2913 ( \4:I_RPOLY_REF100 , MR_SQUELCH_DISB_2p5 );
capacitor #(.c(2.518e-15)) (*
integer library_binding = "analogLib";

 *)
c2914 ( \4:I_RPOLY_REF100 , \I_REXT_50(0)  );
capacitor #(.c(1.592e-17)) (*
integer library_binding = "analogLib";

 *)
c2915 ( \4:I_RPOLY_REF100 , BLW_DIS_2p5 );
capacitor #(.c(1.427e-17)) (*
integer library_binding = "analogLib";

 *)
c2916 ( \4:I_RPOLY_REF100 , TIMING_UP_ANLG );
capacitor #(.c(1.368e-17)) (*
integer library_binding = "analogLib";

 *)
c2917 ( \4:I_RPOLY_REF100 , RESET_DSP );
capacitor #(.c(2.717e-17)) (*
integer library_binding = "analogLib";

 *)
c2918 ( \4:I_RPOLY_REF100 , \25:GND  );
capacitor #(.c(1.276e-16)) (*
integer library_binding = "analogLib";

 *)
c2919 ( \12:I_RPOLY_REF100 , \4:GND  );
capacitor #(.c(1.024e-16)) (*
integer library_binding = "analogLib";

 *)
c2920 ( \12:I_RPOLY_REF100 , \5:GND  );
capacitor #(.c(1.024e-16)) (*
integer library_binding = "analogLib";

 *)
c2921 ( \12:I_RPOLY_REF100 , \6:GNDRX  );
capacitor #(.c(1.431e-17)) (*
integer library_binding = "analogLib";

 *)
c2922 ( \12:I_RPOLY_REF100 , \ADC_1p0(5)  );
capacitor #(.c(9.54e-18)) (*
integer library_binding = "analogLib";

 *)
c2923 ( \12:I_RPOLY_REF100 , \3:ADC_1p0(4)  );
capacitor #(.c(1.049e-17)) (*
integer library_binding = "analogLib";

 *)
c2924 ( \12:I_RPOLY_REF100 , \4:RCLK125_1p0  );
capacitor #(.c(1.168e-17)) (*
integer library_binding = "analogLib";

 *)
c2925 ( \12:I_RPOLY_REF100 , \ADC_1p0(0)  );
capacitor #(.c(9.54e-18)) (*
integer library_binding = "analogLib";

 *)
c2926 ( \12:I_RPOLY_REF100 , \4:I_RPOLY_100(5)  );
capacitor #(.c(1.251e-17)) (*
integer library_binding = "analogLib";

 *)
c2927 ( \12:I_RPOLY_REF100 , \4:FLASH_1p0(0)  );
capacitor #(.c(9.54e-18)) (*
integer library_binding = "analogLib";

 *)
c2928 ( \12:I_RPOLY_REF100 , \3:ADC_1p0(3)  );
capacitor #(.c(2.081e-15)) (*
integer library_binding = "analogLib";

 *)
c2929 ( \12:I_RPOLY_REF100 , GND );
capacitor #(.c(5.19e-17)) (*
integer library_binding = "analogLib";

 *)
c2930 ( \TENBT_FILTER_1p0(4) , \4:GND  );
capacitor #(.c(8.29e-20)) (*
integer library_binding = "analogLib";

 *)
c2931 ( \TENBT_FILTER_1p0(4) , \5:TENBT_FILTER_1p0(3)  );
capacitor #(.c(1.099e-18)) (*
integer library_binding = "analogLib";

 *)
c2932 ( \TENBT_FILTER_1p0(4) , \TENBT_FILTER_1p0(3)  );
capacitor #(.c(6.357e-18)) (*
integer library_binding = "analogLib";

 *)
c2933 ( \TENBT_FILTER_1p0(4) , \1:PHASE_IN(1)  );
capacitor #(.c(1.35e-17)) (*
integer library_binding = "analogLib";

 *)
c2934 ( \TENBT_FILTER_1p0(4) , \1:PLL_160_IN  );
capacitor #(.c(4.172e-18)) (*
integer library_binding = "analogLib";

 *)
c2935 ( \TENBT_FILTER_1p0(4) , \1:PHASE_IN(5)  );
capacitor #(.c(2.88e-18)) (*
integer library_binding = "analogLib";

 *)
c2936 ( \TENBT_FILTER_1p0(4) , \2:PHASE_IN(9)  );
capacitor #(.c(3.19e-18)) (*
integer library_binding = "analogLib";

 *)
c2937 ( \TENBT_FILTER_1p0(4) , \3:PHASE_IN(7)  );
capacitor #(.c(5.828e-18)) (*
integer library_binding = "analogLib";

 *)
c2938 ( \TENBT_FILTER_1p0(4) , \PHASE_IN(8)  );
capacitor #(.c(1.947e-18)) (*
integer library_binding = "analogLib";

 *)
c2939 ( \TENBT_FILTER_1p0(4) , \2:PHASE_IN(2)  );
capacitor #(.c(1.775e-18)) (*
integer library_binding = "analogLib";

 *)
c2940 ( \TENBT_FILTER_1p0(4) , \3:XTAL25  );
capacitor #(.c(8.009e-16)) (*
integer library_binding = "analogLib";

 *)
c2941 ( \TENBT_FILTER_1p0(4) , GND );
capacitor #(.c(5.528e-16)) (*
integer library_binding = "analogLib";

 *)
c2942 ( \TENBT_FILTER_1p0(4) , \24:VDDTX  );
capacitor #(.c(5.322e-17)) (*
integer library_binding = "analogLib";

 *)
c2943 ( \6:TENBT_FILTER_1p0(4) , \4:GND  );
capacitor #(.c(6.872e-19)) (*
integer library_binding = "analogLib";

 *)
c2944 ( \6:TENBT_FILTER_1p0(4) , \5:TENBT_FILTER_1p0(3)  );
capacitor #(.c(5.055e-17)) (*
integer library_binding = "analogLib";

 *)
c2945 ( \6:TENBT_FILTER_1p0(4) , \1:PHASE_IN(1)  );
capacitor #(.c(3.463e-17)) (*
integer library_binding = "analogLib";

 *)
c2946 ( \6:TENBT_FILTER_1p0(4) , \PHASE_IN(8)  );
capacitor #(.c(7.876e-17)) (*
integer library_binding = "analogLib";

 *)
c2947 ( \6:TENBT_FILTER_1p0(4) , \1:PLL_160_IN  );
capacitor #(.c(1.459e-17)) (*
integer library_binding = "analogLib";

 *)
c2948 ( \6:TENBT_FILTER_1p0(4) , \2:PHASE_IN(2)  );
capacitor #(.c(1.729e-17)) (*
integer library_binding = "analogLib";

 *)
c2949 ( \6:TENBT_FILTER_1p0(4) , \3:PHASE_IN(7)  );
capacitor #(.c(1.561e-17)) (*
integer library_binding = "analogLib";

 *)
c2950 ( \6:TENBT_FILTER_1p0(4) , \2:PHASE_IN(9)  );
capacitor #(.c(2.262e-17)) (*
integer library_binding = "analogLib";

 *)
c2951 ( \6:TENBT_FILTER_1p0(4) , \1:PHASE_IN(5)  );
capacitor #(.c(1.201e-17)) (*
integer library_binding = "analogLib";

 *)
c2952 ( \6:TENBT_FILTER_1p0(4) , \TENBT_FILTER_1p0(3)  );
capacitor #(.c(8.389e-16)) (*
integer library_binding = "analogLib";

 *)
c2953 ( \6:TENBT_FILTER_1p0(4) , GND );
capacitor #(.c(2.409e-17)) (*
integer library_binding = "analogLib";

 *)
c2954 ( \6:TENBT_FILTER_1p0(4) , \3:XTAL25  );
capacitor #(.c(2.725e-15)) (*
integer library_binding = "analogLib";

 *)
c2955 ( TRISTATE, GND );
capacitor #(.c(3.651e-16)) (*
integer library_binding = "analogLib";

 *)
c2956 ( TRISTATE, \4:GND  );
capacitor #(.c(1.768e-16)) (*
integer library_binding = "analogLib";

 *)
c2957 ( \1:TRISTATE , \4:GND  );
capacitor #(.c(2.725e-15)) (*
integer library_binding = "analogLib";

 *)
c2958 ( \1:TRISTATE , GND );
capacitor #(.c(1.895e-16)) (*
integer library_binding = "analogLib";

 *)
c2959 ( \MR_SQUELCH_RANGE_2p5(0) , \4:GND  );
capacitor #(.c(2.394e-19)) (*
integer library_binding = "analogLib";

 *)
c2960 ( \MR_SQUELCH_RANGE_2p5(0) , \PHASE_250(2)  );
capacitor #(.c(1.743e-19)) (*
integer library_binding = "analogLib";

 *)
c2961 ( \MR_SQUELCH_RANGE_2p5(0) , \4:PHASE_250(2)  );
capacitor #(.c(6.448e-16)) (*
integer library_binding = "analogLib";

 *)
c2962 ( \MR_SQUELCH_RANGE_2p5(0) , \WANDER_CNT(4)  );
capacitor #(.c(2.371e-18)) (*
integer library_binding = "analogLib";

 *)
c2963 ( \MR_SQUELCH_RANGE_2p5(0) , \4:PHASE_250(8)  );
capacitor #(.c(2.081e-18)) (*
integer library_binding = "analogLib";

 *)
c2964 ( \MR_SQUELCH_RANGE_2p5(0) , \PHASE_250(8)  );
capacitor #(.c(6.175e-19)) (*
integer library_binding = "analogLib";

 *)
c2965 ( \MR_SQUELCH_RANGE_2p5(0) , \3:PHASE_250(1)  );
capacitor #(.c(3.892e-19)) (*
integer library_binding = "analogLib";

 *)
c2966 ( \MR_SQUELCH_RANGE_2p5(0) , \PHASE_250(1)  );
capacitor #(.c(1.375e-20)) (*
integer library_binding = "analogLib";

 *)
c2967 ( \MR_SQUELCH_RANGE_2p5(0) , \2:TX100_DIS_2p5  );
capacitor #(.c(3.752e-19)) (*
integer library_binding = "analogLib";

 *)
c2968 ( \MR_SQUELCH_RANGE_2p5(0) , \9:TX100_DIS_2p5  );
capacitor #(.c(1.03e-17)) (*
integer library_binding = "analogLib";

 *)
c2969 ( \MR_SQUELCH_RANGE_2p5(0) , RX10_PRESENT_2p5 );
capacitor #(.c(1.285e-19)) (*
integer library_binding = "analogLib";

 *)
c2970 ( \MR_SQUELCH_RANGE_2p5(0) , \PHASE_250(6)  );
capacitor #(.c(1.155e-19)) (*
integer library_binding = "analogLib";

 *)
c2971 ( \MR_SQUELCH_RANGE_2p5(0) , \4:PHASE_250(6)  );
capacitor #(.c(3.991e-18)) (*
integer library_binding = "analogLib";

 *)
c2972 ( \MR_SQUELCH_RANGE_2p5(0) , TIMING_UP_ANLG );
capacitor #(.c(3.825e-18)) (*
integer library_binding = "analogLib";

 *)
c2973 ( \MR_SQUELCH_RANGE_2p5(0) , RESET_DSP );
capacitor #(.c(3.283e-18)) (*
integer library_binding = "analogLib";

 *)
c2974 ( \MR_SQUELCH_RANGE_2p5(0) , \5:TIMING_DN_ANLG  );
capacitor #(.c(5.213e-17)) (*
integer library_binding = "analogLib";

 *)
c2975 ( \MR_SQUELCH_RANGE_2p5(0) , \6:RX10_PRESENT_2p5  );
capacitor #(.c(1.115e-18)) (*
integer library_binding = "analogLib";

 *)
c2976 ( \MR_SQUELCH_RANGE_2p5(0) , AEQ_DIS_2p5 );
capacitor #(.c(5.894e-16)) (*
integer library_binding = "analogLib";

 *)
c2977 ( \MR_SQUELCH_RANGE_2p5(0) , \MR_SQUELCH_RANGE_2p5(1)  );
capacitor #(.c(2.125e-18)) (*
integer library_binding = "analogLib";

 *)
c2978 ( \MR_SQUELCH_RANGE_2p5(0) , \PHASE_250(10)  );
capacitor #(.c(2.326e-18)) (*
integer library_binding = "analogLib";

 *)
c2979 ( \MR_SQUELCH_RANGE_2p5(0) , \4:PHASE_250(10)  );
capacitor #(.c(2.531e-18)) (*
integer library_binding = "analogLib";

 *)
c2980 ( \MR_SQUELCH_RANGE_2p5(0) , RCLK125_TST );
capacitor #(.c(1.723e-18)) (*
integer library_binding = "analogLib";

 *)
c2981 ( \MR_SQUELCH_RANGE_2p5(0) , \4:RCLK125_TST  );
capacitor #(.c(4.907e-18)) (*
integer library_binding = "analogLib";

 *)
c2982 ( \MR_SQUELCH_RANGE_2p5(0) , \6:AEQ_DIS_2p5  );
capacitor #(.c(9.213e-19)) (*
integer library_binding = "analogLib";

 *)
c2983 ( \MR_SQUELCH_RANGE_2p5(0) , \5:BLW_DIS_2p5  );
capacitor #(.c(3.928e-18)) (*
integer library_binding = "analogLib";

 *)
c2984 ( \MR_SQUELCH_RANGE_2p5(0) , \PHASE_250(5)  );
capacitor #(.c(2.992e-18)) (*
integer library_binding = "analogLib";

 *)
c2985 ( \MR_SQUELCH_RANGE_2p5(0) , \4:PHASE_250(5)  );
capacitor #(.c(1.856e-19)) (*
integer library_binding = "analogLib";

 *)
c2986 ( \MR_SQUELCH_RANGE_2p5(0) , \4:PHASE_250(4)  );
capacitor #(.c(2.216e-19)) (*
integer library_binding = "analogLib";

 *)
c2987 ( \MR_SQUELCH_RANGE_2p5(0) , \PHASE_250(4)  );
capacitor #(.c(4.84e-19)) (*
integer library_binding = "analogLib";

 *)
c2988 ( \MR_SQUELCH_RANGE_2p5(0) , \PHASE_250(3)  );
capacitor #(.c(2.87e-19)) (*
integer library_binding = "analogLib";

 *)
c2989 ( \MR_SQUELCH_RANGE_2p5(0) , \4:PHASE_250(3)  );
capacitor #(.c(7.419e-16)) (*
integer library_binding = "analogLib";

 *)
c2990 ( \MR_SQUELCH_RANGE_2p5(0) , MR_SQUELCH_DISB_2p5 );
capacitor #(.c(4.982e-19)) (*
integer library_binding = "analogLib";

 *)
c2991 ( \MR_SQUELCH_RANGE_2p5(0) , \2:I_REXT_50(0)  );
capacitor #(.c(2.351e-18)) (*
integer library_binding = "analogLib";

 *)
c2992 ( \MR_SQUELCH_RANGE_2p5(0) , BLW_DIS_2p5 );
capacitor #(.c(8.11e-16)) (*
integer library_binding = "analogLib";

 *)
c2993 ( \MR_SQUELCH_RANGE_2p5(0) , \5:WANDER_CNT(4)  );
capacitor #(.c(3.157e-15)) (*
integer library_binding = "analogLib";

 *)
c2994 ( \MR_SQUELCH_RANGE_2p5(0) , \3:MR_SQUELCH_RANGE_2p5(1)  );
capacitor #(.c(3.345e-15)) (*
integer library_binding = "analogLib";

 *)
c2995 ( \MR_SQUELCH_RANGE_2p5(0) , \3:MR_SQUELCH_DISB_2p5  );
capacitor #(.c(2.931e-15)) (*
integer library_binding = "analogLib";

 *)
c2996 ( \MR_SQUELCH_RANGE_2p5(0) , GND );
capacitor #(.c(2.171e-16)) (*
integer library_binding = "analogLib";

 *)
c2997 ( \4:MR_SQUELCH_RANGE_2p5(0) , \4:GND  );
capacitor #(.c(1.602e-17)) (*
integer library_binding = "analogLib";

 *)
c2998 ( \4:MR_SQUELCH_RANGE_2p5(0) , \PHASE_250(2)  );
capacitor #(.c(1.166e-17)) (*
integer library_binding = "analogLib";

 *)
c2999 ( \4:MR_SQUELCH_RANGE_2p5(0) , \4:PHASE_250(2)  );
capacitor #(.c(6.918e-17)) (*
integer library_binding = "analogLib";

 *)
c3000 ( \4:MR_SQUELCH_RANGE_2p5(0) , \WANDER_CNT(4)  );
capacitor #(.c(5.849e-18)) (*
integer library_binding = "analogLib";

 *)
c3001 ( \4:MR_SQUELCH_RANGE_2p5(0) , \PHASE_250(8)  );
capacitor #(.c(6.706e-16)) (*
integer library_binding = "analogLib";

 *)
c3002 ( \4:MR_SQUELCH_RANGE_2p5(0) , \3:MR_SQUELCH_DISB_2p5  );
capacitor #(.c(2.188e-17)) (*
integer library_binding = "analogLib";

 *)
c3003 ( \4:MR_SQUELCH_RANGE_2p5(0) , \3:PHASE_250(1)  );
capacitor #(.c(1.379e-17)) (*
integer library_binding = "analogLib";

 *)
c3004 ( \4:MR_SQUELCH_RANGE_2p5(0) , \PHASE_250(1)  );
capacitor #(.c(4.871e-19)) (*
integer library_binding = "analogLib";

 *)
c3005 ( \4:MR_SQUELCH_RANGE_2p5(0) , \2:TX100_DIS_2p5  );
capacitor #(.c(1.329e-17)) (*
integer library_binding = "analogLib";

 *)
c3006 ( \4:MR_SQUELCH_RANGE_2p5(0) , \9:TX100_DIS_2p5  );
capacitor #(.c(2.26e-17)) (*
integer library_binding = "analogLib";

 *)
c3007 ( \4:MR_SQUELCH_RANGE_2p5(0) , \4:PHASE_250(8)  );
capacitor #(.c(2.918e-17)) (*
integer library_binding = "analogLib";

 *)
c3008 ( \4:MR_SQUELCH_RANGE_2p5(0) , RX10_PRESENT_2p5 );
capacitor #(.c(5.326e-18)) (*
integer library_binding = "analogLib";

 *)
c3009 ( \4:MR_SQUELCH_RANGE_2p5(0) , \PHASE_250(6)  );
capacitor #(.c(1.026e-17)) (*
integer library_binding = "analogLib";

 *)
c3010 ( \4:MR_SQUELCH_RANGE_2p5(0) , TIMING_UP_ANLG );
capacitor #(.c(9.836e-18)) (*
integer library_binding = "analogLib";

 *)
c3011 ( \4:MR_SQUELCH_RANGE_2p5(0) , RESET_DSP );
capacitor #(.c(8.442e-18)) (*
integer library_binding = "analogLib";

 *)
c3012 ( \4:MR_SQUELCH_RANGE_2p5(0) , \5:TIMING_DN_ANLG  );
capacitor #(.c(8.135e-16)) (*
integer library_binding = "analogLib";

 *)
c3013 ( \4:MR_SQUELCH_RANGE_2p5(0) , \5:WANDER_CNT(4)  );
capacitor #(.c(2.369e-18)) (*
integer library_binding = "analogLib";

 *)
c3014 ( \4:MR_SQUELCH_RANGE_2p5(0) , \5:BLW_DIS_2p5  );
capacitor #(.c(7.564e-20)) (*
integer library_binding = "analogLib";

 *)
c3015 ( \4:MR_SQUELCH_RANGE_2p5(0) , \3:XTAL25  );
capacitor #(.c(1.816e-17)) (*
integer library_binding = "analogLib";

 *)
c3016 ( \4:MR_SQUELCH_RANGE_2p5(0) , \6:XTAL25  );
capacitor #(.c(1.616e-17)) (*
integer library_binding = "analogLib";

 *)
c3017 ( \4:MR_SQUELCH_RANGE_2p5(0) , \4:PHASE_250(6)  );
capacitor #(.c(1.964e-17)) (*
integer library_binding = "analogLib";

 *)
c3018 ( \4:MR_SQUELCH_RANGE_2p5(0) , BLW_DIS_2p5 );
capacitor #(.c(1.765e-17)) (*
integer library_binding = "analogLib";

 *)
c3019 ( \4:MR_SQUELCH_RANGE_2p5(0) , \2:I_REXT_50(0)  );
capacitor #(.c(1.224e-15)) (*
integer library_binding = "analogLib";

 *)
c3020 ( \4:MR_SQUELCH_RANGE_2p5(0) , MR_SQUELCH_DISB_2p5 );
capacitor #(.c(1.765e-17)) (*
integer library_binding = "analogLib";

 *)
c3021 ( \4:MR_SQUELCH_RANGE_2p5(0) , \4:RCLK125_TST  );
capacitor #(.c(1.017e-17)) (*
integer library_binding = "analogLib";

 *)
c3022 ( \4:MR_SQUELCH_RANGE_2p5(0) , \4:PHASE_250(3)  );
capacitor #(.c(1.715e-17)) (*
integer library_binding = "analogLib";

 *)
c3023 ( \4:MR_SQUELCH_RANGE_2p5(0) , \PHASE_250(3)  );
capacitor #(.c(2.074e-16)) (*
integer library_binding = "analogLib";

 *)
c3024 ( \4:MR_SQUELCH_RANGE_2p5(0) , \6:RX10_PRESENT_2p5  );
capacitor #(.c(1.528e-15)) (*
integer library_binding = "analogLib";

 *)
c3025 ( \4:MR_SQUELCH_RANGE_2p5(0) , \MR_SQUELCH_RANGE_2p5(1)  );
capacitor #(.c(6.304e-16)) (*
integer library_binding = "analogLib";

 *)
c3026 ( \4:MR_SQUELCH_RANGE_2p5(0) , \3:MR_SQUELCH_RANGE_2p5(1)  );
capacitor #(.c(1.06e-16)) (*
integer library_binding = "analogLib";

 *)
c3027 ( \4:MR_SQUELCH_RANGE_2p5(0) , \4:PHASE_250(5)  );
capacitor #(.c(1.392e-16)) (*
integer library_binding = "analogLib";

 *)
c3028 ( \4:MR_SQUELCH_RANGE_2p5(0) , \PHASE_250(5)  );
capacitor #(.c(7.421e-18)) (*
integer library_binding = "analogLib";

 *)
c3029 ( \4:MR_SQUELCH_RANGE_2p5(0) , RCLK125_TST );
capacitor #(.c(2.551e-17)) (*
integer library_binding = "analogLib";

 *)
c3030 ( \4:MR_SQUELCH_RANGE_2p5(0) , \6:AEQ_DIS_2p5  );
capacitor #(.c(3.577e-18)) (*
integer library_binding = "analogLib";

 *)
c3031 ( \4:MR_SQUELCH_RANGE_2p5(0) , AEQ_DIS_2p5 );
capacitor #(.c(6.377e-18)) (*
integer library_binding = "analogLib";

 *)
c3032 ( \4:MR_SQUELCH_RANGE_2p5(0) , \PHASE_250(10)  );
capacitor #(.c(1.385e-17)) (*
integer library_binding = "analogLib";

 *)
c3033 ( \4:MR_SQUELCH_RANGE_2p5(0) , \4:PHASE_250(4)  );
capacitor #(.c(1.654e-17)) (*
integer library_binding = "analogLib";

 *)
c3034 ( \4:MR_SQUELCH_RANGE_2p5(0) , \PHASE_250(4)  );
capacitor #(.c(1.932e-17)) (*
integer library_binding = "analogLib";

 *)
c3035 ( \4:MR_SQUELCH_RANGE_2p5(0) , \4:PHASE_250(10)  );
capacitor #(.c(3.358e-15)) (*
integer library_binding = "analogLib";

 *)
c3036 ( \4:MR_SQUELCH_RANGE_2p5(0) , GND );
capacitor #(.c(4.577e-17)) (*
integer library_binding = "analogLib";

 *)
c3037 ( \7:GNDRX , \4:GND  );
capacitor #(.c(7.053e-16)) (*
integer library_binding = "analogLib";

 *)
c3038 ( \7:GNDRX , GND );
capacitor #(.c(4.039e-16)) (*
integer library_binding = "analogLib";

 *)
c3039 ( \5:GNDRX , \4:GND  );
capacitor #(.c(6.224e-15)) (*
integer library_binding = "analogLib";

 *)
c3040 ( \5:GNDRX , GND );
capacitor #(.c(2.685e-16)) (*
integer library_binding = "analogLib";

 *)
c3041 ( \5:GNDRX , \3:ADC_1p0(4)  );
capacitor #(.c(9.746e-17)) (*
integer library_binding = "analogLib";

 *)
c3042 ( \5:GNDRX , \4:I_REXT_100(4)  );
capacitor #(.c(9.746e-17)) (*
integer library_binding = "analogLib";

 *)
c3043 ( \5:GNDRX , \4:I_REXT_100(3)  );
capacitor #(.c(9.746e-17)) (*
integer library_binding = "analogLib";

 *)
c3044 ( \5:GNDRX , \4:I_REXT_100(2)  );
capacitor #(.c(2.268e-16)) (*
integer library_binding = "analogLib";

 *)
c3045 ( \5:GNDRX , \4:FLASH_1p0(0)  );
capacitor #(.c(1.288e-16)) (*
integer library_binding = "analogLib";

 *)
c3046 ( \5:GNDRX , \25:GND  );
capacitor #(.c(9.755e-17)) (*
integer library_binding = "analogLib";

 *)
c3047 ( \5:GNDRX , \4:FLASH_1p0(1)  );
capacitor #(.c(2.08e-16)) (*
integer library_binding = "analogLib";

 *)
c3048 ( \5:GNDRX , \ADC_1p0(5)  );
capacitor #(.c(1.564e-16)) (*
integer library_binding = "analogLib";

 *)
c3049 ( \5:GNDRX , \3:ADC_1p0(3)  );
capacitor #(.c(2.268e-16)) (*
integer library_binding = "analogLib";

 *)
c3050 ( \5:GNDRX , \ADC_1p0(0)  );
capacitor #(.c(1.824e-16)) (*
integer library_binding = "analogLib";

 *)
c3051 ( \5:GNDRX , \4:RCLK125_1p0  );
capacitor #(.c(1.001e-16)) (*
integer library_binding = "analogLib";

 *)
c3052 ( \6:GNDRX , \4:GND  );
capacitor #(.c(2.809e-16)) (*
integer library_binding = "analogLib";

 *)
c3053 ( \6:GNDRX , \7:I_REXT_50(0)  );
capacitor #(.c(3.942e-17)) (*
integer library_binding = "analogLib";

 *)
c3054 ( \6:GNDRX , \I_REXT_50(0)  );
capacitor #(.c(1.543e-15)) (*
integer library_binding = "analogLib";

 *)
c3055 ( \6:GNDRX , GND );
capacitor #(.c(1.736e-16)) (*
integer library_binding = "analogLib";

 *)
c3056 ( \6:GNDRX , \3:ADC_1p0(4)  );
capacitor #(.c(1.561e-15)) (*
integer library_binding = "analogLib";

 *)
c3057 ( \6:GNDRX , \5:GND  );
capacitor #(.c(1.736e-16)) (*
integer library_binding = "analogLib";

 *)
c3058 ( \6:GNDRX , \3:ADC_1p0(3)  );
capacitor #(.c(1.736e-16)) (*
integer library_binding = "analogLib";

 *)
c3059 ( \6:GNDRX , \4:I_RPOLY_100(5)  );
capacitor #(.c(2.498e-16)) (*
integer library_binding = "analogLib";

 *)
c3060 ( \6:GNDRX , \4:FLASH_1p0(0)  );
capacitor #(.c(9.746e-17)) (*
integer library_binding = "analogLib";

 *)
c3061 ( \6:GNDRX , \I_RPOLY_100(4)  );
capacitor #(.c(2.424e-16)) (*
integer library_binding = "analogLib";

 *)
c3062 ( \6:GNDRX , \ADC_1p0(0)  );
capacitor #(.c(9.746e-17)) (*
integer library_binding = "analogLib";

 *)
c3063 ( \6:GNDRX , \4:I_RPOLY_100(3)  );
capacitor #(.c(1.984e-16)) (*
integer library_binding = "analogLib";

 *)
c3064 ( \6:GNDRX , \4:RCLK125_1p0  );
capacitor #(.c(9.746e-17)) (*
integer library_binding = "analogLib";

 *)
c3065 ( \6:GNDRX , \4:I_RPOLY_100(2)  );
capacitor #(.c(9.746e-17)) (*
integer library_binding = "analogLib";

 *)
c3066 ( \6:GNDRX , \4:I_RPOLY_100(0)  );
capacitor #(.c(2.498e-16)) (*
integer library_binding = "analogLib";

 *)
c3067 ( \6:GNDRX , \4:FLASH_1p0(1)  );
capacitor #(.c(2.498e-16)) (*
integer library_binding = "analogLib";

 *)
c3068 ( \6:GNDRX , \ADC_1p0(5)  );
capacitor #(.c(9.746e-17)) (*
integer library_binding = "analogLib";

 *)
c3069 ( \6:GNDRX , \4:I_REXT_100(6)  );
capacitor #(.c(5.238e-16)) (*
integer library_binding = "analogLib";

 *)
c3070 ( \26:GND , \5:BASE10_TX_DIS_1p0  );
capacitor #(.c(1.795e-15)) (*
integer library_binding = "analogLib";

 *)
c3071 ( \26:GND , \24:VDDTX  );
capacitor #(.c(9.534e-17)) (*
integer library_binding = "analogLib";

 *)
c3072 ( \26:GND , TENBT_CLK160_1p0 );
capacitor #(.c(4.617e-17)) (*
integer library_binding = "analogLib";

 *)
c3073 ( \26:GND , \PHASE_IN(10)  );
capacitor #(.c(1.632e-17)) (*
integer library_binding = "analogLib";

 *)
c3074 ( \26:GND , \2:PHASE_IN(3)  );
capacitor #(.c(1.119e-17)) (*
integer library_binding = "analogLib";

 *)
c3075 ( \26:GND , \2:PHASE_IN(2)  );
capacitor #(.c(1.164e-17)) (*
integer library_binding = "analogLib";

 *)
c3076 ( \26:GND , \PHASE_IN(8)  );
capacitor #(.c(1.067e-17)) (*
integer library_binding = "analogLib";

 *)
c3077 ( \26:GND , \3:PHASE_IN(7)  );
capacitor #(.c(1.113e-15)) (*
integer library_binding = "analogLib";

 *)
c3078 ( \26:GND , BASE10_TX_DIS_1p0 );
capacitor #(.c(1.064e-17)) (*
integer library_binding = "analogLib";

 *)
c3079 ( \26:GND , \1:PHASE_IN(5)  );
capacitor #(.c(2.028e-16)) (*
integer library_binding = "analogLib";

 *)
c3080 ( \26:GND , \2:PHASE_IN(9)  );
capacitor #(.c(1.131e-16)) (*
integer library_binding = "analogLib";

 *)
c3081 ( \26:GND , \3:XTAL25  );
capacitor #(.c(1.417e-16)) (*
integer library_binding = "analogLib";

 *)
c3082 ( \26:GND , \1:PLL_160_IN  );
capacitor #(.c(1.358e-16)) (*
integer library_binding = "analogLib";

 *)
c3083 ( \26:GND , \1:PHASE_IN(1)  );
capacitor #(.c(6.029e-16)) (*
integer library_binding = "analogLib";

 *)
c3084 ( \4:GND , \2:PHASE_IN(5)  );
capacitor #(.c(8.09e-16)) (*
integer library_binding = "analogLib";

 *)
c3085 ( \4:GND , \PHASE_IN(8)  );
capacitor #(.c(2.446e-16)) (*
integer library_binding = "analogLib";

 *)
c3086 ( \4:GND , \TX_AMPTRIM_1p0(0)  );
capacitor #(.c(3.355e-16)) (*
integer library_binding = "analogLib";

 *)
c3087 ( \4:GND , BLW_DIS_2p5 );
capacitor #(.c(3.334e-16)) (*
integer library_binding = "analogLib";

 *)
c3088 ( \4:GND , \3:TX_SLOPETRIM_1p0(0)  );
capacitor #(.c(3.618e-17)) (*
integer library_binding = "analogLib";

 *)
c3089 ( \4:GND , \6:TENBT_FILTER_1p0(2)  );
capacitor #(.c(3.105e-16)) (*
integer library_binding = "analogLib";

 *)
c3090 ( \4:GND , \3:POS_DETECT_1p0  );
capacitor #(.c(1.768e-16)) (*
integer library_binding = "analogLib";

 *)
c3091 ( \4:GND , \1:LEDL  );
capacitor #(.c(3.791e-16)) (*
integer library_binding = "analogLib";

 *)
c3092 ( \4:GND , \7:ADC_1p0(5)  );
capacitor #(.c(1.027e-17)) (*
integer library_binding = "analogLib";

 *)
c3093 ( \4:GND , AEQ_BYPASS );
capacitor #(.c(2.862e-16)) (*
integer library_binding = "analogLib";

 *)
c3094 ( \4:GND , AEQ_DIS_2p5 );
capacitor #(.c(7.935e-16)) (*
integer library_binding = "analogLib";

 *)
c3095 ( \4:GND , \4:FLASH_1p0(0)  );
capacitor #(.c(3.531e-16)) (*
integer library_binding = "analogLib";

 *)
c3096 ( \4:GND , \4:I_RPOLY_100(5)  );
capacitor #(.c(1.576e-16)) (*
integer library_binding = "analogLib";

 *)
c3097 ( \4:GND , XTAL25_1p0 );
capacitor #(.c(7.736e-17)) (*
integer library_binding = "analogLib";

 *)
c3098 ( \4:GND , \4:RCLK125_TST  );
capacitor #(.c(6.111e-17)) (*
integer library_binding = "analogLib";

 *)
c3099 ( \4:GND , \4:PHASE_250(2)  );
capacitor #(.c(2.04e-16)) (*
integer library_binding = "analogLib";

 *)
c3100 ( \4:GND , \4:MR_SQUELCH_DISB_1p0  );
capacitor #(.c(7.944e-17)) (*
integer library_binding = "analogLib";

 *)
c3101 ( \4:GND , \WANDER_CNT(3)  );
capacitor #(.c(9.575e-17)) (*
integer library_binding = "analogLib";

 *)
c3102 ( \4:GND , \6:TIMING_UP_ANLG  );
capacitor #(.c(1.768e-16)) (*
integer library_binding = "analogLib";

 *)
c3103 ( \4:GND , \1:ANDIS  );
capacitor #(.c(1.413e-16)) (*
integer library_binding = "analogLib";

 *)
c3104 ( \4:GND , \4:WANDER_CNT(0)  );
capacitor #(.c(9.197e-17)) (*
integer library_binding = "analogLib";

 *)
c3105 ( \4:GND , \PHASE_250(2)  );
capacitor #(.c(3.548e-17)) (*
integer library_binding = "analogLib";

 *)
c3106 ( \4:GND , \5:BASE10_TX_DIS_1p0  );
capacitor #(.c(1.421e-16)) (*
integer library_binding = "analogLib";

 *)
c3107 ( \4:GND , \I_RPOLY_100(2)  );
capacitor #(.c(1.148e-16)) (*
integer library_binding = "analogLib";

 *)
c3108 ( \4:GND , \PHASE_250(9)  );
capacitor #(.c(1.768e-16)) (*
integer library_binding = "analogLib";

 *)
c3109 ( \4:GND , \1:TXD(3)  );
capacitor #(.c(2.741e-16)) (*
integer library_binding = "analogLib";

 *)
c3110 ( \4:GND , \3:MR_SQUELCH_RANGE_1p0(0)  );
capacitor #(.c(1.297e-16)) (*
integer library_binding = "analogLib";

 *)
c3111 ( \4:GND , \6:X10_DIS_2p5  );
capacitor #(.c(1.076e-16)) (*
integer library_binding = "analogLib";

 *)
c3112 ( \4:GND , \3:PHASE_250(9)  );
capacitor #(.c(6.872e-17)) (*
integer library_binding = "analogLib";

 *)
c3113 ( \4:GND , \I_REXT_100(6)  );
capacitor #(.c(6.763e-16)) (*
integer library_binding = "analogLib";

 *)
c3114 ( \4:GND , \6:ADC_1p0(5)  );
capacitor #(.c(3.706e-16)) (*
integer library_binding = "analogLib";

 *)
c3115 ( \4:GND , \MLT3_TDATA_2p5(1)  );
capacitor #(.c(2.1e-16)) (*
integer library_binding = "analogLib";

 *)
c3116 ( \4:GND , \PHASE_IN(3)  );
capacitor #(.c(8.703e-16)) (*
integer library_binding = "analogLib";

 *)
c3117 ( \4:GND , \3:PHASE_IN(7)  );
capacitor #(.c(1.37e-16)) (*
integer library_binding = "analogLib";

 *)
c3118 ( \4:GND , \2:I_REXT_100(2)  );
capacitor #(.c(4.093e-16)) (*
integer library_binding = "analogLib";

 *)
c3119 ( \4:GND , \4:FLASH_1p0(1)  );
capacitor #(.c(2.539e-16)) (*
integer library_binding = "analogLib";

 *)
c3120 ( \4:GND , \7:I_REXT_50(0)  );
capacitor #(.c(1.819e-16)) (*
integer library_binding = "analogLib";

 *)
c3121 ( \4:GND , \5:TXER  );
capacitor #(.c(7.907e-17)) (*
integer library_binding = "analogLib";

 *)
c3122 ( \4:GND , \5:PHASE_IN(5)  );
capacitor #(.c(7.713e-17)) (*
integer library_binding = "analogLib";

 *)
c3123 ( \4:GND , \9:BASEFX_DIS  );
capacitor #(.c(3.91e-17)) (*
integer library_binding = "analogLib";

 *)
c3124 ( \4:GND , \TENBT_FILTER_1p0(1)  );
capacitor #(.c(1.768e-16)) (*
integer library_binding = "analogLib";

 *)
c3125 ( \4:GND , \1:LEDD  );
capacitor #(.c(3.525e-16)) (*
integer library_binding = "analogLib";

 *)
c3126 ( \4:GND , \7:ADC_1p0(4)  );
capacitor #(.c(9.489e-17)) (*
integer library_binding = "analogLib";

 *)
c3127 ( \4:GND , RX10_PRESENT_2p5 );
capacitor #(.c(2.014e-16)) (*
integer library_binding = "analogLib";

 *)
c3128 ( \4:GND , \5:MR_BYPASS10RX_FILTER  );
capacitor #(.c(5.511e-17)) (*
integer library_binding = "analogLib";

 *)
c3129 ( \4:GND , \AEQ_CNT_ANLG(4)  );
capacitor #(.c(3.511e-17)) (*
integer library_binding = "analogLib";

 *)
c3130 ( \4:GND , \5:TENBT_FILTER_1p0(3)  );
capacitor #(.c(1.193e-15)) (*
integer library_binding = "analogLib";

 *)
c3131 ( \4:GND , PLL_160_IN );
capacitor #(.c(1.316e-15)) (*
integer library_binding = "analogLib";

 *)
c3132 ( \4:GND , \PHASE_IN(10)  );
capacitor #(.c(8.716e-16)) (*
integer library_binding = "analogLib";

 *)
c3133 ( \4:GND , \I_REXT_50(0)  );
capacitor #(.c(7.445e-16)) (*
integer library_binding = "analogLib";

 *)
c3134 ( \4:GND , \ADC_1p0(0)  );
capacitor #(.c(1.164e-16)) (*
integer library_binding = "analogLib";

 *)
c3135 ( \4:GND , \I_RPOLY_100(4)  );
capacitor #(.c(2.661e-16)) (*
integer library_binding = "analogLib";

 *)
c3136 ( \4:GND , \7:X10_DIS_2p5  );
capacitor #(.c(5.398e-17)) (*
integer library_binding = "analogLib";

 *)
c3137 ( \4:GND , POS_DETECT_2p5 );
capacitor #(.c(7.572e-17)) (*
integer library_binding = "analogLib";

 *)
c3138 ( \4:GND , \PHASE_250(1)  );
capacitor #(.c(3.239e-16)) (*
integer library_binding = "analogLib";

 *)
c3139 ( \4:GND , \4:MLT3_TDATA_2p5(1)  );
capacitor #(.c(2.051e-16)) (*
integer library_binding = "analogLib";

 *)
c3140 ( \4:GND , \5:WANDER_CNT(2)  );
capacitor #(.c(1.281e-16)) (*
integer library_binding = "analogLib";

 *)
c3141 ( \4:GND , TIMING_DN_ANLG );
capacitor #(.c(1.768e-16)) (*
integer library_binding = "analogLib";

 *)
c3142 ( \4:GND , \1:MDIO_IN  );
capacitor #(.c(9.516e-17)) (*
integer library_binding = "analogLib";

 *)
c3143 ( \4:GND , \5:AEQ_CNT_ANLG(4)  );
capacitor #(.c(9.675e-17)) (*
integer library_binding = "analogLib";

 *)
c3144 ( \4:GND , \3:PHASE_250(1)  );
capacitor #(.c(3.997e-16)) (*
integer library_binding = "analogLib";

 *)
c3145 ( \4:GND , X10_DIS_2p5 );
capacitor #(.c(6.086e-16)) (*
integer library_binding = "analogLib";

 *)
c3146 ( \4:GND , \5:PHASE_IN(7)  );
capacitor #(.c(2.726e-16)) (*
integer library_binding = "analogLib";

 *)
c3147 ( \4:GND , \3:TXER  );
capacitor #(.c(1.431e-16)) (*
integer library_binding = "analogLib";

 *)
c3148 ( \4:GND , \2:I_RPOLY_100(3)  );
capacitor #(.c(1.659e-16)) (*
integer library_binding = "analogLib";

 *)
c3149 ( \4:GND , \4:SLICER_OUT_1p0  );
capacitor #(.c(8.128e-17)) (*
integer library_binding = "analogLib";

 *)
c3150 ( \4:GND , \4:PHASE_250(8)  );
capacitor #(.c(1.965e-16)) (*
integer library_binding = "analogLib";

 *)
c3151 ( \4:GND , NEG_DETECT_1p0 );
capacitor #(.c(3.088e-16)) (*
integer library_binding = "analogLib";

 *)
c3152 ( \4:GND , \3:X_160  );
capacitor #(.c(1.768e-16)) (*
integer library_binding = "analogLib";

 *)
c3153 ( \4:GND , \1:RXER  );
capacitor #(.c(1.498e-16)) (*
integer library_binding = "analogLib";

 *)
c3154 ( \4:GND , MR_SQUELCH_DISB_1p0 );
capacitor #(.c(4.316e-16)) (*
integer library_binding = "analogLib";

 *)
c3155 ( \4:GND , \WANDER_CNT(6)  );
capacitor #(.c(1.105e-16)) (*
integer library_binding = "analogLib";

 *)
c3156 ( \4:GND , \PHASE_250(8)  );
capacitor #(.c(9.117e-16)) (*
integer library_binding = "analogLib";

 *)
c3157 ( \4:GND , \6:ADC_1p0(4)  );
capacitor #(.c(2.202e-16)) (*
integer library_binding = "analogLib";

 *)
c3158 ( \4:GND , \6:PHASE_IN(2)  );
capacitor #(.c(6.607e-16)) (*
integer library_binding = "analogLib";

 *)
c3159 ( \4:GND , \4:PHASE_IN(2)  );
capacitor #(.c(4.788e-16)) (*
integer library_binding = "analogLib";

 *)
c3160 ( \4:GND , \2:I_REXT_50(0)  );
capacitor #(.c(1.393e-16)) (*
integer library_binding = "analogLib";

 *)
c3161 ( \4:GND , \2:I_REXT_100(3)  );
capacitor #(.c(9.032e-16)) (*
integer library_binding = "analogLib";

 *)
c3162 ( \4:GND , \ADC_1p0(5)  );
capacitor #(.c(2.351e-16)) (*
integer library_binding = "analogLib";

 *)
c3163 ( \4:GND , \2:PHASE_IN(1)  );
capacitor #(.c(1.196e-16)) (*
integer library_binding = "analogLib";

 *)
c3164 ( \4:GND , \9:TX100_DIS_2p5  );
capacitor #(.c(1.718e-16)) (*
integer library_binding = "analogLib";

 *)
c3165 ( \4:GND , \5:B10_DIS  );
capacitor #(.c(1.768e-16)) (*
integer library_binding = "analogLib";

 *)
c3166 ( \4:GND , \1:TX_AMP_TRIM(0)  );
capacitor #(.c(3.97e-17)) (*
integer library_binding = "analogLib";

 *)
c3167 ( \4:GND , \6:TENBT_FILTER_1p0(0)  );
capacitor #(.c(1.768e-16)) (*
integer library_binding = "analogLib";

 *)
c3168 ( \4:GND , \1:PHY(3)  );
capacitor #(.c(1.768e-16)) (*
integer library_binding = "analogLib";

 *)
c3169 ( \4:GND , \1:LEDC  );
capacitor #(.c(2.711e-16)) (*
integer library_binding = "analogLib";

 *)
c3170 ( \4:GND , \7:ADC_1p0(3)  );
capacitor #(.c(1.158e-16)) (*
integer library_binding = "analogLib";

 *)
c3171 ( \4:GND , \I_RPOLY_100(5)  );
capacitor #(.c(3.808e-17)) (*
integer library_binding = "analogLib";

 *)
c3172 ( \4:GND , \TENBT_FILTER_1p0(2)  );
capacitor #(.c(2.049e-16)) (*
integer library_binding = "analogLib";

 *)
c3173 ( \4:GND , \PHASE_IN(9)  );
capacitor #(.c(1.131e-16)) (*
integer library_binding = "analogLib";

 *)
c3174 ( \4:GND , \4:I_RPOLY_100(3)  );
capacitor #(.c(3.463e-15)) (*
integer library_binding = "analogLib";

 *)
c3175 ( \4:GND , \25:VDDTX  );
capacitor #(.c(3.125e-16)) (*
integer library_binding = "analogLib";

 *)
c3176 ( \4:GND , POS_DETECT_1p0 );
capacitor #(.c(5.437e-17)) (*
integer library_binding = "analogLib";

 *)
c3177 ( \4:GND , \4:PHASE_250(10)  );
capacitor #(.c(1.987e-16)) (*
integer library_binding = "analogLib";

 *)
c3178 ( \4:GND , \3:TEST_MODE(2)  );
capacitor #(.c(9.277e-17)) (*
integer library_binding = "analogLib";

 *)
c3179 ( \4:GND , RX10_PRESENT_1p0 );
capacitor #(.c(1.768e-16)) (*
integer library_binding = "analogLib";

 *)
c3180 ( \4:GND , \1:MDINT  );
capacitor #(.c(9.611e-17)) (*
integer library_binding = "analogLib";

 *)
c3181 ( \4:GND , \PHASE_250(10)  );
capacitor #(.c(1.736e-16)) (*
integer library_binding = "analogLib";

 *)
c3182 ( \4:GND , \6:FLASH_1p0(1)  );
capacitor #(.c(3.923e-15)) (*
integer library_binding = "analogLib";

 *)
c3183 ( \4:GND , \24:VDDTX  );
capacitor #(.c(1.526e-16)) (*
integer library_binding = "analogLib";

 *)
c3184 ( \4:GND , \2:I_RPOLY_100(4)  );
capacitor #(.c(2.633e-16)) (*
integer library_binding = "analogLib";

 *)
c3185 ( \4:GND , \MR_SQUELCH_RANGE_2p5(1)  );
capacitor #(.c(1.477e-16)) (*
integer library_binding = "analogLib";

 *)
c3186 ( \4:GND , X_125 );
capacitor #(.c(1.768e-16)) (*
integer library_binding = "analogLib";

 *)
c3187 ( \4:GND , \1:TXD(1)  );
capacitor #(.c(1.768e-16)) (*
integer library_binding = "analogLib";

 *)
c3188 ( \4:GND , \1:RXDV  );
capacitor #(.c(2.4e-16)) (*
integer library_binding = "analogLib";

 *)
c3189 ( \4:GND , MR_BYPASS10RX_FILTER );
capacitor #(.c(2.626e-18)) (*
integer library_binding = "analogLib";

 *)
c3190 ( \4:GND , BASEFX_DIS );
capacitor #(.c(6.668e-17)) (*
integer library_binding = "analogLib";

 *)
c3191 ( \4:GND , \I_REXT_100(4)  );
capacitor #(.c(2.89e-16)) (*
integer library_binding = "analogLib";

 *)
c3192 ( \4:GND , \6:ADC_1p0(3)  );
capacitor #(.c(1.252e-16)) (*
integer library_binding = "analogLib";

 *)
c3193 ( \4:GND , \PHASE_IN(1)  );
capacitor #(.c(6.625e-16)) (*
integer library_binding = "analogLib";

 *)
c3194 ( \4:GND , \3:X10_DIS_2p5  );
capacitor #(.c(6.973e-16)) (*
integer library_binding = "analogLib";

 *)
c3195 ( \4:GND , \1:PHASE_IN(5)  );
capacitor #(.c(1.391e-16)) (*
integer library_binding = "analogLib";

 *)
c3196 ( \4:GND , \2:I_REXT_100(4)  );
capacitor #(.c(1.114e-16)) (*
integer library_binding = "analogLib";

 *)
c3197 ( \4:GND , \4:I_REXT_100(6)  );
capacitor #(.c(2.311e-16)) (*
integer library_binding = "analogLib";

 *)
c3198 ( \4:GND , TP_DISC_2p5 );
capacitor #(.c(6.26e-17)) (*
integer library_binding = "analogLib";

 *)
c3199 ( \4:GND , \7:PHASE_IN(3)  );
capacitor #(.c(2.887e-16)) (*
integer library_binding = "analogLib";

 *)
c3200 ( \4:GND , \TX_AMPTRIM_1p0(1)  );
capacitor #(.c(5.75e-17)) (*
integer library_binding = "analogLib";

 *)
c3201 ( \4:GND , \6:TENBT_CLK160_1p0  );
capacitor #(.c(1.768e-16)) (*
integer library_binding = "analogLib";

 *)
c3202 ( \4:GND , \1:PHY(2)  );
capacitor #(.c(7.739e-17)) (*
integer library_binding = "analogLib";

 *)
c3203 ( \4:GND , \5:POS_DETECT_2p5  );
capacitor #(.c(7.488e-17)) (*
integer library_binding = "analogLib";

 *)
c3204 ( \4:GND , \3:I_RPOLY_100(4)  );
capacitor #(.c(3.506e-17)) (*
integer library_binding = "analogLib";

 *)
c3205 ( \4:GND , \5:TENBT_FILTER_1p0(1)  );
capacitor #(.c(2.055e-16)) (*
integer library_binding = "analogLib";

 *)
c3206 ( \4:GND , \6:PHASE_IN(8)  );
capacitor #(.c(6.48e-16)) (*
integer library_binding = "analogLib";

 *)
c3207 ( \4:GND , \4:PHASE_IN(8)  );
capacitor #(.c(3.048e-16)) (*
integer library_binding = "analogLib";

 *)
c3208 ( \4:GND , \4:PHASE_IN(9)  );
capacitor #(.c(1.126e-16)) (*
integer library_binding = "analogLib";

 *)
c3209 ( \4:GND , \4:I_RPOLY_100(2)  );
capacitor #(.c(2.096e-16)) (*
integer library_binding = "analogLib";

 *)
c3210 ( \4:GND , \4:PLL_160_IN  );
capacitor #(.c(1.31e-16)) (*
integer library_binding = "analogLib";

 *)
c3211 ( \4:GND , \WANDER_CNT(0)  );
capacitor #(.c(1.502e-16)) (*
integer library_binding = "analogLib";

 *)
c3212 ( \4:GND , \6:RESET_DSP  );
capacitor #(.c(1.768e-16)) (*
integer library_binding = "analogLib";

 *)
c3213 ( \4:GND , \1:MDC  );
capacitor #(.c(5.63e-16)) (*
integer library_binding = "analogLib";

 *)
c3214 ( \4:GND , \6:FLASH_1p0(0)  );
capacitor #(.c(3.899e-16)) (*
integer library_binding = "analogLib";

 *)
c3215 ( \4:GND , TX100_DIS_2p5 );
capacitor #(.c(4.818e-16)) (*
integer library_binding = "analogLib";

 *)
c3216 ( \4:GND , \2:I_RPOLY_100(5)  );
capacitor #(.c(1.077e-16)) (*
integer library_binding = "analogLib";

 *)
c3217 ( \4:GND , \6:RX10_PRESENT_2p5  );
capacitor #(.c(5.558e-17)) (*
integer library_binding = "analogLib";

 *)
c3218 ( \4:GND , \4:PHASE_250(6)  );
capacitor #(.c(7.345e-17)) (*
integer library_binding = "analogLib";

 *)
c3219 ( \4:GND , \3:XTAL25_1p0  );
capacitor #(.c(1.768e-16)) (*
integer library_binding = "analogLib";

 *)
c3220 ( \4:GND , \1:RXD(4)  );
capacitor #(.c(1.231e-17)) (*
integer library_binding = "analogLib";

 *)
c3221 ( \4:GND , BASE10_TX_DIS_1p0 );
capacitor #(.c(2.61e-16)) (*
integer library_binding = "analogLib";

 *)
c3222 ( \4:GND , \WANDER_CNT(4)  );
capacitor #(.c(6.489e-17)) (*
integer library_binding = "analogLib";

 *)
c3223 ( \4:GND , \PHASE_250(6)  );
capacitor #(.c(6.565e-17)) (*
integer library_binding = "analogLib";

 *)
c3224 ( \4:GND , \I_REXT_100(3)  );
capacitor #(.c(1.862e-16)) (*
integer library_binding = "analogLib";

 *)
c3225 ( \4:GND , \6:I_REXT_50(0)  );
capacitor #(.c(2.281e-16)) (*
integer library_binding = "analogLib";

 *)
c3226 ( \4:GND , \6:PHASE_IN(10)  );
capacitor #(.c(7.918e-17)) (*
integer library_binding = "analogLib";

 *)
c3227 ( \4:GND , \PHASE_IN(2)  );
capacitor #(.c(2.299e-16)) (*
integer library_binding = "analogLib";

 *)
c3228 ( \4:GND , \6:AEQ_DIS_2p5  );
capacitor #(.c(2.538e-16)) (*
integer library_binding = "analogLib";

 *)
c3229 ( \4:GND , \3:TX_AMPTRIM_1p0(0)  );
capacitor #(.c(1.241e-16)) (*
integer library_binding = "analogLib";

 *)
c3230 ( \4:GND , \6:T2_MODE  );
capacitor #(.c(1.768e-16)) (*
integer library_binding = "analogLib";

 *)
c3231 ( \4:GND , \1:PHY(1)  );
capacitor #(.c(3.823e-16)) (*
integer library_binding = "analogLib";

 *)
c3232 ( \4:GND , \7:FLASH_1p0(1)  );
capacitor #(.c(1.364e-16)) (*
integer library_binding = "analogLib";

 *)
c3233 ( \4:GND , RESET_DSP );
capacitor #(.c(7.276e-17)) (*
integer library_binding = "analogLib";

 *)
c3234 ( \4:GND , \I_RPOLY_100(3)  );
capacitor #(.c(9.418e-17)) (*
integer library_binding = "analogLib";

 *)
c3235 ( \4:GND , \AEQ_CNT_ANLG(1)  );
capacitor #(.c(3.66e-17)) (*
integer library_binding = "analogLib";

 *)
c3236 ( \4:GND , \TENBT_FILTER_1p0(0)  );
capacitor #(.c(1.383e-15)) (*
integer library_binding = "analogLib";

 *)
c3237 ( \4:GND , \1:PLL_160_IN  );
capacitor #(.c(7.307e-17)) (*
integer library_binding = "analogLib";

 *)
c3238 ( \4:GND , \4:TX_SLOPETRIM_1p0(1)  );
capacitor #(.c(8.458e-17)) (*
integer library_binding = "analogLib";

 *)
c3239 ( \4:GND , \7:PHASE_IN(9)  );
capacitor #(.c(2.223e-16)) (*
integer library_binding = "analogLib";

 *)
c3240 ( \4:GND , \4:MLT3_TDATA_1p0(0)  );
capacitor #(.c(1.768e-16)) (*
integer library_binding = "analogLib";

 *)
c3241 ( \4:GND , \1:TX_SLP_TRIM(1)  );
capacitor #(.c(1.768e-16)) (*
integer library_binding = "analogLib";

 *)
c3242 ( \4:GND , \1:LEDT  );
capacitor #(.c(3.271e-17)) (*
integer library_binding = "analogLib";

 *)
c3243 ( \4:GND , \5:AEQ_CNT_ANLG(1)  );
capacitor #(.c(1.058e-16)) (*
integer library_binding = "analogLib";

 *)
c3244 ( \4:GND , TIMING_UP_ANLG );
capacitor #(.c(3.227e-16)) (*
integer library_binding = "analogLib";

 *)
c3245 ( \4:GND , \3:MR_SQUELCH_RANGE_2p5(1)  );
capacitor #(.c(3.118e-16)) (*
integer library_binding = "analogLib";

 *)
c3246 ( \4:GND , \5:BLW_DIS_2p5  );
capacitor #(.c(2.791e-16)) (*
integer library_binding = "analogLib";

 *)
c3247 ( \4:GND , \3:TP_DISC_2p5  );
capacitor #(.c(7.757e-16)) (*
integer library_binding = "analogLib";

 *)
c3248 ( \4:GND , \4:PHASE_IN(3)  );
capacitor #(.c(1.062e-15)) (*
integer library_binding = "analogLib";

 *)
c3249 ( \4:GND , \3:ADC_1p0(4)  );
capacitor #(.c(3.13e-16)) (*
integer library_binding = "analogLib";

 *)
c3250 ( \4:GND , X_160 );
capacitor #(.c(6.694e-17)) (*
integer library_binding = "analogLib";

 *)
c3251 ( \4:GND , \4:PHASE_250(5)  );
capacitor #(.c(1.92e-16)) (*
integer library_binding = "analogLib";

 *)
c3252 ( \4:GND , \4:MR_SQUELCH_RANGE_1p0(1)  );
capacitor #(.c(2.438e-16)) (*
integer library_binding = "analogLib";

 *)
c3253 ( \4:GND , \5:WANDER_CNT(6)  );
capacitor #(.c(1.768e-16)) (*
integer library_binding = "analogLib";

 *)
c3254 ( \4:GND , \1:TXC  );
capacitor #(.c(1.768e-16)) (*
integer library_binding = "analogLib";

 *)
c3255 ( \4:GND , \1:RXD(3)  );
capacitor #(.c(2.456e-16)) (*
integer library_binding = "analogLib";

 *)
c3256 ( \4:GND , \MLT3_TDATA_1p0(0)  );
capacitor #(.c(1.187e-16)) (*
integer library_binding = "analogLib";

 *)
c3257 ( \4:GND , \4:B10_DIS  );
capacitor #(.c(1.527e-16)) (*
integer library_binding = "analogLib";

 *)
c3258 ( \4:GND , \4:WANDER_CNT(3)  );
capacitor #(.c(8.421e-17)) (*
integer library_binding = "analogLib";

 *)
c3259 ( \4:GND , \PHASE_250(5)  );
capacitor #(.c(4.777e-17)) (*
integer library_binding = "analogLib";

 *)
c3260 ( \4:GND , \I_REXT_100(2)  );
capacitor #(.c(1.061e-15)) (*
integer library_binding = "analogLib";

 *)
c3261 ( \4:GND , \8:I_REXT_400_TX  );
capacitor #(.c(1.133e-15)) (*
integer library_binding = "analogLib";

 *)
c3262 ( \4:GND , \4:PHASE_IN(10)  );
capacitor #(.c(1.377e-16)) (*
integer library_binding = "analogLib";

 *)
c3263 ( \4:GND , \2:I_REXT_100(6)  );
capacitor #(.c(1.107e-16)) (*
integer library_binding = "analogLib";

 *)
c3264 ( \4:GND , \4:I_REXT_100(4)  );
capacitor #(.c(7.135e-17)) (*
integer library_binding = "analogLib";

 *)
c3265 ( \4:GND , \5:PHASE_IN(1)  );
capacitor #(.c(4.2e-17)) (*
integer library_binding = "analogLib";

 *)
c3266 ( \4:GND , \4:TXER  );
capacitor #(.c(1.768e-16)) (*
integer library_binding = "analogLib";

 *)
c3267 ( \4:GND , \1:PHY(0)  );
capacitor #(.c(3.02e-16)) (*
integer library_binding = "analogLib";

 *)
c3268 ( \4:GND , \7:FLASH_1p0(0)  );
capacitor #(.c(3.238e-16)) (*
integer library_binding = "analogLib";

 *)
c3269 ( \4:GND , \7:ADC_1p0(0)  );
capacitor #(.c(3.279e-16)) (*
integer library_binding = "analogLib";

 *)
c3270 ( \4:GND , RCLK125_1p0 );
capacitor #(.c(7.173e-17)) (*
integer library_binding = "analogLib";

 *)
c3271 ( \4:GND , \3:I_RPOLY_100(2)  );
capacitor #(.c(2.111e-16)) (*
integer library_binding = "analogLib";

 *)
c3272 ( \4:GND , \4:AEQ_CNT_ANLG(0)  );
capacitor #(.c(5.965e-17)) (*
integer library_binding = "analogLib";

 *)
c3273 ( \4:GND , TENBT_CLK160_1p0 );
capacitor #(.c(2.166e-16)) (*
integer library_binding = "analogLib";

 *)
c3274 ( \4:GND , \5:BASEFX_DIS  );
capacitor #(.c(1.015e-15)) (*
integer library_binding = "analogLib";

 *)
c3275 ( \4:GND , \2:PHASE_IN(3)  );
capacitor #(.c(3.162e-16)) (*
integer library_binding = "analogLib";

 *)
c3276 ( \4:GND , \1:PHASE_IN(1)  );
capacitor #(.c(1.117e-16)) (*
integer library_binding = "analogLib";

 *)
c3277 ( \4:GND , \4:I_RPOLY_100(0)  );
capacitor #(.c(3.283e-16)) (*
integer library_binding = "analogLib";

 *)
c3278 ( \4:GND , \TX_SLOPETRIM_1p0(0)  );
capacitor #(.c(7.072e-17)) (*
integer library_binding = "analogLib";

 *)
c3279 ( \4:GND , \7:PHASE_IN(8)  );
capacitor #(.c(1.768e-16)) (*
integer library_binding = "analogLib";

 *)
c3280 ( \4:GND , \1:TX_SLP_TRIM(0)  );
capacitor #(.c(5.677e-17)) (*
integer library_binding = "analogLib";

 *)
c3281 ( \4:GND , RESET_10BT );
capacitor #(.c(1.114e-16)) (*
integer library_binding = "analogLib";

 *)
c3282 ( \4:GND , \AEQ_CNT_ANLG(0)  );
capacitor #(.c(8.675e-17)) (*
integer library_binding = "analogLib";

 *)
c3283 ( \4:GND , \5:TIMING_DN_ANLG  );
capacitor #(.c(1.662e-16)) (*
integer library_binding = "analogLib";

 *)
c3284 ( \4:GND , \7:BASEFX_DIS  );
capacitor #(.c(3.192e-16)) (*
integer library_binding = "analogLib";

 *)
c3285 ( \4:GND , \5:XTAL25  );
capacitor #(.c(4.391e-16)) (*
integer library_binding = "analogLib";

 *)
c3286 ( \4:GND , \3:ADC_1p0(3)  );
capacitor #(.c(5.049e-17)) (*
integer library_binding = "analogLib";

 *)
c3287 ( \4:GND , \4:PHASE_250(4)  );
capacitor #(.c(2.9e-16)) (*
integer library_binding = "analogLib";

 *)
c3288 ( \4:GND , \MR_SQUELCH_RANGE_1p0(0)  );
capacitor #(.c(1.768e-16)) (*
integer library_binding = "analogLib";

 *)
c3289 ( \4:GND , \1:RXD(2)  );
capacitor #(.c(4.226e-16)) (*
integer library_binding = "analogLib";

 *)
c3290 ( \4:GND , \WANDER_CNT(2)  );
capacitor #(.c(9.047e-17)) (*
integer library_binding = "analogLib";

 *)
c3291 ( \4:GND , \PHASE_250(4)  );
capacitor #(.c(5.892e-16)) (*
integer library_binding = "analogLib";

 *)
c3292 ( \4:GND , \6:ADC_1p0(0)  );
capacitor #(.c(1.388e-16)) (*
integer library_binding = "analogLib";

 *)
c3293 ( \4:GND , \2:I_RPOLY_100(0)  );
capacitor #(.c(1.104e-16)) (*
integer library_binding = "analogLib";

 *)
c3294 ( \4:GND , \4:I_REXT_100(3)  );
capacitor #(.c(4.391e-17)) (*
integer library_binding = "analogLib";

 *)
c3295 ( \4:GND , \7:PHASE_IN(10)  );
capacitor #(.c(8.582e-17)) (*
integer library_binding = "analogLib";

 *)
c3296 ( \4:GND , ADC_DIS_2p5 );
capacitor #(.c(1.768e-16)) (*
integer library_binding = "analogLib";

 *)
c3297 ( \4:GND , \1:TXEN  );
capacitor #(.c(1.933e-16)) (*
integer library_binding = "analogLib";

 *)
c3298 ( \4:GND , SLICER_OUT_1p0 );
capacitor #(.c(1.156e-16)) (*
integer library_binding = "analogLib";

 *)
c3299 ( \4:GND , \3:NEG_DETECT_1p0  );
capacitor #(.c(1.768e-16)) (*
integer library_binding = "analogLib";

 *)
c3300 ( \4:GND , \1:CRS  );
capacitor #(.c(1.191e-16)) (*
integer library_binding = "analogLib";

 *)
c3301 ( \4:GND , \PHASE_IN(5)  );
capacitor #(.c(8.255e-16)) (*
integer library_binding = "analogLib";

 *)
c3302 ( \4:GND , \2:PHASE_IN(2)  );
capacitor #(.c(4.76e-16)) (*
integer library_binding = "analogLib";

 *)
c3303 ( \4:GND , \3:XTAL25  );
capacitor #(.c(2.768e-16)) (*
integer library_binding = "analogLib";

 *)
c3304 ( \4:GND , \4:TX_AMPTRIM_1p0(1)  );
capacitor #(.c(4.504e-17)) (*
integer library_binding = "analogLib";

 *)
c3305 ( \4:GND , \7:PHASE_IN(7)  );
capacitor #(.c(1.696e-16)) (*
integer library_binding = "analogLib";

 *)
c3306 ( \4:GND , \TX_SLOPETRIM_1p0(1)  );
capacitor #(.c(3.908e-17)) (*
integer library_binding = "analogLib";

 *)
c3307 ( \4:GND , \TENBT_FILTER_1p0(3)  );
capacitor #(.c(2.254e-16)) (*
integer library_binding = "analogLib";

 *)
c3308 ( \4:GND , \7:RCLK125_1p0  );
capacitor #(.c(1.153e-16)) (*
integer library_binding = "analogLib";

 *)
c3309 ( \4:GND , \6:AEQ_BYPASS  );
capacitor #(.c(1.359e-16)) (*
integer library_binding = "analogLib";

 *)
c3310 ( \4:GND , T2_MODE );
capacitor #(.c(2.216e-16)) (*
integer library_binding = "analogLib";

 *)
c3311 ( \4:GND , \3:MR_SQUELCH_DISB_2p5  );
capacitor #(.c(1.367e-16)) (*
integer library_binding = "analogLib";

 *)
c3312 ( \4:GND , \8:TX100_DIS_2p5  );
capacitor #(.c(8.996e-16)) (*
integer library_binding = "analogLib";

 *)
c3313 ( \4:GND , \2:PHASE_IN(9)  );
capacitor #(.c(2.14e-16)) (*
integer library_binding = "analogLib";

 *)
c3314 ( \4:GND , \6:XTAL25  );
capacitor #(.c(5.811e-17)) (*
integer library_binding = "analogLib";

 *)
c3315 ( \4:GND , \4:PHASE_250(3)  );
capacitor #(.c(2.915e-16)) (*
integer library_binding = "analogLib";

 *)
c3316 ( \4:GND , MR_SQUELCH_DISB_2p5 );
capacitor #(.c(1.071e-16)) (*
integer library_binding = "analogLib";

 *)
c3317 ( \4:GND , \5:WANDER_CNT(4)  );
capacitor #(.c(1.768e-16)) (*
integer library_binding = "analogLib";

 *)
c3318 ( \4:GND , \1:RXD(1)  );
capacitor #(.c(1.768e-16)) (*
integer library_binding = "analogLib";

 *)
c3319 ( \4:GND , \1:MDIO_OUT  );
capacitor #(.c(1.768e-16)) (*
integer library_binding = "analogLib";

 *)
c3320 ( \4:GND , \1:ANLG_TST  );
capacitor #(.c(8.82e-17)) (*
integer library_binding = "analogLib";

 *)
c3321 ( \4:GND , \PHASE_250(3)  );
capacitor #(.c(1.06e-15)) (*
integer library_binding = "analogLib";

 *)
c3322 ( \4:GND , \7:I_REXT_400_TX  );
capacitor #(.c(6.368e-16)) (*
integer library_binding = "analogLib";

 *)
c3323 ( \4:GND , \2:TX100_DIS_2p5  );
capacitor #(.c(1.101e-16)) (*
integer library_binding = "analogLib";

 *)
c3324 ( \4:GND , \4:I_REXT_100(2)  );
capacitor #(.c(1.768e-16)) (*
integer library_binding = "analogLib";

 *)
c3325 ( \4:GND , \1:TXD(4)  );
capacitor #(.c(1.768e-16)) (*
integer library_binding = "analogLib";

 *)
c3326 ( \4:GND , \1:SCAN_MODE  );
capacitor #(.c(1.705e-16)) (*
integer library_binding = "analogLib";

 *)
c3327 ( \4:GND , \MR_SQUELCH_RANGE_1p0(1)  );
capacitor #(.c(1.768e-16)) (*
integer library_binding = "analogLib";

 *)
c3328 ( \4:GND , \1:COL  );
capacitor #(.c(7.927e-17)) (*
integer library_binding = "analogLib";

 *)
c3329 ( \4:GND , RCLK125_TST );
capacitor #(.c(6.972e-17)) (*
integer library_binding = "analogLib";

 *)
c3330 ( \4:GND , \I_RPOLY_100(0)  );
capacitor #(.c(1.006e-16)) (*
integer library_binding = "analogLib";

 *)
c3331 ( \4:GND , \5:ADC_DIS_2p5  );
capacitor #(.c(5.095e-17)) (*
integer library_binding = "analogLib";

 *)
c3332 ( \4:GND , \5:RESET_10BT  );
capacitor #(.c(7.129e-17)) (*
integer library_binding = "analogLib";

 *)
c3333 ( \4:GND , \4:X_125  );
capacitor #(.c(1.341e-16)) (*
integer library_binding = "analogLib";

 *)
c3334 ( \4:GND , \PHASE_IN(7)  );
capacitor #(.c(1.633e-17)) (*
integer library_binding = "analogLib";

 *)
c3335 ( \4:GND , \4:RX10_PRESENT_1p0  );
capacitor #(.c(1.537e-16)) (*
integer library_binding = "analogLib";

 *)
c3336 ( \4:GND , \TEST_MODE(2)  );
capacitor #(.c(5.763e-16)) (*
integer library_binding = "analogLib";

 *)
c3337 ( \4:GND , \1:RCLK125_1p0  );
capacitor #(.c(6.089e-16)) (*
integer library_binding = "analogLib";

 *)
c3338 ( \4:GND , \4:RCLK125_1p0  );
capacitor #(.c(3.651e-16)) (*
integer library_binding = "analogLib";

 *)
c3339 ( \4:GND , MDIO_IN );
capacitor #(.c(3.651e-16)) (*
integer library_binding = "analogLib";

 *)
c3340 ( \4:GND , TXC );
capacitor #(.c(3.651e-16)) (*
integer library_binding = "analogLib";

 *)
c3341 ( \4:GND , RXER );
capacitor #(.c(1.593e-15)) (*
integer library_binding = "analogLib";

 *)
c3342 ( \4:GND , \2:ADC_1p0(3)  );
capacitor #(.c(3.651e-16)) (*
integer library_binding = "analogLib";

 *)
c3343 ( \4:GND , MDINT );
capacitor #(.c(3.651e-16)) (*
integer library_binding = "analogLib";

 *)
c3344 ( \4:GND , \TX_AMP_TRIM(0)  );
capacitor #(.c(3.651e-16)) (*
integer library_binding = "analogLib";

 *)
c3345 ( \4:GND , RXDV );
capacitor #(.c(3.651e-16)) (*
integer library_binding = "analogLib";

 *)
c3346 ( \4:GND , MDC );
capacitor #(.c(7.43e-17)) (*
integer library_binding = "analogLib";

 *)
c3347 ( \4:GND , B10_DIS );
capacitor #(.c(1.645e-16)) (*
integer library_binding = "analogLib";

 *)
c3348 ( \4:GND , TXER );
capacitor #(.c(3.651e-16)) (*
integer library_binding = "analogLib";

 *)
c3349 ( \4:GND , \RXD(4)  );
capacitor #(.c(3.651e-16)) (*
integer library_binding = "analogLib";

 *)
c3350 ( \4:GND , LEDT );
capacitor #(.c(3.651e-16)) (*
integer library_binding = "analogLib";

 *)
c3351 ( \4:GND , \PHY(3)  );
capacitor #(.c(3.651e-16)) (*
integer library_binding = "analogLib";

 *)
c3352 ( \4:GND , TXEN );
capacitor #(.c(3.651e-16)) (*
integer library_binding = "analogLib";

 *)
c3353 ( \4:GND , \RXD(3)  );
capacitor #(.c(1.373e-15)) (*
integer library_binding = "analogLib";

 *)
c3354 ( \4:GND , \FLASH_1p0(0)  );
capacitor #(.c(8.333e-16)) (*
integer library_binding = "analogLib";

 *)
c3355 ( \4:GND , \3:FLASH_1p0(1)  );
capacitor #(.c(3.651e-16)) (*
integer library_binding = "analogLib";

 *)
c3356 ( \4:GND , ANLG_TST );
capacitor #(.c(3.651e-16)) (*
integer library_binding = "analogLib";

 *)
c3357 ( \4:GND , \PHY(2)  );
capacitor #(.c(3.651e-16)) (*
integer library_binding = "analogLib";

 *)
c3358 ( \4:GND , \TXD(4)  );
capacitor #(.c(1.416e-15)) (*
integer library_binding = "analogLib";

 *)
c3359 ( \4:GND , \ADC_1p0(3)  );
capacitor #(.c(3.651e-16)) (*
integer library_binding = "analogLib";

 *)
c3360 ( \4:GND , \RXD(2)  );
capacitor #(.c(8.989e-16)) (*
integer library_binding = "analogLib";

 *)
c3361 ( \4:GND , \2:ADC_1p0(5)  );
capacitor #(.c(9.294e-16)) (*
integer library_binding = "analogLib";

 *)
c3362 ( \4:GND , \3:ADC_1p0(5)  );
capacitor #(.c(3.651e-16)) (*
integer library_binding = "analogLib";

 *)
c3363 ( \4:GND , ANDIS );
capacitor #(.c(3.651e-16)) (*
integer library_binding = "analogLib";

 *)
c3364 ( \4:GND , \PHY(1)  );
capacitor #(.c(3.651e-16)) (*
integer library_binding = "analogLib";

 *)
c3365 ( \4:GND , \TXD(3)  );
capacitor #(.c(8.331e-16)) (*
integer library_binding = "analogLib";

 *)
c3366 ( \4:GND , \ADC_1p0(4)  );
capacitor #(.c(3.651e-16)) (*
integer library_binding = "analogLib";

 *)
c3367 ( \4:GND , CRS );
capacitor #(.c(3.651e-16)) (*
integer library_binding = "analogLib";

 *)
c3368 ( \4:GND , \RXD(1)  );
capacitor #(.c(5.268e-16)) (*
integer library_binding = "analogLib";

 *)
c3369 ( \4:GND , \1:B10_DIS  );
capacitor #(.c(8.502e-16)) (*
integer library_binding = "analogLib";

 *)
c3370 ( \4:GND , \FLASH_1p0(1)  );
capacitor #(.c(3.651e-16)) (*
integer library_binding = "analogLib";

 *)
c3371 ( \4:GND , LEDL );
capacitor #(.c(3.651e-16)) (*
integer library_binding = "analogLib";

 *)
c3372 ( \4:GND , \PHY(0)  );
capacitor #(.c(3.651e-16)) (*
integer library_binding = "analogLib";

 *)
c3373 ( \4:GND , COL );
capacitor #(.c(9.263e-16)) (*
integer library_binding = "analogLib";

 *)
c3374 ( \4:GND , \1:ADC_1p0(4)  );
capacitor #(.c(3.651e-16)) (*
integer library_binding = "analogLib";

 *)
c3375 ( \4:GND , LEDD );
capacitor #(.c(3.651e-16)) (*
integer library_binding = "analogLib";

 *)
c3376 ( \4:GND , MDIO_OUT );
capacitor #(.c(3.651e-16)) (*
integer library_binding = "analogLib";

 *)
c3377 ( \4:GND , \TXD(1)  );
capacitor #(.c(1.401e-15)) (*
integer library_binding = "analogLib";

 *)
c3378 ( \4:GND , \3:FLASH_1p0(0)  );
capacitor #(.c(3.651e-16)) (*
integer library_binding = "analogLib";

 *)
c3379 ( \4:GND , \TX_SLP_TRIM(1)  );
capacitor #(.c(3.651e-16)) (*
integer library_binding = "analogLib";

 *)
c3380 ( \4:GND , LEDC );
capacitor #(.c(3.651e-16)) (*
integer library_binding = "analogLib";

 *)
c3381 ( \4:GND , SCAN_MODE );
capacitor #(.c(6.07e-16)) (*
integer library_binding = "analogLib";

 *)
c3382 ( \4:GND , \2:ADC_1p0(0)  );
capacitor #(.c(5.738e-16)) (*
integer library_binding = "analogLib";

 *)
c3383 ( \4:GND , \3:ADC_1p0(0)  );
capacitor #(.c(3.651e-16)) (*
integer library_binding = "analogLib";

 *)
c3384 ( \4:GND , \TX_SLP_TRIM(0)  );
capacitor #(.c(2.725e-15)) (*
integer library_binding = "analogLib";

 *)
c3385 ( GND, LEDL );
capacitor #(.c(2.725e-15)) (*
integer library_binding = "analogLib";

 *)
c3386 ( GND, \RXD(4)  );
capacitor #(.c(2.725e-15)) (*
integer library_binding = "analogLib";

 *)
c3387 ( GND, \TX_SLP_TRIM(0)  );
capacitor #(.c(7.856e-16)) (*
integer library_binding = "analogLib";

 *)
c3388 ( GND, \5:RESET_10BT  );
capacitor #(.c(1.554e-15)) (*
integer library_binding = "analogLib";

 *)
c3389 ( GND, \5:ADC_DIS_2p5  );
capacitor #(.c(1.08e-15)) (*
integer library_binding = "analogLib";

 *)
c3390 ( GND, \I_RPOLY_100(0)  );
capacitor #(.c(1.227e-15)) (*
integer library_binding = "analogLib";

 *)
c3391 ( GND, RCLK125_TST );
capacitor #(.c(2.725e-15)) (*
integer library_binding = "analogLib";

 *)
c3392 ( GND, \1:COL  );
capacitor #(.c(2.627e-15)) (*
integer library_binding = "analogLib";

 *)
c3393 ( GND, \MR_SQUELCH_RANGE_1p0(1)  );
capacitor #(.c(2.725e-15)) (*
integer library_binding = "analogLib";

 *)
c3394 ( GND, \1:SCAN_MODE  );
capacitor #(.c(2.725e-15)) (*
integer library_binding = "analogLib";

 *)
c3395 ( GND, \1:TXD(4)  );
capacitor #(.c(1.633e-14)) (*
integer library_binding = "analogLib";

 *)
c3396 ( GND, \7:I_REXT_400_TX  );
capacitor #(.c(1.359e-15)) (*
integer library_binding = "analogLib";

 *)
c3397 ( GND, \PHASE_250(3)  );
capacitor #(.c(2.725e-15)) (*
integer library_binding = "analogLib";

 *)
c3398 ( GND, \1:ANLG_TST  );
capacitor #(.c(2.725e-15)) (*
integer library_binding = "analogLib";

 *)
c3399 ( GND, \1:MDIO_OUT  );
capacitor #(.c(2.725e-15)) (*
integer library_binding = "analogLib";

 *)
c3400 ( GND, \1:RXD(1)  );
capacitor #(.c(1.689e-15)) (*
integer library_binding = "analogLib";

 *)
c3401 ( GND, \5:WANDER_CNT(4)  );
capacitor #(.c(4.495e-15)) (*
integer library_binding = "analogLib";

 *)
c3402 ( GND, MR_SQUELCH_DISB_2p5 );
capacitor #(.c(8.955e-16)) (*
integer library_binding = "analogLib";

 *)
c3403 ( GND, \4:PHASE_250(3)  );
capacitor #(.c(3.338e-15)) (*
integer library_binding = "analogLib";

 *)
c3404 ( GND, \6:XTAL25  );
capacitor #(.c(2.725e-15)) (*
integer library_binding = "analogLib";

 *)
c3405 ( GND, MDIO_OUT );
capacitor #(.c(2.107e-15)) (*
integer library_binding = "analogLib";

 *)
c3406 ( GND, \8:TX100_DIS_2p5  );
capacitor #(.c(3.416e-15)) (*
integer library_binding = "analogLib";

 *)
c3407 ( GND, \3:MR_SQUELCH_DISB_2p5  );
capacitor #(.c(3.48e-15)) (*
integer library_binding = "analogLib";

 *)
c3408 ( GND, \7:RCLK125_1p0  );
capacitor #(.c(2.614e-15)) (*
integer library_binding = "analogLib";

 *)
c3409 ( GND, \TX_SLOPETRIM_1p0(1)  );
capacitor #(.c(7.059e-16)) (*
integer library_binding = "analogLib";

 *)
c3410 ( GND, \7:PHASE_IN(7)  );
capacitor #(.c(4.266e-15)) (*
integer library_binding = "analogLib";

 *)
c3411 ( GND, \4:TX_AMPTRIM_1p0(1)  );
capacitor #(.c(5.398e-15)) (*
integer library_binding = "analogLib";

 *)
c3412 ( GND, \1:B10_DIS  );
capacitor #(.c(2.725e-15)) (*
integer library_binding = "analogLib";

 *)
c3413 ( GND, RXDV );
capacitor #(.c(2.725e-15)) (*
integer library_binding = "analogLib";

 *)
c3414 ( GND, \TX_SLP_TRIM(1)  );
capacitor #(.c(1.836e-15)) (*
integer library_binding = "analogLib";

 *)
c3415 ( GND, \PHASE_IN(5)  );
capacitor #(.c(2.725e-15)) (*
integer library_binding = "analogLib";

 *)
c3416 ( GND, \1:CRS  );
capacitor #(.c(1.781e-15)) (*
integer library_binding = "analogLib";

 *)
c3417 ( GND, \3:NEG_DETECT_1p0  );
capacitor #(.c(2.979e-15)) (*
integer library_binding = "analogLib";

 *)
c3418 ( GND, SLICER_OUT_1p0 );
capacitor #(.c(2.725e-15)) (*
integer library_binding = "analogLib";

 *)
c3419 ( GND, \1:TXEN  );
capacitor #(.c(7.229e-16)) (*
integer library_binding = "analogLib";

 *)
c3420 ( GND, \7:PHASE_IN(10)  );
capacitor #(.c(2.725e-15)) (*
integer library_binding = "analogLib";

 *)
c3421 ( GND, \TXD(3)  );
capacitor #(.c(9.08e-15)) (*
integer library_binding = "analogLib";

 *)
c3422 ( GND, \6:ADC_1p0(0)  );
capacitor #(.c(1.398e-15)) (*
integer library_binding = "analogLib";

 *)
c3423 ( GND, \PHASE_250(4)  );
capacitor #(.c(6.513e-15)) (*
integer library_binding = "analogLib";

 *)
c3424 ( GND, \WANDER_CNT(2)  );
capacitor #(.c(2.725e-15)) (*
integer library_binding = "analogLib";

 *)
c3425 ( GND, \1:RXD(2)  );
capacitor #(.c(7.902e-16)) (*
integer library_binding = "analogLib";

 *)
c3426 ( GND, \4:PHASE_250(4)  );
capacitor #(.c(2.725e-15)) (*
integer library_binding = "analogLib";

 *)
c3427 ( GND, \PHY(0)  );
capacitor #(.c(4.919e-15)) (*
integer library_binding = "analogLib";

 *)
c3428 ( GND, \5:XTAL25  );
capacitor #(.c(2.561e-15)) (*
integer library_binding = "analogLib";

 *)
c3429 ( GND, \7:BASEFX_DIS  );
capacitor #(.c(1.727e-15)) (*
integer library_binding = "analogLib";

 *)
c3430 ( GND, \AEQ_CNT_ANLG(0)  );
capacitor #(.c(2.725e-15)) (*
integer library_binding = "analogLib";

 *)
c3431 ( GND, \1:TX_SLP_TRIM(0)  );
capacitor #(.c(5.06e-15)) (*
integer library_binding = "analogLib";

 *)
c3432 ( GND, \TX_SLOPETRIM_1p0(0)  );
capacitor #(.c(2.725e-15)) (*
integer library_binding = "analogLib";

 *)
c3433 ( GND, RXER );
capacitor #(.c(9.196e-16)) (*
integer library_binding = "analogLib";

 *)
c3434 ( GND, TENBT_CLK160_1p0 );
capacitor #(.c(1.111e-15)) (*
integer library_binding = "analogLib";

 *)
c3435 ( GND, \3:I_RPOLY_100(2)  );
capacitor #(.c(5.053e-15)) (*
integer library_binding = "analogLib";

 *)
c3436 ( GND, RCLK125_1p0 );
capacitor #(.c(4.989e-15)) (*
integer library_binding = "analogLib";

 *)
c3437 ( GND, \7:ADC_1p0(0)  );
capacitor #(.c(4.654e-15)) (*
integer library_binding = "analogLib";

 *)
c3438 ( GND, \7:FLASH_1p0(0)  );
capacitor #(.c(2.725e-15)) (*
integer library_binding = "analogLib";

 *)
c3439 ( GND, \1:PHY(0)  );
capacitor #(.c(6.472e-16)) (*
integer library_binding = "analogLib";

 *)
c3440 ( GND, \4:TXER  );
capacitor #(.c(2.725e-15)) (*
integer library_binding = "analogLib";

 *)
c3441 ( GND, \TXD(4)  );
capacitor #(.c(1.636e-14)) (*
integer library_binding = "analogLib";

 *)
c3442 ( GND, \8:I_REXT_400_TX  );
capacitor #(.c(1.298e-15)) (*
integer library_binding = "analogLib";

 *)
c3443 ( GND, \PHASE_250(5)  );
capacitor #(.c(2.367e-15)) (*
integer library_binding = "analogLib";

 *)
c3444 ( GND, \4:WANDER_CNT(3)  );
capacitor #(.c(1.829e-15)) (*
integer library_binding = "analogLib";

 *)
c3445 ( GND, \4:B10_DIS  );
capacitor #(.c(3.784e-15)) (*
integer library_binding = "analogLib";

 *)
c3446 ( GND, \MLT3_TDATA_1p0(0)  );
capacitor #(.c(2.725e-15)) (*
integer library_binding = "analogLib";

 *)
c3447 ( GND, \1:RXD(3)  );
capacitor #(.c(2.725e-15)) (*
integer library_binding = "analogLib";

 *)
c3448 ( GND, \1:TXC  );
capacitor #(.c(3.768e-15)) (*
integer library_binding = "analogLib";

 *)
c3449 ( GND, \5:WANDER_CNT(6)  );
capacitor #(.c(2.725e-15)) (*
integer library_binding = "analogLib";

 *)
c3450 ( GND, \PHY(1)  );
capacitor #(.c(4.308e-15)) (*
integer library_binding = "analogLib";

 *)
c3451 ( GND, \3:TP_DISC_2p5  );
capacitor #(.c(4.82e-15)) (*
integer library_binding = "analogLib";

 *)
c3452 ( GND, \5:BLW_DIS_2p5  );
capacitor #(.c(4.976e-15)) (*
integer library_binding = "analogLib";

 *)
c3453 ( GND, \3:MR_SQUELCH_RANGE_2p5(1)  );
capacitor #(.c(5.09e-16)) (*
integer library_binding = "analogLib";

 *)
c3454 ( GND, \5:AEQ_CNT_ANLG(1)  );
capacitor #(.c(2.725e-15)) (*
integer library_binding = "analogLib";

 *)
c3455 ( GND, \1:LEDT  );
capacitor #(.c(2.725e-15)) (*
integer library_binding = "analogLib";

 *)
c3456 ( GND, \1:TX_SLP_TRIM(1)  );
capacitor #(.c(3.436e-15)) (*
integer library_binding = "analogLib";

 *)
c3457 ( GND, \4:MLT3_TDATA_1p0(0)  );
capacitor #(.c(1.126e-15)) (*
integer library_binding = "analogLib";

 *)
c3458 ( GND, \4:TX_SLOPETRIM_1p0(1)  );
capacitor #(.c(2.725e-15)) (*
integer library_binding = "analogLib";

 *)
c3459 ( GND, LEDT );
capacitor #(.c(5.648e-16)) (*
integer library_binding = "analogLib";

 *)
c3460 ( GND, \TENBT_FILTER_1p0(0)  );
capacitor #(.c(1.128e-15)) (*
integer library_binding = "analogLib";

 *)
c3461 ( GND, \I_RPOLY_100(3)  );
capacitor #(.c(2.125e-15)) (*
integer library_binding = "analogLib";

 *)
c3462 ( GND, RESET_DSP );
capacitor #(.c(5.891e-15)) (*
integer library_binding = "analogLib";

 *)
c3463 ( GND, \7:FLASH_1p0(1)  );
capacitor #(.c(2.725e-15)) (*
integer library_binding = "analogLib";

 *)
c3464 ( GND, \1:PHY(1)  );
capacitor #(.c(3.912e-15)) (*
integer library_binding = "analogLib";

 *)
c3465 ( GND, \3:TX_AMPTRIM_1p0(0)  );
capacitor #(.c(3.557e-15)) (*
integer library_binding = "analogLib";

 *)
c3466 ( GND, \6:AEQ_DIS_2p5  );
capacitor #(.c(2.725e-15)) (*
integer library_binding = "analogLib";

 *)
c3467 ( GND, TXEN );
capacitor #(.c(3.515e-15)) (*
integer library_binding = "analogLib";

 *)
c3468 ( GND, \6:PHASE_IN(10)  );
capacitor #(.c(2.878e-15)) (*
integer library_binding = "analogLib";

 *)
c3469 ( GND, \6:I_REXT_50(0)  );
capacitor #(.c(1.018e-15)) (*
integer library_binding = "analogLib";

 *)
c3470 ( GND, \I_REXT_100(3)  );
capacitor #(.c(1.002e-15)) (*
integer library_binding = "analogLib";

 *)
c3471 ( GND, \PHASE_250(6)  );
capacitor #(.c(4.04e-15)) (*
integer library_binding = "analogLib";

 *)
c3472 ( GND, \WANDER_CNT(4)  );
capacitor #(.c(2.725e-15)) (*
integer library_binding = "analogLib";

 *)
c3473 ( GND, \1:RXD(4)  );
capacitor #(.c(1.132e-15)) (*
integer library_binding = "analogLib";

 *)
c3474 ( GND, \3:XTAL25_1p0  );
capacitor #(.c(8.588e-16)) (*
integer library_binding = "analogLib";

 *)
c3475 ( GND, \4:PHASE_250(6)  );
capacitor #(.c(2.725e-15)) (*
integer library_binding = "analogLib";

 *)
c3476 ( GND, \PHY(2)  );
capacitor #(.c(6.009e-15)) (*
integer library_binding = "analogLib";

 *)
c3477 ( GND, TX100_DIS_2p5 );
capacitor #(.c(8.675e-15)) (*
integer library_binding = "analogLib";

 *)
c3478 ( GND, \6:FLASH_1p0(0)  );
capacitor #(.c(2.725e-15)) (*
integer library_binding = "analogLib";

 *)
c3479 ( GND, \1:MDC  );
capacitor #(.c(2.352e-15)) (*
integer library_binding = "analogLib";

 *)
c3480 ( GND, \6:RESET_DSP  );
capacitor #(.c(2.084e-15)) (*
integer library_binding = "analogLib";

 *)
c3481 ( GND, \WANDER_CNT(0)  );
capacitor #(.c(3.268e-15)) (*
integer library_binding = "analogLib";

 *)
c3482 ( GND, \4:PLL_160_IN  );
capacitor #(.c(2.725e-15)) (*
integer library_binding = "analogLib";

 *)
c3483 ( GND, ANDIS );
capacitor #(.c(2.725e-15)) (*
integer library_binding = "analogLib";

 *)
c3484 ( GND, MDC );
capacitor #(.c(2.725e-15)) (*
integer library_binding = "analogLib";

 *)
c3485 ( GND, SCAN_MODE );
capacitor #(.c(3.166e-15)) (*
integer library_binding = "analogLib";

 *)
c3486 ( GND, \6:PHASE_IN(8)  );
capacitor #(.c(5.413e-16)) (*
integer library_binding = "analogLib";

 *)
c3487 ( GND, \5:TENBT_FILTER_1p0(1)  );
capacitor #(.c(1.157e-15)) (*
integer library_binding = "analogLib";

 *)
c3488 ( GND, \3:I_RPOLY_100(4)  );
capacitor #(.c(1.193e-15)) (*
integer library_binding = "analogLib";

 *)
c3489 ( GND, \5:POS_DETECT_2p5  );
capacitor #(.c(2.725e-15)) (*
integer library_binding = "analogLib";

 *)
c3490 ( GND, \1:PHY(2)  );
capacitor #(.c(4.453e-15)) (*
integer library_binding = "analogLib";

 *)
c3491 ( GND, \TX_AMPTRIM_1p0(1)  );
capacitor #(.c(3.586e-15)) (*
integer library_binding = "analogLib";

 *)
c3492 ( GND, TP_DISC_2p5 );
capacitor #(.c(2.725e-15)) (*
integer library_binding = "analogLib";

 *)
c3493 ( GND, \RXD(1)  );
capacitor #(.c(7.326e-16)) (*
integer library_binding = "analogLib";

 *)
c3494 ( GND, TXER );
capacitor #(.c(1.93e-15)) (*
integer library_binding = "analogLib";

 *)
c3495 ( GND, \PHASE_IN(1)  );
capacitor #(.c(4.454e-15)) (*
integer library_binding = "analogLib";

 *)
c3496 ( GND, \6:ADC_1p0(3)  );
capacitor #(.c(1.033e-15)) (*
integer library_binding = "analogLib";

 *)
c3497 ( GND, \I_REXT_100(4)  );
capacitor #(.c(4.047e-17)) (*
integer library_binding = "analogLib";

 *)
c3498 ( GND, BASEFX_DIS );
capacitor #(.c(2.725e-15)) (*
integer library_binding = "analogLib";

 *)
c3499 ( GND, \1:RXDV  );
capacitor #(.c(2.725e-15)) (*
integer library_binding = "analogLib";

 *)
c3500 ( GND, \1:TXD(1)  );
capacitor #(.c(2.281e-15)) (*
integer library_binding = "analogLib";

 *)
c3501 ( GND, X_125 );
capacitor #(.c(2.725e-15)) (*
integer library_binding = "analogLib";

 *)
c3502 ( GND, COL );
capacitor #(.c(2.725e-15)) (*
integer library_binding = "analogLib";

 *)
c3503 ( GND, \PHY(3)  );
capacitor #(.c(2.725e-15)) (*
integer library_binding = "analogLib";

 *)
c3504 ( GND, TXC );
capacitor #(.c(6.045e-14)) (*
integer library_binding = "analogLib";

 *)
c3505 ( GND, \24:VDDTX  );
capacitor #(.c(2.675e-15)) (*
integer library_binding = "analogLib";

 *)
c3506 ( GND, \6:FLASH_1p0(1)  );
capacitor #(.c(1.485e-15)) (*
integer library_binding = "analogLib";

 *)
c3507 ( GND, \PHASE_250(10)  );
capacitor #(.c(2.725e-15)) (*
integer library_binding = "analogLib";

 *)
c3508 ( GND, \1:MDINT  );
capacitor #(.c(1.43e-15)) (*
integer library_binding = "analogLib";

 *)
c3509 ( GND, RX10_PRESENT_1p0 );
capacitor #(.c(3.061e-15)) (*
integer library_binding = "analogLib";

 *)
c3510 ( GND, \3:TEST_MODE(2)  );
capacitor #(.c(8.417e-16)) (*
integer library_binding = "analogLib";

 *)
c3511 ( GND, \4:PHASE_250(10)  );
capacitor #(.c(5.337e-14)) (*
integer library_binding = "analogLib";

 *)
c3512 ( GND, \25:VDDTX  );
capacitor #(.c(2.725e-15)) (*
integer library_binding = "analogLib";

 *)
c3513 ( GND, ANLG_TST );
capacitor #(.c(2.725e-15)) (*
integer library_binding = "analogLib";

 *)
c3514 ( GND, MDINT );
capacitor #(.c(3.157e-15)) (*
integer library_binding = "analogLib";

 *)
c3515 ( GND, \PHASE_IN(9)  );
capacitor #(.c(5.881e-16)) (*
integer library_binding = "analogLib";

 *)
c3516 ( GND, \TENBT_FILTER_1p0(2)  );
capacitor #(.c(1.788e-15)) (*
integer library_binding = "analogLib";

 *)
c3517 ( GND, \I_RPOLY_100(5)  );
capacitor #(.c(4.178e-15)) (*
integer library_binding = "analogLib";

 *)
c3518 ( GND, \7:ADC_1p0(3)  );
capacitor #(.c(2.725e-15)) (*
integer library_binding = "analogLib";

 *)
c3519 ( GND, \1:LEDC  );
capacitor #(.c(2.725e-15)) (*
integer library_binding = "analogLib";

 *)
c3520 ( GND, \1:PHY(3)  );
capacitor #(.c(2.725e-15)) (*
integer library_binding = "analogLib";

 *)
c3521 ( GND, \1:TX_AMP_TRIM(0)  );
capacitor #(.c(1.853e-15)) (*
integer library_binding = "analogLib";

 *)
c3522 ( GND, \9:TX100_DIS_2p5  );
capacitor #(.c(2.725e-15)) (*
integer library_binding = "analogLib";

 *)
c3523 ( GND, LEDC );
capacitor #(.c(2.725e-15)) (*
integer library_binding = "analogLib";

 *)
c3524 ( GND, \RXD(2)  );
capacitor #(.c(2.725e-15)) (*
integer library_binding = "analogLib";

 *)
c3525 ( GND, \TX_AMP_TRIM(0)  );
capacitor #(.c(3.394e-15)) (*
integer library_binding = "analogLib";

 *)
c3526 ( GND, \6:PHASE_IN(2)  );
capacitor #(.c(1.405e-14)) (*
integer library_binding = "analogLib";

 *)
c3527 ( GND, \6:ADC_1p0(4)  );
capacitor #(.c(1.702e-15)) (*
integer library_binding = "analogLib";

 *)
c3528 ( GND, \PHASE_250(8)  );
capacitor #(.c(6.652e-15)) (*
integer library_binding = "analogLib";

 *)
c3529 ( GND, \WANDER_CNT(6)  );
capacitor #(.c(2.312e-15)) (*
integer library_binding = "analogLib";

 *)
c3530 ( GND, MR_SQUELCH_DISB_1p0 );
capacitor #(.c(2.725e-15)) (*
integer library_binding = "analogLib";

 *)
c3531 ( GND, \1:RXER  );
capacitor #(.c(4.759e-15)) (*
integer library_binding = "analogLib";

 *)
c3532 ( GND, \3:X_160  );
capacitor #(.c(1.252e-15)) (*
integer library_binding = "analogLib";

 *)
c3533 ( GND, \4:PHASE_250(8)  );
capacitor #(.c(2.565e-15)) (*
integer library_binding = "analogLib";

 *)
c3534 ( GND, \4:SLICER_OUT_1p0  );
capacitor #(.c(4.201e-15)) (*
integer library_binding = "analogLib";

 *)
c3535 ( GND, \3:TXER  );
capacitor #(.c(2.725e-15)) (*
integer library_binding = "analogLib";

 *)
c3536 ( GND, CRS );
capacitor #(.c(6.159e-15)) (*
integer library_binding = "analogLib";

 *)
c3537 ( GND, X10_DIS_2p5 );
capacitor #(.c(1.491e-15)) (*
integer library_binding = "analogLib";

 *)
c3538 ( GND, \3:PHASE_250(1)  );
capacitor #(.c(1.508e-15)) (*
integer library_binding = "analogLib";

 *)
c3539 ( GND, \5:AEQ_CNT_ANLG(4)  );
capacitor #(.c(2.725e-15)) (*
integer library_binding = "analogLib";

 *)
c3540 ( GND, \1:MDIO_IN  );
capacitor #(.c(2.011e-15)) (*
integer library_binding = "analogLib";

 *)
c3541 ( GND, TIMING_DN_ANLG );
capacitor #(.c(3.171e-15)) (*
integer library_binding = "analogLib";

 *)
c3542 ( GND, \5:WANDER_CNT(2)  );
capacitor #(.c(5.045e-15)) (*
integer library_binding = "analogLib";

 *)
c3543 ( GND, \4:MLT3_TDATA_2p5(1)  );
capacitor #(.c(1.167e-15)) (*
integer library_binding = "analogLib";

 *)
c3544 ( GND, \PHASE_250(1)  );
capacitor #(.c(8.411e-16)) (*
integer library_binding = "analogLib";

 *)
c3545 ( GND, POS_DETECT_2p5 );
capacitor #(.c(4.101e-15)) (*
integer library_binding = "analogLib";

 *)
c3546 ( GND, \7:X10_DIS_2p5  );
capacitor #(.c(2.725e-15)) (*
integer library_binding = "analogLib";

 *)
c3547 ( GND, MDIO_IN );
capacitor #(.c(1.839e-14)) (*
integer library_binding = "analogLib";

 *)
c3548 ( GND, PLL_160_IN );
capacitor #(.c(5.419e-16)) (*
integer library_binding = "analogLib";

 *)
c3549 ( GND, \5:TENBT_FILTER_1p0(3)  );
capacitor #(.c(8.697e-16)) (*
integer library_binding = "analogLib";

 *)
c3550 ( GND, \AEQ_CNT_ANLG(4)  );
capacitor #(.c(3.115e-15)) (*
integer library_binding = "analogLib";

 *)
c3551 ( GND, \5:MR_BYPASS10RX_FILTER  );
capacitor #(.c(5.431e-15)) (*
integer library_binding = "analogLib";

 *)
c3552 ( GND, \7:ADC_1p0(4)  );
capacitor #(.c(2.725e-15)) (*
integer library_binding = "analogLib";

 *)
c3553 ( GND, \1:LEDD  );
capacitor #(.c(1.189e-15)) (*
integer library_binding = "analogLib";

 *)
c3554 ( GND, \9:BASEFX_DIS  );
capacitor #(.c(2.803e-15)) (*
integer library_binding = "analogLib";

 *)
c3555 ( GND, \5:TXER  );
capacitor #(.c(3.917e-15)) (*
integer library_binding = "analogLib";

 *)
c3556 ( GND, \7:I_REXT_50(0)  );
capacitor #(.c(2.725e-15)) (*
integer library_binding = "analogLib";

 *)
c3557 ( GND, LEDD );
capacitor #(.c(2.725e-15)) (*
integer library_binding = "analogLib";

 *)
c3558 ( GND, \RXD(3)  );
capacitor #(.c(3.236e-15)) (*
integer library_binding = "analogLib";

 *)
c3559 ( GND, \PHASE_IN(3)  );
capacitor #(.c(5.726e-15)) (*
integer library_binding = "analogLib";

 *)
c3560 ( GND, \MLT3_TDATA_2p5(1)  );
capacitor #(.c(1.042e-14)) (*
integer library_binding = "analogLib";

 *)
c3561 ( GND, \6:ADC_1p0(5)  );
capacitor #(.c(1.065e-15)) (*
integer library_binding = "analogLib";

 *)
c3562 ( GND, \I_REXT_100(6)  );
capacitor #(.c(1.663e-15)) (*
integer library_binding = "analogLib";

 *)
c3563 ( GND, \3:PHASE_250(9)  );
capacitor #(.c(4.224e-15)) (*
integer library_binding = "analogLib";

 *)
c3564 ( GND, \3:MR_SQUELCH_RANGE_1p0(0)  );
capacitor #(.c(2.725e-15)) (*
integer library_binding = "analogLib";

 *)
c3565 ( GND, \1:TXD(3)  );
capacitor #(.c(1.772e-15)) (*
integer library_binding = "analogLib";

 *)
c3566 ( GND, \PHASE_250(9)  );
capacitor #(.c(2.725e-15)) (*
integer library_binding = "analogLib";

 *)
c3567 ( GND, \TXD(1)  );
capacitor #(.c(5.483e-16)) (*
integer library_binding = "analogLib";

 *)
c3568 ( GND, \5:BASE10_TX_DIS_1p0  );
capacitor #(.c(1.422e-15)) (*
integer library_binding = "analogLib";

 *)
c3569 ( GND, \PHASE_250(2)  );
capacitor #(.c(2.182e-15)) (*
integer library_binding = "analogLib";

 *)
c3570 ( GND, \4:WANDER_CNT(0)  );
capacitor #(.c(2.725e-15)) (*
integer library_binding = "analogLib";

 *)
c3571 ( GND, \1:ANDIS  );
capacitor #(.c(1.517e-15)) (*
integer library_binding = "analogLib";

 *)
c3572 ( GND, \6:TIMING_UP_ANLG  );
capacitor #(.c(1.251e-15)) (*
integer library_binding = "analogLib";

 *)
c3573 ( GND, \WANDER_CNT(3)  );
capacitor #(.c(9.45e-16)) (*
integer library_binding = "analogLib";

 *)
c3574 ( GND, \4:PHASE_250(2)  );
capacitor #(.c(1.195e-15)) (*
integer library_binding = "analogLib";

 *)
c3575 ( GND, \4:RCLK125_TST  );
capacitor #(.c(8.902e-16)) (*
integer library_binding = "analogLib";

 *)
c3576 ( GND, B10_DIS );
capacitor #(.c(4.414e-15)) (*
integer library_binding = "analogLib";

 *)
c3577 ( GND, AEQ_DIS_2p5 );
capacitor #(.c(1.743e-16)) (*
integer library_binding = "analogLib";

 *)
c3578 ( GND, AEQ_BYPASS );
capacitor #(.c(5.842e-15)) (*
integer library_binding = "analogLib";

 *)
c3579 ( GND, \7:ADC_1p0(5)  );
capacitor #(.c(2.725e-15)) (*
integer library_binding = "analogLib";

 *)
c3580 ( GND, \1:LEDL  );
capacitor #(.c(4.784e-15)) (*
integer library_binding = "analogLib";

 *)
c3581 ( GND, \3:POS_DETECT_1p0  );
capacitor #(.c(5.138e-15)) (*
integer library_binding = "analogLib";

 *)
c3582 ( GND, \3:TX_SLOPETRIM_1p0(0)  );
capacitor #(.c(5.182e-15)) (*
integer library_binding = "analogLib";

 *)
c3583 ( GND, BLW_DIS_2p5 );
capacitor #(.c(3.77e-15)) (*
integer library_binding = "analogLib";

 *)
c3584 ( GND, \TX_AMPTRIM_1p0(0)  );
capacitor #(.c(3.406e-15)) (*
integer library_binding = "analogLib";

 *)
c3585 ( GND, \5:BASEFX_DIS  );
capacitor #(.c(4.1e-15)) (*
integer library_binding = "analogLib";

 *)
c3586 ( GND, \ADC_1p0(3)  );
capacitor #(.c(4.161e-15)) (*
integer library_binding = "analogLib";

 *)
c3587 ( GND, \ADC_1p0(4)  );
capacitor #(.c(6.151e-15)) (*
integer library_binding = "analogLib";

 *)
c3588 ( GND, \3:FLASH_1p0(0)  );
capacitor #(.c(4.036e-15)) (*
integer library_binding = "analogLib";

 *)
c3589 ( GND, \3:ADC_1p0(0)  );
capacitor #(.c(5.098e-15)) (*
integer library_binding = "analogLib";

 *)
c3590 ( GND, \3:FLASH_1p0(1)  );
capacitor #(.c(5.05e-15)) (*
integer library_binding = "analogLib";

 *)
c3591 ( GND, \3:ADC_1p0(5)  );
capacitor #(.c(5.515e-15)) (*
integer library_binding = "analogLib";

 *)
c3592 ( GND, \2:ADC_1p0(0)  );
capacitor #(.c(7.732e-15)) (*
integer library_binding = "analogLib";

 *)
c3593 ( GND, \1:RCLK125_1p0  );
capacitor #(.c(4.344e-15)) (*
integer library_binding = "analogLib";

 *)
c3594 ( GND, \2:ADC_1p0(3)  );
capacitor #(.c(5.787e-15)) (*
integer library_binding = "analogLib";

 *)
c3595 ( GND, \FLASH_1p0(0)  );
capacitor #(.c(5.455e-15)) (*
integer library_binding = "analogLib";

 *)
c3596 ( GND, \2:ADC_1p0(5)  );
capacitor #(.c(6.341e-15)) (*
integer library_binding = "analogLib";

 *)
c3597 ( GND, \FLASH_1p0(1)  );
capacitor #(.c(6.187e-15)) (*
integer library_binding = "analogLib";

 *)
c3598 ( GND, \1:ADC_1p0(4)  );
capacitor #(.c(1.751e-14)) (*
integer library_binding = "analogLib";

 *)
c3599 ( GND, \4:PHASE_IN(10)  );
capacitor #(.c(9.42e-15)) (*
integer library_binding = "analogLib";

 *)
c3600 ( GND, \5:PHASE_IN(7)  );
capacitor #(.c(1.2e-14)) (*
integer library_binding = "analogLib";

 *)
c3601 ( GND, \4:PHASE_IN(3)  );
capacitor #(.c(1.002e-14)) (*
integer library_binding = "analogLib";

 *)
c3602 ( GND, \4:PHASE_IN(8)  );
capacitor #(.c(9.342e-15)) (*
integer library_binding = "analogLib";

 *)
c3603 ( GND, \2:PHASE_IN(5)  );
capacitor #(.c(1.02e-14)) (*
integer library_binding = "analogLib";

 *)
c3604 ( GND, \4:PHASE_IN(2)  );
capacitor #(.c(1.03e-14)) (*
integer library_binding = "analogLib";

 *)
c3605 ( GND, \3:X10_DIS_2p5  );
capacitor #(.c(9.888e-15)) (*
integer library_binding = "analogLib";

 *)
c3606 ( GND, \2:TX100_DIS_2p5  );
capacitor #(.c(2.033e-14)) (*
integer library_binding = "analogLib";

 *)
c3607 ( GND, \PHASE_IN(10)  );
capacitor #(.c(1.567e-14)) (*
integer library_binding = "analogLib";

 *)
c3608 ( GND, \2:PHASE_IN(3)  );
capacitor #(.c(1.273e-14)) (*
integer library_binding = "analogLib";

 *)
c3609 ( GND, \2:PHASE_IN(2)  );
capacitor #(.c(1.25e-14)) (*
integer library_binding = "analogLib";

 *)
c3610 ( GND, \PHASE_IN(8)  );
capacitor #(.c(1.342e-14)) (*
integer library_binding = "analogLib";

 *)
c3611 ( GND, \3:PHASE_IN(7)  );
capacitor #(.c(1.076e-14)) (*
integer library_binding = "analogLib";

 *)
c3612 ( GND, \1:PHASE_IN(5)  );
capacitor #(.c(1.344e-14)) (*
integer library_binding = "analogLib";

 *)
c3613 ( GND, \I_REXT_50(0)  );
capacitor #(.c(7.407e-15)) (*
integer library_binding = "analogLib";

 *)
c3614 ( GND, \2:I_REXT_50(0)  );
capacitor #(.c(7.355e-15)) (*
integer library_binding = "analogLib";

 *)
c3615 ( GND, \3:XTAL25  );
capacitor #(.c(2.124e-15)) (*
integer library_binding = "analogLib";

 *)
c3616 ( GND, \2:I_REXT_100(2)  );
capacitor #(.c(2.159e-15)) (*
integer library_binding = "analogLib";

 *)
c3617 ( GND, \2:I_REXT_100(3)  );
capacitor #(.c(2.156e-15)) (*
integer library_binding = "analogLib";

 *)
c3618 ( GND, \2:I_REXT_100(4)  );
capacitor #(.c(2.135e-15)) (*
integer library_binding = "analogLib";

 *)
c3619 ( GND, \2:I_REXT_100(6)  );
capacitor #(.c(2.153e-15)) (*
integer library_binding = "analogLib";

 *)
c3620 ( GND, \2:I_RPOLY_100(0)  );
capacitor #(.c(2.203e-15)) (*
integer library_binding = "analogLib";

 *)
c3621 ( GND, \I_RPOLY_100(2)  );
capacitor #(.c(2.219e-15)) (*
integer library_binding = "analogLib";

 *)
c3622 ( GND, \2:I_RPOLY_100(3)  );
capacitor #(.c(2.361e-15)) (*
integer library_binding = "analogLib";

 *)
c3623 ( GND, \2:I_RPOLY_100(4)  );
capacitor #(.c(7.438e-15)) (*
integer library_binding = "analogLib";

 *)
c3624 ( GND, \2:I_RPOLY_100(5)  );
capacitor #(.c(1.637e-14)) (*
integer library_binding = "analogLib";

 *)
c3625 ( GND, \3:ADC_1p0(4)  );
capacitor #(.c(6.874e-15)) (*
integer library_binding = "analogLib";

 *)
c3626 ( GND, \3:ADC_1p0(3)  );
capacitor #(.c(1.223e-14)) (*
integer library_binding = "analogLib";

 *)
c3627 ( GND, \4:FLASH_1p0(0)  );
capacitor #(.c(1.148e-14)) (*
integer library_binding = "analogLib";

 *)
c3628 ( GND, \ADC_1p0(0)  );
capacitor #(.c(8.451e-15)) (*
integer library_binding = "analogLib";

 *)
c3629 ( GND, \4:RCLK125_1p0  );
capacitor #(.c(6.413e-15)) (*
integer library_binding = "analogLib";

 *)
c3630 ( GND, \4:FLASH_1p0(1)  );
capacitor #(.c(1.392e-14)) (*
integer library_binding = "analogLib";

 *)
c3631 ( GND, \ADC_1p0(5)  );
capacitor #(.c(4.726e-15)) (*
integer library_binding = "analogLib";

 *)
c3632 ( GND, \4:PHASE_IN(9)  );
capacitor #(.c(3.642e-15)) (*
integer library_binding = "analogLib";

 *)
c3633 ( GND, \2:PHASE_IN(1)  );
capacitor #(.c(1.387e-14)) (*
integer library_binding = "analogLib";

 *)
c3634 ( GND, \2:PHASE_IN(9)  );
capacitor #(.c(2.133e-14)) (*
integer library_binding = "analogLib";

 *)
c3635 ( GND, \1:PLL_160_IN  );
capacitor #(.c(4.876e-15)) (*
integer library_binding = "analogLib";

 *)
c3636 ( GND, \1:PHASE_IN(1)  );
capacitor #(.c(5.457e-15)) (*
integer library_binding = "analogLib";

 *)
c3637 ( GND, \4:I_RPOLY_100(5)  );
capacitor #(.c(1.854e-15)) (*
integer library_binding = "analogLib";

 *)
c3638 ( GND, \I_RPOLY_100(4)  );
capacitor #(.c(1.816e-15)) (*
integer library_binding = "analogLib";

 *)
c3639 ( GND, \4:I_RPOLY_100(3)  );
capacitor #(.c(1.797e-15)) (*
integer library_binding = "analogLib";

 *)
c3640 ( GND, \4:I_RPOLY_100(2)  );
capacitor #(.c(1.783e-15)) (*
integer library_binding = "analogLib";

 *)
c3641 ( GND, \4:I_RPOLY_100(0)  );
capacitor #(.c(1.778e-15)) (*
integer library_binding = "analogLib";

 *)
c3642 ( GND, \4:I_REXT_100(6)  );
capacitor #(.c(1.767e-15)) (*
integer library_binding = "analogLib";

 *)
c3643 ( GND, \4:I_REXT_100(4)  );
capacitor #(.c(1.763e-15)) (*
integer library_binding = "analogLib";

 *)
c3644 ( GND, \4:I_REXT_100(3)  );
capacitor #(.c(1.758e-15)) (*
integer library_binding = "analogLib";

 *)
c3645 ( GND, \4:I_REXT_100(2)  );
capacitor #(.c(4.833e-15)) (*
integer library_binding = "analogLib";

 *)
c3646 ( GND, X_160 );
capacitor #(.c(1.11e-15)) (*
integer library_binding = "analogLib";

 *)
c3647 ( GND, \4:X_125  );
capacitor #(.c(2.439e-15)) (*
integer library_binding = "analogLib";

 *)
c3648 ( GND, XTAL25_1p0 );
capacitor #(.c(2.38e-15)) (*
integer library_binding = "analogLib";

 *)
c3649 ( GND, \TEST_MODE(2)  );
capacitor #(.c(1.68e-15)) (*
integer library_binding = "analogLib";

 *)
c3650 ( GND, \6:RX10_PRESENT_2p5  );
capacitor #(.c(2.625e-16)) (*
integer library_binding = "analogLib";

 *)
c3651 ( GND, \4:RX10_PRESENT_1p0  );
capacitor #(.c(4.826e-15)) (*
integer library_binding = "analogLib";

 *)
c3652 ( GND, POS_DETECT_1p0 );
capacitor #(.c(1.323e-15)) (*
integer library_binding = "analogLib";

 *)
c3653 ( GND, \7:PHASE_IN(9)  );
capacitor #(.c(1.109e-15)) (*
integer library_binding = "analogLib";

 *)
c3654 ( GND, \7:PHASE_IN(8)  );
capacitor #(.c(1.245e-15)) (*
integer library_binding = "analogLib";

 *)
c3655 ( GND, \5:PHASE_IN(5)  );
capacitor #(.c(1.006e-15)) (*
integer library_binding = "analogLib";

 *)
c3656 ( GND, \7:PHASE_IN(3)  );
capacitor #(.c(1.256e-15)) (*
integer library_binding = "analogLib";

 *)
c3657 ( GND, \PHASE_IN(2)  );
capacitor #(.c(1.146e-15)) (*
integer library_binding = "analogLib";

 *)
c3658 ( GND, \5:PHASE_IN(1)  );
capacitor #(.c(1.038e-15)) (*
integer library_binding = "analogLib";

 *)
c3659 ( GND, \4:PHASE_250(5)  );
capacitor #(.c(3.038e-15)) (*
integer library_binding = "analogLib";

 *)
c3660 ( GND, NEG_DETECT_1p0 );
capacitor #(.c(4.073e-15)) (*
integer library_binding = "analogLib";

 *)
c3661 ( GND, \MR_SQUELCH_RANGE_2p5(1)  );
capacitor #(.c(2.968e-15)) (*
integer library_binding = "analogLib";

 *)
c3662 ( GND, \4:MR_SQUELCH_RANGE_1p0(1)  );
capacitor #(.c(4.478e-15)) (*
integer library_binding = "analogLib";

 *)
c3663 ( GND, \MR_SQUELCH_RANGE_1p0(0)  );
capacitor #(.c(3.153e-15)) (*
integer library_binding = "analogLib";

 *)
c3664 ( GND, \4:MR_SQUELCH_DISB_1p0  );
capacitor #(.c(2.657e-15)) (*
integer library_binding = "analogLib";

 *)
c3665 ( GND, \5:B10_DIS  );
capacitor #(.c(1.348e-15)) (*
integer library_binding = "analogLib";

 *)
c3666 ( GND, ADC_DIS_2p5 );
capacitor #(.c(6.272e-16)) (*
integer library_binding = "analogLib";

 *)
c3667 ( GND, \TENBT_FILTER_1p0(3)  );
capacitor #(.c(5.779e-16)) (*
integer library_binding = "analogLib";

 *)
c3668 ( GND, \6:TENBT_FILTER_1p0(2)  );
capacitor #(.c(6.296e-16)) (*
integer library_binding = "analogLib";

 *)
c3669 ( GND, \TENBT_FILTER_1p0(1)  );
capacitor #(.c(6.278e-16)) (*
integer library_binding = "analogLib";

 *)
c3670 ( GND, \6:TENBT_FILTER_1p0(0)  );
capacitor #(.c(8.999e-16)) (*
integer library_binding = "analogLib";

 *)
c3671 ( GND, \6:TENBT_CLK160_1p0  );
capacitor #(.c(2.034e-15)) (*
integer library_binding = "analogLib";

 *)
c3672 ( GND, \6:T2_MODE  );
capacitor #(.c(8.882e-16)) (*
integer library_binding = "analogLib";

 *)
c3673 ( GND, RESET_10BT );
capacitor #(.c(3.83e-15)) (*
integer library_binding = "analogLib";

 *)
c3674 ( GND, MR_BYPASS10RX_FILTER );
capacitor #(.c(2e-16)) (*
integer library_binding = "analogLib";
 *)

c3675 ( GND, BASE10_TX_DIS_1p0 );
capacitor #(.c(1.787e-15)) (*
integer library_binding = "analogLib";

 *)
c3676 ( GND, \6:AEQ_BYPASS  );
capacitor #(.c(2.015e-15)) (*
integer library_binding = "analogLib";

 *)
c3677 ( GND, \6:X10_DIS_2p5  );
capacitor #(.c(4.502e-19)) (*
integer library_binding = "analogLib";

 *)
c3678 ( GND, \1:TPIP  );
capacitor #(.c(4.502e-19)) (*
integer library_binding = "analogLib";

 *)
c3679 ( GND, \1:TPIN  );
capacitor #(.c(1.679e-15)) (*
integer library_binding = "analogLib";

 *)
c3680 ( GND, TIMING_UP_ANLG );
capacitor #(.c(1.428e-15)) (*
integer library_binding = "analogLib";

 *)
c3681 ( GND, \5:TIMING_DN_ANLG  );
capacitor #(.c(2.119e-15)) (*
integer library_binding = "analogLib";

 *)
c3682 ( GND, T2_MODE );
capacitor #(.c(1.469e-15)) (*
integer library_binding = "analogLib";

 *)
c3683 ( GND, RX10_PRESENT_2p5 );
capacitor #(.c(7.446e-16)) (*
integer library_binding = "analogLib";

 *)
c3684 ( GND, \I_REXT_100(2)  );
capacitor #(.c(1.476e-15)) (*
integer library_binding = "analogLib";

 *)
c3685 ( GND, \AEQ_CNT_ANLG(1)  );
capacitor #(.c(3.262e-15)) (*
integer library_binding = "analogLib";

 *)
c3686 ( GND, \4:AEQ_CNT_ANLG(0)  );
capacitor #(.c(2.76e-19)) (*
integer library_binding = "analogLib";

 *)
c3687 ( GND, \1:TPOP  );
capacitor #(.c(2.76e-19)) (*
integer library_binding = "analogLib";

 *)
c3688 ( GND, \1:TPON  );
capacitor #(.c(2.286e-19)) (*
integer library_binding = "analogLib";

 *)
c3689 ( GND, \1:VDDA_250  );
capacitor #(.c(3.266e-19)) (*
integer library_binding = "analogLib";

 *)
c3690 ( GND, \1:VDDA_160  );
capacitor #(.c(1.077e-19)) (*
integer library_binding = "analogLib";

 *)
c3691 ( GND, \1:RBIAS_SENSE  );
capacitor #(.c(3.059e-20)) (*
integer library_binding = "analogLib";

 *)
c3692 ( GND, \1:RBIAS  );
capacitor #(.c(2.074e-15)) (*
integer library_binding = "analogLib";

 *)
c3693 ( GND, \PHASE_IN(7)  );
capacitor #(.c(2.449e-19)) (*
integer library_binding = "analogLib";

 *)
c3694 ( GND, \1:GNDA_250  );
capacitor #(.c(2.286e-19)) (*
integer library_binding = "analogLib";

 *)
c3695 ( GND, \1:GNDA_160  );
capacitor #(.c(1.631e-20)) (*
integer library_binding = "analogLib";

 *)
c3696 ( GND, XTAL25 );
capacitor #(.c(7.715e-20)) (*
integer library_binding = "analogLib";

 *)
c3697 ( GND, RBIAS );
capacitor #(.c(1.226e-17)) (*
integer library_binding = "analogLib";

 *)
c3698 ( GND, \BGTRIM(3)  );
capacitor #(.c(2.18e-17)) (*
integer library_binding = "analogLib";

 *)
c3699 ( GND, \BGTRIM(2)  );
capacitor #(.c(1.226e-17)) (*
integer library_binding = "analogLib";

 *)
c3700 ( GND, \BGTRIM(0)  );
capacitor #(.c(2.369e-15)) (*
integer library_binding = "analogLib";

 *)
c3701 ( \5:GND , \7:I_REXT_50(0)  );
capacitor #(.c(3.325e-16)) (*
integer library_binding = "analogLib";

 *)
c3702 ( \5:GND , \I_REXT_50(0)  );
capacitor #(.c(9.746e-17)) (*
integer library_binding = "analogLib";

 *)
c3703 ( \5:GND , \I_RPOLY_100(4)  );
capacitor #(.c(9.746e-17)) (*
integer library_binding = "analogLib";

 *)
c3704 ( \5:GND , \4:I_RPOLY_100(3)  );
capacitor #(.c(9.746e-17)) (*
integer library_binding = "analogLib";

 *)
c3705 ( \5:GND , \4:I_REXT_100(6)  );
capacitor #(.c(9.746e-17)) (*
integer library_binding = "analogLib";

 *)
c3706 ( \5:GND , \4:I_RPOLY_100(2)  );
capacitor #(.c(9.746e-17)) (*
integer library_binding = "analogLib";

 *)
c3707 ( \5:GND , \4:I_REXT_100(4)  );
capacitor #(.c(9.746e-17)) (*
integer library_binding = "analogLib";

 *)
c3708 ( \5:GND , \4:I_RPOLY_100(0)  );
capacitor #(.c(9.746e-17)) (*
integer library_binding = "analogLib";

 *)
c3709 ( \5:GND , \4:I_REXT_100(3)  );
capacitor #(.c(9.746e-17)) (*
integer library_binding = "analogLib";

 *)
c3710 ( \5:GND , \4:I_REXT_100(2)  );
capacitor #(.c(1.736e-16)) (*
integer library_binding = "analogLib";

 *)
c3711 ( \5:GND , \4:I_RPOLY_100(5)  );
capacitor #(.c(4.433e-20)) (*
integer library_binding = "analogLib";

 *)
c3712 ( \25:GND , \5:POS_DETECT_2p5  );
capacitor #(.c(3.308e-17)) (*
integer library_binding = "analogLib";

 *)
c3713 ( \25:GND , POS_DETECT_2p5 );
capacitor #(.c(1.115e-17)) (*
integer library_binding = "analogLib";

 *)
c3714 ( \25:GND , \7:I_REXT_50(0)  );
capacitor #(.c(1.974e-17)) (*
integer library_binding = "analogLib";

 *)
c3715 ( \25:GND , \4:I_RPOLY_100(2)  );
capacitor #(.c(1.356e-17)) (*
integer library_binding = "analogLib";

 *)
c3716 ( \25:GND , \4:FLASH_1p0(0)  );
capacitor #(.c(1.356e-17)) (*
integer library_binding = "analogLib";

 *)
c3717 ( \25:GND , \ADC_1p0(0)  );
capacitor #(.c(1.974e-17)) (*
integer library_binding = "analogLib";

 *)
c3718 ( \25:GND , \4:I_RPOLY_100(0)  );
capacitor #(.c(2.344e-17)) (*
integer library_binding = "analogLib";

 *)
c3719 ( \25:GND , \I_REXT_50(0)  );
capacitor #(.c(1.974e-17)) (*
integer library_binding = "analogLib";

 *)
c3720 ( \25:GND , \4:I_REXT_100(6)  );
capacitor #(.c(1.974e-17)) (*
integer library_binding = "analogLib";

 *)
c3721 ( \25:GND , \4:I_REXT_100(4)  );
capacitor #(.c(1.443e-17)) (*
integer library_binding = "analogLib";

 *)
c3722 ( \25:GND , \ADC_1p0(5)  );
capacitor #(.c(1.974e-17)) (*
integer library_binding = "analogLib";

 *)
c3723 ( \25:GND , \4:I_REXT_100(3)  );
capacitor #(.c(1.974e-17)) (*
integer library_binding = "analogLib";

 *)
c3724 ( \25:GND , \4:I_REXT_100(2)  );
capacitor #(.c(2.495e-17)) (*
integer library_binding = "analogLib";

 *)
c3725 ( \25:GND , \2:I_REXT_100(2)  );
capacitor #(.c(2.495e-17)) (*
integer library_binding = "analogLib";

 *)
c3726 ( \25:GND , \2:I_REXT_100(3)  );
capacitor #(.c(2.495e-17)) (*
integer library_binding = "analogLib";

 *)
c3727 ( \25:GND , \2:I_REXT_100(4)  );
capacitor #(.c(2.495e-17)) (*
integer library_binding = "analogLib";

 *)
c3728 ( \25:GND , \2:I_REXT_100(6)  );
capacitor #(.c(2.495e-17)) (*
integer library_binding = "analogLib";

 *)
c3729 ( \25:GND , \2:I_RPOLY_100(0)  );
capacitor #(.c(2.495e-17)) (*
integer library_binding = "analogLib";

 *)
c3730 ( \25:GND , \I_RPOLY_100(2)  );
capacitor #(.c(2.495e-17)) (*
integer library_binding = "analogLib";

 *)
c3731 ( \25:GND , \2:I_RPOLY_100(3)  );
capacitor #(.c(2.522e-17)) (*
integer library_binding = "analogLib";

 *)
c3732 ( \25:GND , \2:I_RPOLY_100(4)  );
capacitor #(.c(3.778e-17)) (*
integer library_binding = "analogLib";

 *)
c3733 ( \25:GND , \2:I_RPOLY_100(5)  );
capacitor #(.c(3.969e-16)) (*
integer library_binding = "analogLib";

 *)
c3734 ( \25:GND , \4:I_RPOLY_100(5)  );
capacitor #(.c(1.824e-17)) (*
integer library_binding = "analogLib";

 *)
c3735 ( \25:GND , \3:ADC_1p0(4)  );
capacitor #(.c(2.388e-17)) (*
integer library_binding = "analogLib";

 *)
c3736 ( \25:GND , \I_RPOLY_100(4)  );
capacitor #(.c(1.974e-17)) (*
integer library_binding = "analogLib";

 *)
c3737 ( \25:GND , \4:I_RPOLY_100(3)  );
capacitor #(.c(1.574e-15)) (*
integer library_binding = "analogLib";

 *)
c3738 ( \24:GND , \24:VDDTX  );
capacitor #(.c(1.702e-17)) (*
integer library_binding = "analogLib";

 *)
c3739 ( \AEQ_CNT_ANLG(1) , \7:BASEFX_DIS  );
capacitor #(.c(1.959e-17)) (*
integer library_binding = "analogLib";

 *)
c3740 ( \AEQ_CNT_ANLG(1) , \WANDER_CNT(4)  );
capacitor #(.c(8.672e-15)) (*
integer library_binding = "analogLib";

 *)
c3741 ( \AEQ_CNT_ANLG(1) , AEQ_DIS_2p5 );
capacitor #(.c(1.277e-18)) (*
integer library_binding = "analogLib";

 *)
c3742 ( \AEQ_CNT_ANLG(1) , \5:WANDER_CNT(4)  );
capacitor #(.c(1.356e-18)) (*
integer library_binding = "analogLib";

 *)
c3743 ( \AEQ_CNT_ANLG(1) , \5:AEQ_CNT_ANLG(4)  );
capacitor #(.c(1.114e-18)) (*
integer library_binding = "analogLib";

 *)
c3744 ( \AEQ_CNT_ANLG(1) , \2:PHASE_IN(1)  );
capacitor #(.c(1.225e-18)) (*
integer library_binding = "analogLib";

 *)
c3745 ( \AEQ_CNT_ANLG(1) , \4:PHASE_IN(9)  );
capacitor #(.c(3.368e-18)) (*
integer library_binding = "analogLib";

 *)
c3746 ( \AEQ_CNT_ANLG(1) , BASEFX_DIS );
capacitor #(.c(2.414e-17)) (*
integer library_binding = "analogLib";

 *)
c3747 ( \AEQ_CNT_ANLG(1) , \5:BASEFX_DIS  );
capacitor #(.c(1.971e-17)) (*
integer library_binding = "analogLib";

 *)
c3748 ( \AEQ_CNT_ANLG(1) , \WANDER_CNT(6)  );
capacitor #(.c(2.209e-15)) (*
integer library_binding = "analogLib";

 *)
c3749 ( \AEQ_CNT_ANLG(1) , \6:AEQ_DIS_2p5  );
capacitor #(.c(9.749e-18)) (*
integer library_binding = "analogLib";

 *)
c3750 ( \AEQ_CNT_ANLG(1) , \5:BLW_DIS_2p5  );
capacitor #(.c(1.854e-17)) (*
integer library_binding = "analogLib";

 *)
c3751 ( \AEQ_CNT_ANLG(1) , \4:AEQ_CNT_ANLG(0)  );
capacitor #(.c(1.621e-18)) (*
integer library_binding = "analogLib";

 *)
c3752 ( \AEQ_CNT_ANLG(1) , \5:WANDER_CNT(6)  );
capacitor #(.c(1.11e-18)) (*
integer library_binding = "analogLib";

 *)
c3753 ( \AEQ_CNT_ANLG(1) , \6:XTAL25  );
capacitor #(.c(1.217e-18)) (*
integer library_binding = "analogLib";

 *)
c3754 ( \AEQ_CNT_ANLG(1) , \4:PLL_160_IN  );
capacitor #(.c(2.271e-18)) (*
integer library_binding = "analogLib";

 *)
c3755 ( \AEQ_CNT_ANLG(1) , \AEQ_CNT_ANLG(0)  );
capacitor #(.c(1.26e-16)) (*
integer library_binding = "analogLib";

 *)
c3756 ( \AEQ_CNT_ANLG(1) , \25:VDDTX  );
capacitor #(.c(2.4e-17)) (*
integer library_binding = "analogLib";

 *)
c3757 ( \AEQ_CNT_ANLG(1) , \24:VDDTX  );
capacitor #(.c(1.373e-19)) (*
integer library_binding = "analogLib";

 *)
c3758 ( \AEQ_CNT_ANLG(1) , BLW_DIS_2p5 );
capacitor #(.c(1.295e-18)) (*
integer library_binding = "analogLib";

 *)
c3759 ( \AEQ_CNT_ANLG(1) , \2:I_REXT_50(0)  );
capacitor #(.c(1.336e-17)) (*
integer library_binding = "analogLib";

 *)
c3760 ( \AEQ_CNT_ANLG(1) , \6:I_REXT_50(0)  );
capacitor #(.c(1.013e-17)) (*
integer library_binding = "analogLib";

 *)
c3761 ( \AEQ_CNT_ANLG(1) , \AEQ_CNT_ANLG(4)  );
capacitor #(.c(1.473e-17)) (*
integer library_binding = "analogLib";

 *)
c3762 ( \AEQ_CNT_ANLG(1) , \5:ADC_DIS_2p5  );
capacitor #(.c(1.471e-19)) (*
integer library_binding = "analogLib";

 *)
c3763 ( \AEQ_CNT_ANLG(1) , ADC_DIS_2p5 );
capacitor #(.c(1.349e-18)) (*
integer library_binding = "analogLib";

 *)
c3764 ( \AEQ_CNT_ANLG(1) , \WANDER_CNT(0)  );
capacitor #(.c(1.403e-17)) (*
integer library_binding = "analogLib";

 *)
c3765 ( \AEQ_CNT_ANLG(1) , \4:WANDER_CNT(0)  );
capacitor #(.c(1.561e-17)) (*
integer library_binding = "analogLib";

 *)
c3766 ( \AEQ_CNT_ANLG(1) , \4:WANDER_CNT(3)  );
capacitor #(.c(1.354e-18)) (*
integer library_binding = "analogLib";

 *)
c3767 ( \AEQ_CNT_ANLG(1) , \WANDER_CNT(3)  );
capacitor #(.c(1.908e-17)) (*
integer library_binding = "analogLib";

 *)
c3768 ( \AEQ_CNT_ANLG(1) , \8:TX100_DIS_2p5  );
capacitor #(.c(3.289e-19)) (*
integer library_binding = "analogLib";

 *)
c3769 ( \AEQ_CNT_ANLG(1) , \2:TX100_DIS_2p5  );
capacitor #(.c(1.941e-17)) (*
integer library_binding = "analogLib";

 *)
c3770 ( \AEQ_CNT_ANLG(1) , \6:X10_DIS_2p5  );
capacitor #(.c(5.854e-19)) (*
integer library_binding = "analogLib";

 *)
c3771 ( \5:AEQ_CNT_ANLG(1) , \7:BASEFX_DIS  );
capacitor #(.c(1.172e-18)) (*
integer library_binding = "analogLib";

 *)
c3772 ( \5:AEQ_CNT_ANLG(1) , \WANDER_CNT(4)  );
capacitor #(.c(3.353e-19)) (*
integer library_binding = "analogLib";

 *)
c3773 ( \5:AEQ_CNT_ANLG(1) , \5:BLW_DIS_2p5  );
capacitor #(.c(4.455e-20)) (*
integer library_binding = "analogLib";

 *)
c3774 ( \5:AEQ_CNT_ANLG(1) , \2:I_REXT_50(0)  );
capacitor #(.c(4.594e-19)) (*
integer library_binding = "analogLib";

 *)
c3775 ( \5:AEQ_CNT_ANLG(1) , \6:I_REXT_50(0)  );
capacitor #(.c(1.794e-18)) (*
integer library_binding = "analogLib";

 *)
c3776 ( \5:AEQ_CNT_ANLG(1) , \AEQ_CNT_ANLG(4)  );
capacitor #(.c(1.389e-17)) (*
integer library_binding = "analogLib";

 *)
c3777 ( \5:AEQ_CNT_ANLG(1) , \WANDER_CNT(0)  );
capacitor #(.c(1.061e-18)) (*
integer library_binding = "analogLib";

 *)
c3778 ( \5:AEQ_CNT_ANLG(1) , \4:WANDER_CNT(0)  );
capacitor #(.c(2.727e-16)) (*
integer library_binding = "analogLib";

 *)
c3779 ( \5:AEQ_CNT_ANLG(1) , \24:VDDTX  );
capacitor #(.c(1.432e-15)) (*
integer library_binding = "analogLib";

 *)
c3780 ( \5:AEQ_CNT_ANLG(1) , \25:VDDTX  );
capacitor #(.c(1.627e-17)) (*
integer library_binding = "analogLib";

 *)
c3781 ( \5:AEQ_CNT_ANLG(1) , \AEQ_CNT_ANLG(0)  );
capacitor #(.c(1.819e-18)) (*
integer library_binding = "analogLib";

 *)
c3782 ( \5:AEQ_CNT_ANLG(1) , \4:AEQ_CNT_ANLG(0)  );
capacitor #(.c(8.779e-20)) (*
integer library_binding = "analogLib";

 *)
c3783 ( \5:AEQ_CNT_ANLG(1) , \1:PLL_160_IN  );
capacitor #(.c(1.383e-17)) (*
integer library_binding = "analogLib";

 *)
c3784 ( \5:AEQ_CNT_ANLG(1) , \4:PLL_160_IN  );
capacitor #(.c(5.252e-20)) (*
integer library_binding = "analogLib";

 *)
c3785 ( \5:AEQ_CNT_ANLG(1) , \3:XTAL25  );
capacitor #(.c(1.261e-17)) (*
integer library_binding = "analogLib";

 *)
c3786 ( \5:AEQ_CNT_ANLG(1) , \6:XTAL25  );
capacitor #(.c(1.402e-17)) (*
integer library_binding = "analogLib";

 *)
c3787 ( \5:AEQ_CNT_ANLG(1) , \5:WANDER_CNT(6)  );
capacitor #(.c(1.62e-18)) (*
integer library_binding = "analogLib";

 *)
c3788 ( \5:AEQ_CNT_ANLG(1) , \WANDER_CNT(6)  );
capacitor #(.c(6.573e-15)) (*
integer library_binding = "analogLib";

 *)
c3789 ( \5:AEQ_CNT_ANLG(1) , \6:AEQ_DIS_2p5  );
capacitor #(.c(2.696e-16)) (*
integer library_binding = "analogLib";

 *)
c3790 ( \5:AEQ_CNT_ANLG(1) , \5:BASEFX_DIS  );
capacitor #(.c(1.392e-17)) (*
integer library_binding = "analogLib";

 *)
c3791 ( \5:AEQ_CNT_ANLG(1) , \4:PHASE_IN(9)  );
capacitor #(.c(1.266e-17)) (*
integer library_binding = "analogLib";

 *)
c3792 ( \5:AEQ_CNT_ANLG(1) , \2:PHASE_IN(1)  );
capacitor #(.c(1.351e-17)) (*
integer library_binding = "analogLib";

 *)
c3793 ( \5:AEQ_CNT_ANLG(1) , \5:AEQ_CNT_ANLG(4)  );
capacitor #(.c(1.384e-17)) (*
integer library_binding = "analogLib";

 *)
c3794 ( \5:AEQ_CNT_ANLG(1) , \WANDER_CNT(3)  );
capacitor #(.c(1.378e-17)) (*
integer library_binding = "analogLib";

 *)
c3795 ( \5:AEQ_CNT_ANLG(1) , \5:WANDER_CNT(4)  );
capacitor #(.c(1.113e-18)) (*
integer library_binding = "analogLib";

 *)
c3796 ( \5:AEQ_CNT_ANLG(1) , \4:WANDER_CNT(3)  );
capacitor #(.c(1.871e-15)) (*
integer library_binding = "analogLib";

 *)
c3797 ( \5:AEQ_CNT_ANLG(1) , AEQ_DIS_2p5 );
capacitor #(.c(3.445e-16)) (*
integer library_binding = "analogLib";

 *)
c3798 ( \5:AEQ_CNT_ANLG(1) , BASEFX_DIS );
capacitor #(.c(5.184e-18)) (*
integer library_binding = "analogLib";

 *)
c3799 ( \PHASE_250(5) , \PHASE_250(2)  );
capacitor #(.c(3.772e-18)) (*
integer library_binding = "analogLib";

 *)
c3800 ( \PHASE_250(5) , \4:PHASE_250(2)  );
capacitor #(.c(1.682e-18)) (*
integer library_binding = "analogLib";

 *)
c3801 ( \PHASE_250(5) , \3:MR_SQUELCH_DISB_2p5  );
capacitor #(.c(6.189e-18)) (*
integer library_binding = "analogLib";

 *)
c3802 ( \PHASE_250(5) , \3:PHASE_250(1)  );
capacitor #(.c(1.915e-19)) (*
integer library_binding = "analogLib";

 *)
c3803 ( \PHASE_250(5) , \2:TX100_DIS_2p5  );
capacitor #(.c(1.054e-17)) (*
integer library_binding = "analogLib";

 *)
c3804 ( \PHASE_250(5) , \PHASE_250(1)  );
capacitor #(.c(5.228e-18)) (*
integer library_binding = "analogLib";

 *)
c3805 ( \PHASE_250(5) , \9:TX100_DIS_2p5  );
capacitor #(.c(1.709e-18)) (*
integer library_binding = "analogLib";

 *)
c3806 ( \PHASE_250(5) , \5:BLW_DIS_2p5  );
capacitor #(.c(3.309e-17)) (*
integer library_binding = "analogLib";

 *)
c3807 ( \PHASE_250(5) , RX10_PRESENT_2p5 );
capacitor #(.c(1.188e-18)) (*
integer library_binding = "analogLib";

 *)
c3808 ( \PHASE_250(5) , AEQ_DIS_2p5 );
capacitor #(.c(2.156e-17)) (*
integer library_binding = "analogLib";

 *)
c3809 ( \PHASE_250(5) , \6:AEQ_DIS_2p5  );
capacitor #(.c(2.217e-17)) (*
integer library_binding = "analogLib";

 *)
c3810 ( \PHASE_250(5) , BLW_DIS_2p5 );
capacitor #(.c(2.534e-17)) (*
integer library_binding = "analogLib";

 *)
c3811 ( \PHASE_250(5) , MR_SQUELCH_DISB_2p5 );
capacitor #(.c(5.767e-18)) (*
integer library_binding = "analogLib";

 *)
c3812 ( \PHASE_250(5) , \4:PHASE_250(3)  );
capacitor #(.c(5.971e-18)) (*
integer library_binding = "analogLib";

 *)
c3813 ( \PHASE_250(5) , \PHASE_250(3)  );
capacitor #(.c(9.011e-16)) (*
integer library_binding = "analogLib";

 *)
c3814 ( \PHASE_250(5) , \6:RX10_PRESENT_2p5  );
capacitor #(.c(2.868e-17)) (*
integer library_binding = "analogLib";

 *)
c3815 ( \PHASE_250(5) , \3:PHASE_250(9)  );
capacitor #(.c(7.387e-18)) (*
integer library_binding = "analogLib";

 *)
c3816 ( \PHASE_250(5) , \PHASE_250(4)  );
capacitor #(.c(6.187e-18)) (*
integer library_binding = "analogLib";

 *)
c3817 ( \PHASE_250(5) , \4:PHASE_250(4)  );
capacitor #(.c(5.258e-18)) (*
integer library_binding = "analogLib";

 *)
c3818 ( \PHASE_250(5) , \2:I_REXT_50(0)  );
capacitor #(.c(1.169e-17)) (*
integer library_binding = "analogLib";

 *)
c3819 ( \PHASE_250(5) , \PHASE_250(9)  );
capacitor #(.c(1.266e-17)) (*
integer library_binding = "analogLib";

 *)
c3820 ( \PHASE_250(5) , \3:X10_DIS_2p5  );
capacitor #(.c(4.733e-18)) (*
integer library_binding = "analogLib";

 *)
c3821 ( \4:PHASE_250(5) , \PHASE_250(2)  );
capacitor #(.c(3.498e-17)) (*
integer library_binding = "analogLib";

 *)
c3822 ( \4:PHASE_250(5) , \4:PHASE_250(2)  );
capacitor #(.c(6.861e-18)) (*
integer library_binding = "analogLib";

 *)
c3823 ( \4:PHASE_250(5) , \3:PHASE_250(1)  );
capacitor #(.c(1.033e-18)) (*
integer library_binding = "analogLib";

 *)
c3824 ( \4:PHASE_250(5) , \2:TX100_DIS_2p5  );
capacitor #(.c(4.012e-17)) (*
integer library_binding = "analogLib";

 *)
c3825 ( \4:PHASE_250(5) , \PHASE_250(1)  );
capacitor #(.c(2.819e-17)) (*
integer library_binding = "analogLib";

 *)
c3826 ( \4:PHASE_250(5) , \9:TX100_DIS_2p5  );
capacitor #(.c(1.874e-17)) (*
integer library_binding = "analogLib";

 *)
c3827 ( \4:PHASE_250(5) , RX10_PRESENT_2p5 );
capacitor #(.c(1.779e-19)) (*
integer library_binding = "analogLib";

 *)
c3828 ( \4:PHASE_250(5) , \3:XTAL25  );
capacitor #(.c(4.272e-17)) (*
integer library_binding = "analogLib";

 *)
c3829 ( \4:PHASE_250(5) , \6:XTAL25  );
capacitor #(.c(6.724e-19)) (*
integer library_binding = "analogLib";

 *)
c3830 ( \4:PHASE_250(5) , AEQ_DIS_2p5 );
capacitor #(.c(1.221e-17)) (*
integer library_binding = "analogLib";

 *)
c3831 ( \4:PHASE_250(5) , \6:AEQ_DIS_2p5  );
capacitor #(.c(5.071e-18)) (*
integer library_binding = "analogLib";

 *)
c3832 ( \4:PHASE_250(5) , BLW_DIS_2p5 );
capacitor #(.c(6.724e-18)) (*
integer library_binding = "analogLib";

 *)
c3833 ( \4:PHASE_250(5) , MR_SQUELCH_DISB_2p5 );
capacitor #(.c(5.102e-16)) (*
integer library_binding = "analogLib";

 *)
c3834 ( \4:PHASE_250(5) , \6:RX10_PRESENT_2p5  );
capacitor #(.c(1.624e-17)) (*
integer library_binding = "analogLib";

 *)
c3835 ( \4:PHASE_250(5) , \3:PHASE_250(9)  );
capacitor #(.c(2.075e-17)) (*
integer library_binding = "analogLib";

 *)
c3836 ( \4:PHASE_250(5) , \PHASE_250(9)  );
capacitor #(.c(2.835e-17)) (*
integer library_binding = "analogLib";

 *)
c3837 ( \4:PHASE_250(5) , \2:I_REXT_50(0)  );
capacitor #(.c(1.501e-17)) (*
integer library_binding = "analogLib";

 *)
c3838 ( \4:PHASE_250(5) , \4:PHASE_250(3)  );
capacitor #(.c(5.062e-18)) (*
integer library_binding = "analogLib";

 *)
c3839 ( \4:PHASE_250(5) , \PHASE_250(3)  );
capacitor #(.c(5.936e-18)) (*
integer library_binding = "analogLib";

 *)
c3840 ( \4:PHASE_250(5) , \PHASE_250(4)  );
capacitor #(.c(3.321e-17)) (*
integer library_binding = "analogLib";

 *)
c3841 ( \4:PHASE_250(5) , \4:PHASE_250(4)  );
capacitor #(.c(8.547e-19)) (*
integer library_binding = "analogLib";

 *)
c3842 ( \1:B10_DIS , \5:TXER  );
capacitor #(.c(1.102e-17)) (*
integer library_binding = "analogLib";

 *)
c3843 ( \1:B10_DIS , \3:TXER  );
capacitor #(.c(2.817e-19)) (*
integer library_binding = "analogLib";

 *)
c3844 ( \5:B10_DIS , SLICER_OUT_1p0 );
capacitor #(.c(2.735e-18)) (*
integer library_binding = "analogLib";

 *)
c3845 ( \5:B10_DIS , \3:X_160  );
capacitor #(.c(1.853e-17)) (*
integer library_binding = "analogLib";

 *)
c3846 ( \5:B10_DIS , \4:SLICER_OUT_1p0  );
capacitor #(.c(2.56e-18)) (*
integer library_binding = "analogLib";

 *)
c3847 ( \5:B10_DIS , \3:POS_DETECT_1p0  );
capacitor #(.c(1.962e-17)) (*
integer library_binding = "analogLib";

 *)
c3848 ( \5:B10_DIS , \4:X_125  );
capacitor #(.c(2.68e-18)) (*
integer library_binding = "analogLib";

 *)
c3849 ( \5:B10_DIS , \3:XTAL25_1p0  );
capacitor #(.c(1.969e-17)) (*
integer library_binding = "analogLib";

 *)
c3850 ( \5:B10_DIS , X_160 );
capacitor #(.c(2.676e-18)) (*
integer library_binding = "analogLib";

 *)
c3851 ( \5:B10_DIS , \3:NEG_DETECT_1p0  );
capacitor #(.c(1.683e-17)) (*
integer library_binding = "analogLib";

 *)
c3852 ( \5:B10_DIS , NEG_DETECT_1p0 );
capacitor #(.c(1.986e-17)) (*
integer library_binding = "analogLib";

 *)
c3853 ( \5:B10_DIS , POS_DETECT_1p0 );
capacitor #(.c(1.724e-17)) (*
integer library_binding = "analogLib";

 *)
c3854 ( \5:B10_DIS , XTAL25_1p0 );
capacitor #(.c(2.237e-17)) (*
integer library_binding = "analogLib";

 *)
c3855 ( \5:B10_DIS , \2:ADC_1p0(0)  );
capacitor #(.c(1.909e-17)) (*
integer library_binding = "analogLib";

 *)
c3856 ( \5:B10_DIS , \1:RCLK125_1p0  );
capacitor #(.c(1.778e-17)) (*
integer library_binding = "analogLib";

 *)
c3857 ( \5:B10_DIS , \2:ADC_1p0(3)  );
capacitor #(.c(1.835e-17)) (*
integer library_binding = "analogLib";

 *)
c3858 ( \5:B10_DIS , \FLASH_1p0(0)  );
capacitor #(.c(2.022e-17)) (*
integer library_binding = "analogLib";

 *)
c3859 ( \5:B10_DIS , \2:ADC_1p0(5)  );
capacitor #(.c(1.959e-17)) (*
integer library_binding = "analogLib";

 *)
c3860 ( \5:B10_DIS , \FLASH_1p0(1)  );
capacitor #(.c(1.959e-17)) (*
integer library_binding = "analogLib";

 *)
c3861 ( \5:B10_DIS , \1:ADC_1p0(4)  );
capacitor #(.c(1.362e-19)) (*
integer library_binding = "analogLib";

 *)
c3862 ( \WANDER_CNT(3) , \7:BASEFX_DIS  );
capacitor #(.c(1.81e-18)) (*
integer library_binding = "analogLib";

 *)
c3863 ( \WANDER_CNT(3) , \WANDER_CNT(4)  );
capacitor #(.c(7.405e-19)) (*
integer library_binding = "analogLib";

 *)
c3864 ( \WANDER_CNT(3) , \WANDER_CNT(2)  );
capacitor #(.c(1.502e-17)) (*
integer library_binding = "analogLib";

 *)
c3865 ( \WANDER_CNT(3) , \5:WANDER_CNT(2)  );
capacitor #(.c(1.621e-18)) (*
integer library_binding = "analogLib";

 *)
c3866 ( \WANDER_CNT(3) , \AEQ_CNT_ANLG(4)  );
capacitor #(.c(4.271e-17)) (*
integer library_binding = "analogLib";

 *)
c3867 ( \WANDER_CNT(3) , \9:TX100_DIS_2p5  );
capacitor #(.c(5.354e-16)) (*
integer library_binding = "analogLib";

 *)
c3868 ( \WANDER_CNT(3) , AEQ_BYPASS );
capacitor #(.c(2.122e-15)) (*
integer library_binding = "analogLib";

 *)
c3869 ( \WANDER_CNT(3) , \5:ADC_DIS_2p5  );
capacitor #(.c(6.307e-15)) (*
integer library_binding = "analogLib";

 *)
c3870 ( \WANDER_CNT(3) , \WANDER_CNT(0)  );
capacitor #(.c(1.041e-16)) (*
integer library_binding = "analogLib";

 *)
c3871 ( \WANDER_CNT(3) , \24:VDDTX  );
capacitor #(.c(5.464e-16)) (*
integer library_binding = "analogLib";

 *)
c3872 ( \WANDER_CNT(3) , \25:VDDTX  );
capacitor #(.c(2.623e-18)) (*
integer library_binding = "analogLib";

 *)
c3873 ( \WANDER_CNT(3) , RX10_PRESENT_2p5 );
capacitor #(.c(3.589e-15)) (*
integer library_binding = "analogLib";

 *)
c3874 ( \WANDER_CNT(3) , ADC_DIS_2p5 );
capacitor #(.c(1.469e-17)) (*
integer library_binding = "analogLib";

 *)
c3875 ( \WANDER_CNT(3) , \AEQ_CNT_ANLG(0)  );
capacitor #(.c(1.023e-17)) (*
integer library_binding = "analogLib";

 *)
c3876 ( \WANDER_CNT(3) , \6:RX10_PRESENT_2p5  );
capacitor #(.c(7.007e-20)) (*
integer library_binding = "analogLib";

 *)
c3877 ( \WANDER_CNT(3) , \1:PLL_160_IN  );
capacitor #(.c(1.104e-17)) (*
integer library_binding = "analogLib";

 *)
c3878 ( \WANDER_CNT(3) , \4:PLL_160_IN  );
capacitor #(.c(4.659e-20)) (*
integer library_binding = "analogLib";

 *)
c3879 ( \WANDER_CNT(3) , \3:XTAL25  );
capacitor #(.c(1.119e-17)) (*
integer library_binding = "analogLib";

 *)
c3880 ( \WANDER_CNT(3) , \6:XTAL25  );
capacitor #(.c(1.376e-19)) (*
integer library_binding = "analogLib";

 *)
c3881 ( \WANDER_CNT(3) , \5:BLW_DIS_2p5  );
capacitor #(.c(1.166e-17)) (*
integer library_binding = "analogLib";

 *)
c3882 ( \WANDER_CNT(3) , \6:AEQ_DIS_2p5  );
capacitor #(.c(5.469e-16)) (*
integer library_binding = "analogLib";

 *)
c3883 ( \WANDER_CNT(3) , \4:WANDER_CNT(0)  );
capacitor #(.c(1.481e-19)) (*
integer library_binding = "analogLib";

 *)
c3884 ( \WANDER_CNT(3) , \WANDER_CNT(6)  );
capacitor #(.c(1.208e-18)) (*
integer library_binding = "analogLib";

 *)
c3885 ( \WANDER_CNT(3) , \4:AEQ_CNT_ANLG(0)  );
capacitor #(.c(1.21e-19)) (*
integer library_binding = "analogLib";

 *)
c3886 ( \WANDER_CNT(3) , T2_MODE );
capacitor #(.c(2.963e-18)) (*
integer library_binding = "analogLib";

 *)
c3887 ( \WANDER_CNT(3) , AEQ_DIS_2p5 );
capacitor #(.c(2.128e-17)) (*
integer library_binding = "analogLib";

 *)
c3888 ( \WANDER_CNT(3) , \5:WANDER_CNT(4)  );
capacitor #(.c(1.007e-15)) (*
integer library_binding = "analogLib";

 *)
c3889 ( \WANDER_CNT(3) , \2:TX100_DIS_2p5  );
capacitor #(.c(7.036e-17)) (*
integer library_binding = "analogLib";

 *)
c3890 ( \WANDER_CNT(3) , \2:PHASE_IN(1)  );
capacitor #(.c(1.405e-17)) (*
integer library_binding = "analogLib";

 *)
c3891 ( \WANDER_CNT(3) , \2:I_REXT_50(0)  );
capacitor #(.c(1.114e-16)) (*
integer library_binding = "analogLib";

 *)
c3892 ( \WANDER_CNT(3) , \6:X10_DIS_2p5  );
capacitor #(.c(4.891e-16)) (*
integer library_binding = "analogLib";

 *)
c3893 ( \WANDER_CNT(3) , \3:X10_DIS_2p5  );
capacitor #(.c(5.036e-16)) (*
integer library_binding = "analogLib";

 *)
c3894 ( \WANDER_CNT(3) , \6:AEQ_BYPASS  );
capacitor #(.c(1.916e-17)) (*
integer library_binding = "analogLib";

 *)
c3895 ( \WANDER_CNT(3) , \5:BASEFX_DIS  );
capacitor #(.c(1.116e-17)) (*
integer library_binding = "analogLib";

 *)
c3896 ( \WANDER_CNT(3) , \4:PHASE_IN(9)  );
capacitor #(.c(1.398e-17)) (*
integer library_binding = "analogLib";

 *)
c3897 ( \WANDER_CNT(3) , \5:AEQ_CNT_ANLG(4)  );
capacitor #(.c(1.902e-16)) (*
integer library_binding = "analogLib";

 *)
c3898 ( \WANDER_CNT(3) , \8:TX100_DIS_2p5  );
capacitor #(.c(1.556e-17)) (*
integer library_binding = "analogLib";

 *)
c3899 ( \4:WANDER_CNT(3) , \7:BASEFX_DIS  );
capacitor #(.c(1.456e-19)) (*
integer library_binding = "analogLib";

 *)
c3900 ( \4:WANDER_CNT(3) , \WANDER_CNT(4)  );
capacitor #(.c(5.956e-20)) (*
integer library_binding = "analogLib";

 *)
c3901 ( \4:WANDER_CNT(3) , \WANDER_CNT(2)  );
capacitor #(.c(1.208e-18)) (*
integer library_binding = "analogLib";

 *)
c3902 ( \4:WANDER_CNT(3) , \5:WANDER_CNT(2)  );
capacitor #(.c(1.372e-17)) (*
integer library_binding = "analogLib";

 *)
c3903 ( \4:WANDER_CNT(3) , \AEQ_CNT_ANLG(4)  );
capacitor #(.c(3.435e-18)) (*
integer library_binding = "analogLib";

 *)
c3904 ( \4:WANDER_CNT(3) , \9:TX100_DIS_2p5  );
capacitor #(.c(4.886e-16)) (*
integer library_binding = "analogLib";

 *)
c3905 ( \4:WANDER_CNT(3) , AEQ_BYPASS );
capacitor #(.c(2.992e-15)) (*
integer library_binding = "analogLib";

 *)
c3906 ( \4:WANDER_CNT(3) , \5:ADC_DIS_2p5  );
capacitor #(.c(5.743e-16)) (*
integer library_binding = "analogLib";

 *)
c3907 ( \4:WANDER_CNT(3) , \WANDER_CNT(0)  );
capacitor #(.c(2.213e-19)) (*
integer library_binding = "analogLib";

 *)
c3908 ( \4:WANDER_CNT(3) , BLW_DIS_2p5 );
capacitor #(.c(8.37e-18)) (*
integer library_binding = "analogLib";

 *)
c3909 ( \4:WANDER_CNT(3) , \24:VDDTX  );
capacitor #(.c(4.395e-17)) (*
integer library_binding = "analogLib";

 *)
c3910 ( \4:WANDER_CNT(3) , \25:VDDTX  );
capacitor #(.c(1.538e-17)) (*
integer library_binding = "analogLib";

 *)
c3911 ( \4:WANDER_CNT(3) , RX10_PRESENT_2p5 );
capacitor #(.c(3.168e-16)) (*
integer library_binding = "analogLib";

 *)
c3912 ( \4:WANDER_CNT(3) , ADC_DIS_2p5 );
capacitor #(.c(1.182e-18)) (*
integer library_binding = "analogLib";

 *)
c3913 ( \4:WANDER_CNT(3) , \AEQ_CNT_ANLG(0)  );
capacitor #(.c(1.161e-18)) (*
integer library_binding = "analogLib";

 *)
c3914 ( \4:WANDER_CNT(3) , \6:RX10_PRESENT_2p5  );
capacitor #(.c(8.88e-19)) (*
integer library_binding = "analogLib";

 *)
c3915 ( \4:WANDER_CNT(3) , \4:PLL_160_IN  );
capacitor #(.c(8.997e-19)) (*
integer library_binding = "analogLib";

 *)
c3916 ( \4:WANDER_CNT(3) , \6:XTAL25  );
capacitor #(.c(1.571e-17)) (*
integer library_binding = "analogLib";

 *)
c3917 ( \4:WANDER_CNT(3) , \5:BLW_DIS_2p5  );
capacitor #(.c(9.381e-19)) (*
integer library_binding = "analogLib";

 *)
c3918 ( \4:WANDER_CNT(3) , \6:AEQ_DIS_2p5  );
capacitor #(.c(7.476e-15)) (*
integer library_binding = "analogLib";

 *)
c3919 ( \4:WANDER_CNT(3) , \4:WANDER_CNT(0)  );
capacitor #(.c(1.691e-17)) (*
integer library_binding = "analogLib";

 *)
c3920 ( \4:WANDER_CNT(3) , \WANDER_CNT(6)  );
capacitor #(.c(1.56e-17)) (*
integer library_binding = "analogLib";

 *)
c3921 ( \4:WANDER_CNT(3) , \4:AEQ_CNT_ANLG(0)  );
capacitor #(.c(3.542e-16)) (*
integer library_binding = "analogLib";

 *)
c3922 ( \4:WANDER_CNT(3) , \6:X10_DIS_2p5  );
capacitor #(.c(1.382e-17)) (*
integer library_binding = "analogLib";

 *)
c3923 ( \4:WANDER_CNT(3) , T2_MODE );
capacitor #(.c(1.616e-17)) (*
integer library_binding = "analogLib";

 *)
c3924 ( \4:WANDER_CNT(3) , AEQ_DIS_2p5 );
capacitor #(.c(8.887e-17)) (*
integer library_binding = "analogLib";

 *)
c3925 ( \4:WANDER_CNT(3) , \2:TX100_DIS_2p5  );
capacitor #(.c(4.741e-16)) (*
integer library_binding = "analogLib";

 *)
c3926 ( \4:WANDER_CNT(3) , \8:TX100_DIS_2p5  );
capacitor #(.c(1.353e-18)) (*
integer library_binding = "analogLib";

 *)
c3927 ( \4:WANDER_CNT(3) , \5:AEQ_CNT_ANLG(4)  );
capacitor #(.c(8.976e-19)) (*
integer library_binding = "analogLib";

 *)
c3928 ( \4:WANDER_CNT(3) , \4:PHASE_IN(9)  );
capacitor #(.c(1.916e-18)) (*
integer library_binding = "analogLib";

 *)
c3929 ( \4:WANDER_CNT(3) , \5:BASEFX_DIS  );
capacitor #(.c(4.953e-17)) (*
integer library_binding = "analogLib";

 *)
c3930 ( \4:WANDER_CNT(3) , \6:AEQ_BYPASS  );
capacitor #(.c(3.934e-17)) (*
integer library_binding = "analogLib";

 *)
c3931 ( \4:WANDER_CNT(3) , \3:X10_DIS_2p5  );
capacitor #(.c(1.13e-18)) (*
integer library_binding = "analogLib";

 *)
c3932 ( \4:WANDER_CNT(3) , \2:I_REXT_50(0)  );
capacitor #(.c(5.659e-18)) (*
integer library_binding = "analogLib";

 *)
c3933 ( \4:WANDER_CNT(3) , \2:PHASE_IN(1)  );
capacitor #(.c(1.712e-18)) (*
integer library_binding = "analogLib";

 *)
c3934 ( \4:WANDER_CNT(3) , \5:WANDER_CNT(4)  );
capacitor #(.c(1.442e-16)) (*
integer library_binding = "analogLib";

 *)
c3935 ( \ADC_1p0(5) , \6:ADC_1p0(3)  );
capacitor #(.c(2.024e-19)) (*
integer library_binding = "analogLib";

 *)
c3936 ( \ADC_1p0(5) , \6:FLASH_1p0(0)  );
capacitor #(.c(1.895e-17)) (*
integer library_binding = "analogLib";

 *)
c3937 ( \ADC_1p0(5) , \7:I_REXT_50(0)  );
capacitor #(.c(2.659e-18)) (*
integer library_binding = "analogLib";

 *)
c3938 ( \ADC_1p0(5) , \I_REXT_50(0)  );
capacitor #(.c(1.22e-17)) (*
integer library_binding = "analogLib";

 *)
c3939 ( \ADC_1p0(5) , \4:I_REXT_100(4)  );
capacitor #(.c(1.941e-17)) (*
integer library_binding = "analogLib";

 *)
c3940 ( \ADC_1p0(5) , \4:RCLK125_1p0  );
capacitor #(.c(1.22e-17)) (*
integer library_binding = "analogLib";

 *)
c3941 ( \ADC_1p0(5) , \4:I_RPOLY_100(2)  );
capacitor #(.c(1.22e-17)) (*
integer library_binding = "analogLib";

 *)
c3942 ( \ADC_1p0(5) , \4:I_REXT_100(3)  );
capacitor #(.c(1.22e-17)) (*
integer library_binding = "analogLib";

 *)
c3943 ( \ADC_1p0(5) , \4:I_REXT_100(2)  );
capacitor #(.c(1.22e-17)) (*
integer library_binding = "analogLib";

 *)
c3944 ( \ADC_1p0(5) , \4:I_RPOLY_100(0)  );
capacitor #(.c(1.309e-14)) (*
integer library_binding = "analogLib";

 *)
c3945 ( \ADC_1p0(5) , \3:ADC_1p0(3)  );
capacitor #(.c(2.719e-17)) (*
integer library_binding = "analogLib";

 *)
c3946 ( \ADC_1p0(5) , \4:FLASH_1p0(1)  );
capacitor #(.c(1.547e-17)) (*
integer library_binding = "analogLib";

 *)
c3947 ( \ADC_1p0(5) , \4:I_RPOLY_100(5)  );
capacitor #(.c(1.22e-17)) (*
integer library_binding = "analogLib";

 *)
c3948 ( \ADC_1p0(5) , \4:I_REXT_100(6)  );
capacitor #(.c(1.22e-17)) (*
integer library_binding = "analogLib";

 *)
c3949 ( \ADC_1p0(5) , \I_RPOLY_100(4)  );
capacitor #(.c(1.22e-17)) (*
integer library_binding = "analogLib";

 *)
c3950 ( \ADC_1p0(5) , \4:I_RPOLY_100(3)  );
capacitor #(.c(1.301e-14)) (*
integer library_binding = "analogLib";

 *)
c3951 ( \6:ADC_1p0(5) , \6:ADC_1p0(3)  );
capacitor #(.c(1.981e-17)) (*
integer library_binding = "analogLib";

 *)
c3952 ( \6:ADC_1p0(5) , RCLK125_1p0 );
capacitor #(.c(1.37e-19)) (*
integer library_binding = "analogLib";

 *)
c3953 ( \6:ADC_1p0(5) , \4:RCLK125_1p0  );
capacitor #(.c(1.827e-17)) (*
integer library_binding = "analogLib";

 *)
c3954 ( \6:ADC_1p0(5) , \6:FLASH_1p0(0)  );
capacitor #(.c(2.614e-19)) (*
integer library_binding = "analogLib";

 *)
c3955 ( \6:ADC_1p0(5) , \4:FLASH_1p0(0)  );
capacitor #(.c(4.535e-16)) (*
integer library_binding = "analogLib";

 *)
c3956 ( \6:ADC_1p0(5) , \3:ADC_1p0(3)  );
capacitor #(.c(7.036e-18)) (*
integer library_binding = "analogLib";

 *)
c3957 ( \3:ADC_1p0(5) , \1:RCLK125_1p0  );
capacitor #(.c(6.51e-18)) (*
integer library_binding = "analogLib";

 *)
c3958 ( \3:ADC_1p0(5) , \4:RCLK125_1p0  );
capacitor #(.c(1.628e-17)) (*
integer library_binding = "analogLib";

 *)
c3959 ( \3:ADC_1p0(5) , \3:ADC_1p0(0)  );
capacitor #(.c(3.733e-15)) (*
integer library_binding = "analogLib";

 *)
c3960 ( \3:ADC_1p0(5) , \ADC_1p0(3)  );
capacitor #(.c(5.425e-16)) (*
integer library_binding = "analogLib";

 *)
c3961 ( \3:ADC_1p0(5) , \2:ADC_1p0(3)  );
capacitor #(.c(4.25e-15)) (*
integer library_binding = "analogLib";

 *)
c3962 ( \3:ADC_1p0(5) , \3:FLASH_1p0(1)  );
capacitor #(.c(1.969e-18)) (*
integer library_binding = "analogLib";

 *)
c3963 ( \2:ADC_1p0(5) , \7:ADC_1p0(3)  );
capacitor #(.c(1.456e-15)) (*
integer library_binding = "analogLib";

 *)
c3964 ( \2:ADC_1p0(5) , \4:MLT3_TDATA_1p0(0)  );
capacitor #(.c(2.306e-18)) (*
integer library_binding = "analogLib";

 *)
c3965 ( \2:ADC_1p0(5) , \7:FLASH_1p0(1)  );
capacitor #(.c(1.871e-18)) (*
integer library_binding = "analogLib";

 *)
c3966 ( \2:ADC_1p0(5) , RX10_PRESENT_1p0 );
capacitor #(.c(3.502e-19)) (*
integer library_binding = "analogLib";

 *)
c3967 ( \2:ADC_1p0(5) , \4:RX10_PRESENT_1p0  );
capacitor #(.c(1.972e-18)) (*
integer library_binding = "analogLib";

 *)
c3968 ( \2:ADC_1p0(5) , \7:RCLK125_1p0  );
capacitor #(.c(2.489e-19)) (*
integer library_binding = "analogLib";

 *)
c3969 ( \2:ADC_1p0(5) , \1:RCLK125_1p0  );
capacitor #(.c(1.881e-18)) (*
integer library_binding = "analogLib";

 *)
c3970 ( \2:ADC_1p0(5) , X_125 );
capacitor #(.c(3.401e-19)) (*
integer library_binding = "analogLib";

 *)
c3971 ( \2:ADC_1p0(5) , \4:X_125  );
capacitor #(.c(1.97e-18)) (*
integer library_binding = "analogLib";

 *)
c3972 ( \2:ADC_1p0(5) , \7:FLASH_1p0(0)  );
capacitor #(.c(1.899e-18)) (*
integer library_binding = "analogLib";

 *)
c3973 ( \2:ADC_1p0(5) , \TX_SLOPETRIM_1p0(1)  );
capacitor #(.c(3.216e-19)) (*
integer library_binding = "analogLib";

 *)
c3974 ( \2:ADC_1p0(5) , \4:TX_SLOPETRIM_1p0(1)  );
capacitor #(.c(2.659e-19)) (*
integer library_binding = "analogLib";

 *)
c3975 ( \2:ADC_1p0(5) , \2:ADC_1p0(0)  );
capacitor #(.c(1.955e-18)) (*
integer library_binding = "analogLib";

 *)
c3976 ( \2:ADC_1p0(5) , \7:ADC_1p0(0)  );
capacitor #(.c(1.866e-18)) (*
integer library_binding = "analogLib";

 *)
c3977 ( \2:ADC_1p0(5) , \3:TEST_MODE(2)  );
capacitor #(.c(3.55e-19)) (*
integer library_binding = "analogLib";

 *)
c3978 ( \2:ADC_1p0(5) , \TEST_MODE(2)  );
capacitor #(.c(7.724e-16)) (*
integer library_binding = "analogLib";

 *)
c3979 ( \2:ADC_1p0(5) , SLICER_OUT_1p0 );
capacitor #(.c(2.369e-15)) (*
integer library_binding = "analogLib";

 *)
c3980 ( \2:ADC_1p0(5) , \4:SLICER_OUT_1p0  );
capacitor #(.c(3.659e-16)) (*
integer library_binding = "analogLib";

 *)
c3981 ( \2:ADC_1p0(5) , \MLT3_TDATA_1p0(0)  );
capacitor #(.c(4.044e-15)) (*
integer library_binding = "analogLib";

 *)
c3982 ( \2:ADC_1p0(5) , \2:ADC_1p0(3)  );
capacitor #(.c(2.022e-17)) (*
integer library_binding = "analogLib";

 *)
c3983 ( \2:ADC_1p0(5) , \5:TXER  );
capacitor #(.c(2.022e-17)) (*
integer library_binding = "analogLib";

 *)
c3984 ( \2:ADC_1p0(5) , \4:MR_SQUELCH_RANGE_1p0(1)  );
capacitor #(.c(2.022e-17)) (*
integer library_binding = "analogLib";

 *)
c3985 ( \2:ADC_1p0(5) , \MR_SQUELCH_RANGE_1p0(0)  );
capacitor #(.c(2.161e-17)) (*
integer library_binding = "analogLib";

 *)
c3986 ( \2:ADC_1p0(5) , POS_DETECT_1p0 );
capacitor #(.c(2.022e-17)) (*
integer library_binding = "analogLib";

 *)
c3987 ( \2:ADC_1p0(5) , X_160 );
capacitor #(.c(1.145e-17)) (*
integer library_binding = "analogLib";

 *)
c3988 ( \2:ADC_1p0(5) , \FLASH_1p0(0)  );
capacitor #(.c(2.022e-17)) (*
integer library_binding = "analogLib";

 *)
c3989 ( \2:ADC_1p0(5) , \4:MR_SQUELCH_DISB_1p0  );
capacitor #(.c(2.022e-17)) (*
integer library_binding = "analogLib";

 *)
c3990 ( \2:ADC_1p0(5) , \TX_SLOPETRIM_1p0(0)  );
capacitor #(.c(2.161e-17)) (*
integer library_binding = "analogLib";

 *)
c3991 ( \2:ADC_1p0(5) , NEG_DETECT_1p0 );
capacitor #(.c(4.259e-15)) (*
integer library_binding = "analogLib";

 *)
c3992 ( \2:ADC_1p0(5) , \FLASH_1p0(1)  );
capacitor #(.c(2.022e-17)) (*
integer library_binding = "analogLib";

 *)
c3993 ( \2:ADC_1p0(5) , \4:TX_AMPTRIM_1p0(1)  );
capacitor #(.c(2.022e-17)) (*
integer library_binding = "analogLib";

 *)
c3994 ( \2:ADC_1p0(5) , XTAL25_1p0 );
capacitor #(.c(2.022e-17)) (*
integer library_binding = "analogLib";

 *)
c3995 ( \2:ADC_1p0(5) , \TX_AMPTRIM_1p0(0)  );
capacitor #(.c(1.719e-17)) (*
integer library_binding = "analogLib";

 *)
c3996 ( \7:ADC_1p0(5) , \7:ADC_1p0(3)  );
capacitor #(.c(2.196e-18)) (*
integer library_binding = "analogLib";

 *)
c3997 ( \7:ADC_1p0(5) , \2:ADC_1p0(3)  );
capacitor #(.c(1.447e-16)) (*
integer library_binding = "analogLib";

 *)
c3998 ( \7:ADC_1p0(5) , \4:MLT3_TDATA_1p0(0)  );
capacitor #(.c(2.013e-17)) (*
integer library_binding = "analogLib";

 *)
c3999 ( \7:ADC_1p0(5) , \7:FLASH_1p0(1)  );
capacitor #(.c(2.237e-18)) (*
integer library_binding = "analogLib";

 *)
c4000 ( \7:ADC_1p0(5) , \FLASH_1p0(1)  );
capacitor #(.c(1.633e-17)) (*
integer library_binding = "analogLib";

 *)
c4001 ( \7:ADC_1p0(5) , RX10_PRESENT_1p0 );
capacitor #(.c(3.057e-18)) (*
integer library_binding = "analogLib";

 *)
c4002 ( \7:ADC_1p0(5) , \4:RX10_PRESENT_1p0  );
capacitor #(.c(1.721e-17)) (*
integer library_binding = "analogLib";

 *)
c4003 ( \7:ADC_1p0(5) , \7:RCLK125_1p0  );
capacitor #(.c(2.173e-18)) (*
integer library_binding = "analogLib";

 *)
c4004 ( \7:ADC_1p0(5) , \1:RCLK125_1p0  );
capacitor #(.c(1.642e-17)) (*
integer library_binding = "analogLib";

 *)
c4005 ( \7:ADC_1p0(5) , X_125 );
capacitor #(.c(8.957e-16)) (*
integer library_binding = "analogLib";

 *)
c4006 ( \7:ADC_1p0(5) , \MLT3_TDATA_1p0(0)  );
capacitor #(.c(2.968e-18)) (*
integer library_binding = "analogLib";

 *)
c4007 ( \7:ADC_1p0(5) , \4:X_125  );
capacitor #(.c(2.189e-18)) (*
integer library_binding = "analogLib";

 *)
c4008 ( \7:ADC_1p0(5) , \FLASH_1p0(0)  );
capacitor #(.c(1.72e-17)) (*
integer library_binding = "analogLib";

 *)
c4009 ( \7:ADC_1p0(5) , \7:FLASH_1p0(0)  );
capacitor #(.c(1.999e-16)) (*
integer library_binding = "analogLib";

 *)
c4010 ( \7:ADC_1p0(5) , \4:SLICER_OUT_1p0  );
capacitor #(.c(1.193e-15)) (*
integer library_binding = "analogLib";

 *)
c4011 ( \7:ADC_1p0(5) , SLICER_OUT_1p0 );
capacitor #(.c(1.658e-17)) (*
integer library_binding = "analogLib";

 *)
c4012 ( \7:ADC_1p0(5) , \TX_SLOPETRIM_1p0(1)  );
capacitor #(.c(2.807e-18)) (*
integer library_binding = "analogLib";

 *)
c4013 ( \7:ADC_1p0(5) , \4:TX_SLOPETRIM_1p0(1)  );
capacitor #(.c(2.321e-18)) (*
integer library_binding = "analogLib";

 *)
c4014 ( \7:ADC_1p0(5) , \2:ADC_1p0(0)  );
capacitor #(.c(1.706e-17)) (*
integer library_binding = "analogLib";

 *)
c4015 ( \7:ADC_1p0(5) , \7:ADC_1p0(0)  );
capacitor #(.c(1.629e-17)) (*
integer library_binding = "analogLib";

 *)
c4016 ( \7:ADC_1p0(5) , \3:TEST_MODE(2)  );
capacitor #(.c(3.099e-18)) (*
integer library_binding = "analogLib";

 *)
c4017 ( \7:ADC_1p0(5) , \TEST_MODE(2)  );
capacitor #(.c(1.993e-17)) (*
integer library_binding = "analogLib";

 *)
c4018 ( \TX_SLOPETRIM_1p0(0) , \4:MLT3_TDATA_1p0(0)  );
capacitor #(.c(3.071e-18)) (*
integer library_binding = "analogLib";

 *)
c4019 ( \TX_SLOPETRIM_1p0(0) , \3:X_160  );
capacitor #(.c(1.644e-17)) (*
integer library_binding = "analogLib";

 *)
c4020 ( \TX_SLOPETRIM_1p0(0) , \TEST_MODE(2)  );
capacitor #(.c(1.853e-17)) (*
integer library_binding = "analogLib";

 *)
c4021 ( \TX_SLOPETRIM_1p0(0) , \4:SLICER_OUT_1p0  );
capacitor #(.c(1.678e-17)) (*
integer library_binding = "analogLib";

 *)
c4022 ( \TX_SLOPETRIM_1p0(0) , \4:RX10_PRESENT_1p0  );
capacitor #(.c(3.386e-18)) (*
integer library_binding = "analogLib";

 *)
c4023 ( \TX_SLOPETRIM_1p0(0) , \3:POS_DETECT_1p0  );
capacitor #(.c(7.082e-19)) (*
integer library_binding = "analogLib";

 *)
c4024 ( \TX_SLOPETRIM_1p0(0) , RX10_PRESENT_1p0 );
capacitor #(.c(9.884e-19)) (*
integer library_binding = "analogLib";

 *)
c4025 ( \TX_SLOPETRIM_1p0(0) , SLICER_OUT_1p0 );
capacitor #(.c(7.081e-19)) (*
integer library_binding = "analogLib";

 *)
c4026 ( \TX_SLOPETRIM_1p0(0) , \3:TEST_MODE(2)  );
capacitor #(.c(1.104e-18)) (*
integer library_binding = "analogLib";

 *)
c4027 ( \TX_SLOPETRIM_1p0(0) , \MLT3_TDATA_1p0(0)  );
capacitor #(.c(1.962e-17)) (*
integer library_binding = "analogLib";

 *)
c4028 ( \TX_SLOPETRIM_1p0(0) , \4:X_125  );
capacitor #(.c(7.084e-19)) (*
integer library_binding = "analogLib";

 *)
c4029 ( \TX_SLOPETRIM_1p0(0) , X_125 );
capacitor #(.c(2.018e-17)) (*
integer library_binding = "analogLib";

 *)
c4030 ( \TX_SLOPETRIM_1p0(0) , POS_DETECT_1p0 );
capacitor #(.c(1.723e-17)) (*
integer library_binding = "analogLib";

 *)
c4031 ( \TX_SLOPETRIM_1p0(0) , X_160 );
capacitor #(.c(1.717e-17)) (*
integer library_binding = "analogLib";

 *)
c4032 ( \TX_SLOPETRIM_1p0(0) , \2:ADC_1p0(0)  );
capacitor #(.c(1.31e-17)) (*
integer library_binding = "analogLib";

 *)
c4033 ( \TX_SLOPETRIM_1p0(0) , \1:RCLK125_1p0  );
capacitor #(.c(2.142e-17)) (*
integer library_binding = "analogLib";

 *)
c4034 ( \TX_SLOPETRIM_1p0(0) , \2:ADC_1p0(3)  );
capacitor #(.c(1.835e-17)) (*
integer library_binding = "analogLib";

 *)
c4035 ( \TX_SLOPETRIM_1p0(0) , \FLASH_1p0(0)  );
capacitor #(.c(1.959e-17)) (*
integer library_binding = "analogLib";

 *)
c4036 ( \TX_SLOPETRIM_1p0(0) , \FLASH_1p0(1)  );
capacitor #(.c(1.959e-17)) (*
integer library_binding = "analogLib";

 *)
c4037 ( \TX_SLOPETRIM_1p0(0) , \1:ADC_1p0(4)  );
capacitor #(.c(2.048e-17)) (*
integer library_binding = "analogLib";

 *)
c4038 ( \3:TX_SLOPETRIM_1p0(0) , \3:X_160  );
capacitor #(.c(2.375e-17)) (*
integer library_binding = "analogLib";

 *)
c4039 ( \3:TX_SLOPETRIM_1p0(0) , \3:POS_DETECT_1p0  );
capacitor #(.c(2.09e-17)) (*
integer library_binding = "analogLib";

 *)
c4040 ( \3:TX_SLOPETRIM_1p0(0) , RX10_PRESENT_1p0 );
capacitor #(.c(2.09e-17)) (*
integer library_binding = "analogLib";

 *)
c4041 ( \3:TX_SLOPETRIM_1p0(0) , SLICER_OUT_1p0 );
capacitor #(.c(2.09e-17)) (*
integer library_binding = "analogLib";

 *)
c4042 ( \3:TX_SLOPETRIM_1p0(0) , X_125 );
capacitor #(.c(2.09e-17)) (*
integer library_binding = "analogLib";

 *)
c4043 ( \3:TX_SLOPETRIM_1p0(0) , \3:TEST_MODE(2)  );
capacitor #(.c(2.09e-17)) (*
integer library_binding = "analogLib";

 *)
c4044 ( \3:TX_SLOPETRIM_1p0(0) , \MLT3_TDATA_1p0(0)  );
capacitor #(.c(3.246e-18)) (*
integer library_binding = "analogLib";

 *)
c4045 ( \3:TX_SLOPETRIM_1p0(0) , X_160 );
capacitor #(.c(3.99e-18)) (*
integer library_binding = "analogLib";

 *)
c4046 ( \3:TX_SLOPETRIM_1p0(0) , POS_DETECT_1p0 );
capacitor #(.c(1.578e-15)) (*
integer library_binding = "analogLib";

 *)
c4047 ( \I_REXT_100(6) , \I_RPOLY_100(0)  );
capacitor #(.c(5.203e-16)) (*
integer library_binding = "analogLib";

 *)
c4048 ( \I_REXT_100(6) , \2:I_RPOLY_100(0)  );
capacitor #(.c(4.01e-18)) (*
integer library_binding = "analogLib";

 *)
c4049 ( \I_REXT_100(6) , \5:POS_DETECT_2p5  );
capacitor #(.c(5.74e-18)) (*
integer library_binding = "analogLib";

 *)
c4050 ( \I_REXT_100(6) , POS_DETECT_2p5 );
capacitor #(.c(4.652e-16)) (*
integer library_binding = "analogLib";

 *)
c4051 ( \2:I_REXT_100(6) , \I_RPOLY_100(0)  );
capacitor #(.c(1.182e-18)) (*
integer library_binding = "analogLib";

 *)
c4052 ( \2:I_REXT_100(6) , \5:POS_DETECT_2p5  );
capacitor #(.c(1.692e-18)) (*
integer library_binding = "analogLib";

 *)
c4053 ( \2:I_REXT_100(6) , POS_DETECT_2p5 );
capacitor #(.c(1.643e-14)) (*
integer library_binding = "analogLib";

 *)
c4054 ( \2:I_REXT_100(6) , \2:I_RPOLY_100(0)  );
capacitor #(.c(1.276e-17)) (*
integer library_binding = "analogLib";

 *)
c4055 ( \4:I_REXT_100(6) , \7:I_REXT_50(0)  );
capacitor #(.c(1.246e-17)) (*
integer library_binding = "analogLib";

 *)
c4056 ( \4:I_REXT_100(6) , \4:FLASH_1p0(0)  );
capacitor #(.c(1.246e-17)) (*
integer library_binding = "analogLib";

 *)
c4057 ( \4:I_REXT_100(6) , \ADC_1p0(0)  );
capacitor #(.c(5.952e-17)) (*
integer library_binding = "analogLib";

 *)
c4058 ( \4:I_REXT_100(6) , \2:I_RPOLY_100(0)  );
capacitor #(.c(1.281e-14)) (*
integer library_binding = "analogLib";

 *)
c4059 ( \4:I_REXT_100(6) , \4:I_RPOLY_100(0)  );
capacitor #(.c(1.508e-17)) (*
integer library_binding = "analogLib";

 *)
c4060 ( \4:I_REXT_100(6) , \3:ADC_1p0(4)  );
capacitor #(.c(2.229e-17)) (*
integer library_binding = "analogLib";

 *)
c4061 ( \TENBT_FILTER_1p0(3) , \1:PHASE_IN(5)  );
capacitor #(.c(1.555e-17)) (*
integer library_binding = "analogLib";

 *)
c4062 ( \TENBT_FILTER_1p0(3) , \2:PHASE_IN(9)  );
capacitor #(.c(1.676e-17)) (*
integer library_binding = "analogLib";

 *)
c4063 ( \TENBT_FILTER_1p0(3) , \3:PHASE_IN(7)  );
capacitor #(.c(2.495e-17)) (*
integer library_binding = "analogLib";

 *)
c4064 ( \TENBT_FILTER_1p0(3) , \PHASE_IN(8)  );
capacitor #(.c(9.678e-17)) (*
integer library_binding = "analogLib";

 *)
c4065 ( \TENBT_FILTER_1p0(3) , \TENBT_FILTER_1p0(2)  );
capacitor #(.c(8.611e-17)) (*
integer library_binding = "analogLib";

 *)
c4066 ( \TENBT_FILTER_1p0(3) , \1:PLL_160_IN  );
capacitor #(.c(5.177e-17)) (*
integer library_binding = "analogLib";

 *)
c4067 ( \TENBT_FILTER_1p0(3) , \1:PHASE_IN(1)  );
capacitor #(.c(1.542e-17)) (*
integer library_binding = "analogLib";

 *)
c4068 ( \TENBT_FILTER_1p0(3) , \2:PHASE_IN(2)  );
capacitor #(.c(5.349e-16)) (*
integer library_binding = "analogLib";

 *)
c4069 ( \TENBT_FILTER_1p0(3) , \6:TENBT_FILTER_1p0(2)  );
capacitor #(.c(2.822e-17)) (*
integer library_binding = "analogLib";

 *)
c4070 ( \TENBT_FILTER_1p0(3) , \3:XTAL25  );
capacitor #(.c(3.713e-18)) (*
integer library_binding = "analogLib";

 *)
c4071 ( \5:TENBT_FILTER_1p0(3) , \1:PHASE_IN(1)  );
capacitor #(.c(7.239e-18)) (*
integer library_binding = "analogLib";

 *)
c4072 ( \5:TENBT_FILTER_1p0(3) , \1:PLL_160_IN  );
capacitor #(.c(1.24e-18)) (*
integer library_binding = "analogLib";

 *)
c4073 ( \5:TENBT_FILTER_1p0(3) , \3:XTAL25  );
capacitor #(.c(1.967e-18)) (*
integer library_binding = "analogLib";

 *)
c4074 ( \5:TENBT_FILTER_1p0(3) , \1:PHASE_IN(5)  );
capacitor #(.c(1.373e-18)) (*
integer library_binding = "analogLib";

 *)
c4075 ( \5:TENBT_FILTER_1p0(3) , \2:PHASE_IN(9)  );
capacitor #(.c(1.479e-18)) (*
integer library_binding = "analogLib";

 *)
c4076 ( \5:TENBT_FILTER_1p0(3) , \3:PHASE_IN(7)  );
capacitor #(.c(2.202e-18)) (*
integer library_binding = "analogLib";

 *)
c4077 ( \5:TENBT_FILTER_1p0(3) , \PHASE_IN(8)  );
capacitor #(.c(1.113e-18)) (*
integer library_binding = "analogLib";

 *)
c4078 ( \5:TENBT_FILTER_1p0(3) , \2:PHASE_IN(2)  );
capacitor #(.c(4.654e-17)) (*
integer library_binding = "analogLib";

 *)
c4079 ( \5:TENBT_FILTER_1p0(3) , \6:TENBT_FILTER_1p0(2)  );
capacitor #(.c(4.821e-16)) (*
integer library_binding = "analogLib";

 *)
c4080 ( \5:TENBT_FILTER_1p0(3) , \TENBT_FILTER_1p0(2)  );
capacitor #(.c(4.694e-16)) (*
integer library_binding = "analogLib";

 *)
c4081 ( \5:TENBT_FILTER_1p0(3) , \24:VDDTX  );
capacitor #(.c(5.729e-18)) (*
integer library_binding = "analogLib";

 *)
c4082 ( POS_DETECT_2p5, \I_RPOLY_100(0)  );
capacitor #(.c(1.703e-18)) (*
integer library_binding = "analogLib";

 *)
c4083 ( POS_DETECT_2p5, \2:I_RPOLY_100(0)  );
capacitor #(.c(1.272e-17)) (*
integer library_binding = "analogLib";

 *)
c4084 ( POS_DETECT_2p5, \I_REXT_50(0)  );
capacitor #(.c(1.724e-18)) (*
integer library_binding = "analogLib";

 *)
c4085 ( POS_DETECT_2p5, \I_RPOLY_100(2)  );
capacitor #(.c(5.708e-18)) (*
integer library_binding = "analogLib";

 *)
c4086 ( POS_DETECT_2p5, \3:I_RPOLY_100(2)  );
capacitor #(.c(5.785e-18)) (*
integer library_binding = "analogLib";

 *)
c4087 ( POS_DETECT_2p5, \I_REXT_100(2)  );
capacitor #(.c(1.647e-18)) (*
integer library_binding = "analogLib";

 *)
c4088 ( POS_DETECT_2p5, \2:I_REXT_100(2)  );
capacitor #(.c(1.735e-18)) (*
integer library_binding = "analogLib";

 *)
c4089 ( POS_DETECT_2p5, \2:I_RPOLY_100(3)  );
capacitor #(.c(5.697e-18)) (*
integer library_binding = "analogLib";

 *)
c4090 ( POS_DETECT_2p5, \I_RPOLY_100(3)  );
capacitor #(.c(1.658e-18)) (*
integer library_binding = "analogLib";

 *)
c4091 ( POS_DETECT_2p5, \2:I_REXT_100(3)  );
capacitor #(.c(5.773e-18)) (*
integer library_binding = "analogLib";

 *)
c4092 ( POS_DETECT_2p5, \I_REXT_100(3)  );
capacitor #(.c(1.761e-18)) (*
integer library_binding = "analogLib";

 *)
c4093 ( POS_DETECT_2p5, \2:I_RPOLY_100(4)  );
capacitor #(.c(5.738e-18)) (*
integer library_binding = "analogLib";

 *)
c4094 ( POS_DETECT_2p5, \3:I_RPOLY_100(4)  );
capacitor #(.c(1.67e-18)) (*
integer library_binding = "analogLib";

 *)
c4095 ( POS_DETECT_2p5, \2:I_REXT_100(4)  );
capacitor #(.c(5.762e-18)) (*
integer library_binding = "analogLib";

 *)
c4096 ( POS_DETECT_2p5, \I_REXT_100(4)  );
capacitor #(.c(8.027e-18)) (*
integer library_binding = "analogLib";

 *)
c4097 ( POS_DETECT_2p5, \I_RPOLY_100(5)  );
capacitor #(.c(2.481e-18)) (*
integer library_binding = "analogLib";

 *)
c4098 ( POS_DETECT_2p5, \2:I_RPOLY_100(5)  );
capacitor #(.c(4.002e-18)) (*
integer library_binding = "analogLib";

 *)
c4099 ( \5:POS_DETECT_2p5 , \I_RPOLY_100(0)  );
capacitor #(.c(1.19e-18)) (*
integer library_binding = "analogLib";

 *)
c4100 ( \5:POS_DETECT_2p5 , \2:I_RPOLY_100(0)  );
capacitor #(.c(8.886e-18)) (*
integer library_binding = "analogLib";

 *)
c4101 ( \5:POS_DETECT_2p5 , \I_REXT_50(0)  );
capacitor #(.c(1.204e-18)) (*
integer library_binding = "analogLib";

 *)
c4102 ( \5:POS_DETECT_2p5 , \I_RPOLY_100(2)  );
capacitor #(.c(3.987e-18)) (*
integer library_binding = "analogLib";

 *)
c4103 ( \5:POS_DETECT_2p5 , \3:I_RPOLY_100(2)  );
capacitor #(.c(4.041e-18)) (*
integer library_binding = "analogLib";

 *)
c4104 ( \5:POS_DETECT_2p5 , \I_REXT_100(2)  );
capacitor #(.c(1.15e-18)) (*
integer library_binding = "analogLib";

 *)
c4105 ( \5:POS_DETECT_2p5 , \2:I_REXT_100(2)  );
capacitor #(.c(1.212e-18)) (*
integer library_binding = "analogLib";

 *)
c4106 ( \5:POS_DETECT_2p5 , \2:I_RPOLY_100(3)  );
capacitor #(.c(3.98e-18)) (*
integer library_binding = "analogLib";

 *)
c4107 ( \5:POS_DETECT_2p5 , \I_RPOLY_100(3)  );
capacitor #(.c(1.159e-18)) (*
integer library_binding = "analogLib";

 *)
c4108 ( \5:POS_DETECT_2p5 , \2:I_REXT_100(3)  );
capacitor #(.c(4.033e-18)) (*
integer library_binding = "analogLib";

 *)
c4109 ( \5:POS_DETECT_2p5 , \I_REXT_100(3)  );
capacitor #(.c(1.23e-18)) (*
integer library_binding = "analogLib";

 *)
c4110 ( \5:POS_DETECT_2p5 , \2:I_RPOLY_100(4)  );
capacitor #(.c(4.009e-18)) (*
integer library_binding = "analogLib";

 *)
c4111 ( \5:POS_DETECT_2p5 , \3:I_RPOLY_100(4)  );
capacitor #(.c(1.166e-18)) (*
integer library_binding = "analogLib";

 *)
c4112 ( \5:POS_DETECT_2p5 , \2:I_REXT_100(4)  );
capacitor #(.c(4.025e-18)) (*
integer library_binding = "analogLib";

 *)
c4113 ( \5:POS_DETECT_2p5 , \I_REXT_100(4)  );
capacitor #(.c(5.608e-18)) (*
integer library_binding = "analogLib";

 *)
c4114 ( \5:POS_DETECT_2p5 , \I_RPOLY_100(5)  );
capacitor #(.c(1.733e-18)) (*
integer library_binding = "analogLib";

 *)
c4115 ( \5:POS_DETECT_2p5 , \2:I_RPOLY_100(5)  );
capacitor #(.c(1.276e-17)) (*
integer library_binding = "analogLib";

 *)
c4116 ( \4:I_RPOLY_100(0) , \7:I_REXT_50(0)  );
capacitor #(.c(1.508e-17)) (*
integer library_binding = "analogLib";

 *)
c4117 ( \4:I_RPOLY_100(0) , \3:ADC_1p0(4)  );
capacitor #(.c(1.246e-17)) (*
integer library_binding = "analogLib";

 *)
c4118 ( \4:I_RPOLY_100(0) , \4:FLASH_1p0(0)  );
capacitor #(.c(1.246e-17)) (*
integer library_binding = "analogLib";

 *)
c4119 ( \4:I_RPOLY_100(0) , \ADC_1p0(0)  );
capacitor #(.c(1.799e-17)) (*
integer library_binding = "analogLib";

 *)
c4120 ( \FLASH_1p0(0) , \4:MLT3_TDATA_1p0(0)  );
capacitor #(.c(3.585e-19)) (*
integer library_binding = "analogLib";

 *)
c4121 ( \FLASH_1p0(0) , \MLT3_TDATA_1p0(0)  );
capacitor #(.c(1.991e-18)) (*
integer library_binding = "analogLib";

 *)
c4122 ( \FLASH_1p0(0) , \7:FLASH_1p0(1)  );
capacitor #(.c(1.879e-18)) (*
integer library_binding = "analogLib";

 *)
c4123 ( \FLASH_1p0(0) , RX10_PRESENT_1p0 );
capacitor #(.c(3.517e-19)) (*
integer library_binding = "analogLib";

 *)
c4124 ( \FLASH_1p0(0) , \4:RX10_PRESENT_1p0  );
capacitor #(.c(3.565e-19)) (*
integer library_binding = "analogLib";

 *)
c4125 ( \FLASH_1p0(0) , \TEST_MODE(2)  );
capacitor #(.c(1.874e-18)) (*
integer library_binding = "analogLib";

 *)
c4126 ( \FLASH_1p0(0) , \3:TEST_MODE(2)  );
capacitor #(.c(1.284e-16)) (*
integer library_binding = "analogLib";

 *)
c4127 ( \FLASH_1p0(0) , \TX_SLOPETRIM_1p0(1)  );
capacitor #(.c(6.649e-16)) (*
integer library_binding = "analogLib";

 *)
c4128 ( \FLASH_1p0(0) , SLICER_OUT_1p0 );
capacitor #(.c(8.607e-16)) (*
integer library_binding = "analogLib";

 *)
c4129 ( \FLASH_1p0(0) , \4:TX_SLOPETRIM_1p0(1)  );
capacitor #(.c(2.505e-15)) (*
integer library_binding = "analogLib";

 *)
c4130 ( \FLASH_1p0(0) , \4:SLICER_OUT_1p0  );
capacitor #(.c(1.889e-18)) (*
integer library_binding = "analogLib";

 *)
c4131 ( \FLASH_1p0(0) , X_125 );
capacitor #(.c(1.999e-18)) (*
integer library_binding = "analogLib";

 *)
c4132 ( \FLASH_1p0(0) , \7:ADC_1p0(4)  );
capacitor #(.c(3.415e-19)) (*
integer library_binding = "analogLib";

 *)
c4133 ( \FLASH_1p0(0) , \4:X_125  );
capacitor #(.c(1.835e-17)) (*
integer library_binding = "analogLib";

 *)
c4134 ( \FLASH_1p0(0) , \4:MR_SQUELCH_RANGE_1p0(1)  );
capacitor #(.c(1.835e-17)) (*
integer library_binding = "analogLib";

 *)
c4135 ( \FLASH_1p0(0) , \MR_SQUELCH_RANGE_1p0(0)  );
capacitor #(.c(1.975e-17)) (*
integer library_binding = "analogLib";

 *)
c4136 ( \FLASH_1p0(0) , POS_DETECT_1p0 );
capacitor #(.c(1.835e-17)) (*
integer library_binding = "analogLib";

 *)
c4137 ( \FLASH_1p0(0) , X_160 );
capacitor #(.c(1.835e-17)) (*
integer library_binding = "analogLib";

 *)
c4138 ( \FLASH_1p0(0) , \4:MR_SQUELCH_DISB_1p0  );
capacitor #(.c(1.298e-17)) (*
integer library_binding = "analogLib";

 *)
c4139 ( \FLASH_1p0(0) , \FLASH_1p0(1)  );
capacitor #(.c(1.975e-17)) (*
integer library_binding = "analogLib";

 *)
c4140 ( \FLASH_1p0(0) , NEG_DETECT_1p0 );
capacitor #(.c(1.835e-17)) (*
integer library_binding = "analogLib";

 *)
c4141 ( \FLASH_1p0(0) , \4:TX_AMPTRIM_1p0(1)  );
capacitor #(.c(4.475e-15)) (*
integer library_binding = "analogLib";

 *)
c4142 ( \FLASH_1p0(0) , \1:ADC_1p0(4)  );
capacitor #(.c(1.835e-17)) (*
integer library_binding = "analogLib";

 *)
c4143 ( \FLASH_1p0(0) , XTAL25_1p0 );
capacitor #(.c(4.958e-17)) (*
integer library_binding = "analogLib";

 *)
c4144 ( \FLASH_1p0(0) , \ADC_1p0(4)  );
capacitor #(.c(1.835e-17)) (*
integer library_binding = "analogLib";

 *)
c4145 ( \FLASH_1p0(0) , \TX_AMPTRIM_1p0(0)  );
capacitor #(.c(1.835e-17)) (*
integer library_binding = "analogLib";

 *)
c4146 ( \FLASH_1p0(0) , \5:TXER  );
capacitor #(.c(1.564e-17)) (*
integer library_binding = "analogLib";

 *)
c4147 ( \7:FLASH_1p0(0) , \7:FLASH_1p0(1)  );
capacitor #(.c(1.738e-18)) (*
integer library_binding = "analogLib";

 *)
c4148 ( \7:FLASH_1p0(0) , \FLASH_1p0(1)  );
capacitor #(.c(1.476e-17)) (*
integer library_binding = "analogLib";

 *)
c4149 ( \7:FLASH_1p0(0) , RX10_PRESENT_1p0 );
capacitor #(.c(2.762e-18)) (*
integer library_binding = "analogLib";

 *)
c4150 ( \7:FLASH_1p0(0) , \4:RX10_PRESENT_1p0  );
capacitor #(.c(2.8e-18)) (*
integer library_binding = "analogLib";

 *)
c4151 ( \7:FLASH_1p0(0) , \TEST_MODE(2)  );
capacitor #(.c(1.472e-17)) (*
integer library_binding = "analogLib";

 *)
c4152 ( \7:FLASH_1p0(0) , \3:TEST_MODE(2)  );
capacitor #(.c(9.194e-16)) (*
integer library_binding = "analogLib";

 *)
c4153 ( \7:FLASH_1p0(0) , \TX_SLOPETRIM_1p0(1)  );
capacitor #(.c(1.307e-15)) (*
integer library_binding = "analogLib";

 *)
c4154 ( \7:FLASH_1p0(0) , SLICER_OUT_1p0 );
capacitor #(.c(2.191e-16)) (*
integer library_binding = "analogLib";

 *)
c4155 ( \7:FLASH_1p0(0) , \4:SLICER_OUT_1p0  );
capacitor #(.c(3.372e-16)) (*
integer library_binding = "analogLib";

 *)
c4156 ( \7:FLASH_1p0(0) , \4:TX_SLOPETRIM_1p0(1)  );
capacitor #(.c(1.484e-17)) (*
integer library_binding = "analogLib";

 *)
c4157 ( \7:FLASH_1p0(0) , X_125 );
capacitor #(.c(1.675e-18)) (*
integer library_binding = "analogLib";

 *)
c4158 ( \7:FLASH_1p0(0) , \1:ADC_1p0(4)  );
capacitor #(.c(1.57e-17)) (*
integer library_binding = "analogLib";

 *)
c4159 ( \7:FLASH_1p0(0) , \7:ADC_1p0(4)  );
capacitor #(.c(2.683e-18)) (*
integer library_binding = "analogLib";

 *)
c4160 ( \7:FLASH_1p0(0) , \4:X_125  );
capacitor #(.c(1.336e-17)) (*
integer library_binding = "analogLib";

 *)
c4161 ( \3:FLASH_1p0(0) , \ADC_1p0(3)  );
capacitor #(.c(4.508e-15)) (*
integer library_binding = "analogLib";

 *)
c4162 ( \3:FLASH_1p0(0) , \ADC_1p0(4)  );
capacitor #(.c(2.553e-19)) (*
integer library_binding = "analogLib";

 *)
c4163 ( \4:FLASH_1p0(0) , \6:ADC_1p0(3)  );
capacitor #(.c(1.431e-16)) (*
integer library_binding = "analogLib";

 *)
c4164 ( \4:FLASH_1p0(0) , \6:ADC_1p0(0)  );
capacitor #(.c(1.692e-17)) (*
integer library_binding = "analogLib";

 *)
c4165 ( \4:FLASH_1p0(0) , \7:I_REXT_50(0)  );
capacitor #(.c(2.374e-18)) (*
integer library_binding = "analogLib";

 *)
c4166 ( \4:FLASH_1p0(0) , \I_REXT_50(0)  );
capacitor #(.c(1.573e-17)) (*
integer library_binding = "analogLib";

 *)
c4167 ( \4:FLASH_1p0(0) , \4:I_RPOLY_100(5)  );
capacitor #(.c(1.246e-17)) (*
integer library_binding = "analogLib";

 *)
c4168 ( \4:FLASH_1p0(0) , \I_RPOLY_100(4)  );
capacitor #(.c(1.246e-17)) (*
integer library_binding = "analogLib";

 *)
c4169 ( \4:FLASH_1p0(0) , \4:I_RPOLY_100(3)  );
capacitor #(.c(1.246e-17)) (*
integer library_binding = "analogLib";

 *)
c4170 ( \4:FLASH_1p0(0) , \4:I_REXT_100(4)  );
capacitor #(.c(1.246e-17)) (*
integer library_binding = "analogLib";

 *)
c4171 ( \4:FLASH_1p0(0) , \4:I_RPOLY_100(2)  );
capacitor #(.c(1.246e-17)) (*
integer library_binding = "analogLib";

 *)
c4172 ( \4:FLASH_1p0(0) , \4:I_REXT_100(3)  );
capacitor #(.c(1.246e-17)) (*
integer library_binding = "analogLib";

 *)
c4173 ( \4:FLASH_1p0(0) , \4:I_REXT_100(2)  );
capacitor #(.c(1.899e-17)) (*
integer library_binding = "analogLib";

 *)
c4174 ( \4:FLASH_1p0(0) , \3:ADC_1p0(3)  );
capacitor #(.c(1.03e-14)) (*
integer library_binding = "analogLib";

 *)
c4175 ( \4:FLASH_1p0(0) , \ADC_1p0(0)  );
capacitor #(.c(1.784e-17)) (*
integer library_binding = "analogLib";

 *)
c4176 ( \6:FLASH_1p0(0) , \6:ADC_1p0(3)  );
capacitor #(.c(1.843e-19)) (*
integer library_binding = "analogLib";

 *)
c4177 ( \6:FLASH_1p0(0) , \3:ADC_1p0(3)  );
capacitor #(.c(9.997e-15)) (*
integer library_binding = "analogLib";

 *)
c4178 ( \6:FLASH_1p0(0) , \6:ADC_1p0(0)  );
capacitor #(.c(1.953e-17)) (*
integer library_binding = "analogLib";

 *)
c4179 ( \6:FLASH_1p0(0) , RCLK125_1p0 );
capacitor #(.c(1.351e-19)) (*
integer library_binding = "analogLib";

 *)
c4180 ( \6:FLASH_1p0(0) , \4:RCLK125_1p0  );
capacitor #(.c(3.159e-16)) (*
integer library_binding = "analogLib";

 *)
c4181 ( \6:FLASH_1p0(0) , \ADC_1p0(0)  );
capacitor #(.c(1.993e-17)) (*
integer library_binding = "analogLib";

 *)
c4182 ( \5:TXER , \4:MLT3_TDATA_1p0(0)  );
capacitor #(.c(3.972e-19)) (*
integer library_binding = "analogLib";

 *)
c4183 ( \5:TXER , \MLT3_TDATA_1p0(0)  );
capacitor #(.c(2.817e-19)) (*
integer library_binding = "analogLib";

 *)
c4184 ( \5:TXER , SLICER_OUT_1p0 );
capacitor #(.c(2.735e-18)) (*
integer library_binding = "analogLib";

 *)
c4185 ( \5:TXER , \3:X_160  );
capacitor #(.c(1.644e-17)) (*
integer library_binding = "analogLib";

 *)
c4186 ( \5:TXER , \TEST_MODE(2)  );
capacitor #(.c(1.853e-17)) (*
integer library_binding = "analogLib";

 *)
c4187 ( \5:TXER , \4:SLICER_OUT_1p0  );
capacitor #(.c(1.678e-17)) (*
integer library_binding = "analogLib";

 *)
c4188 ( \5:TXER , \4:RX10_PRESENT_1p0  );
capacitor #(.c(2.56e-18)) (*
integer library_binding = "analogLib";

 *)
c4189 ( \5:TXER , \3:POS_DETECT_1p0  );
capacitor #(.c(1.962e-17)) (*
integer library_binding = "analogLib";

 *)
c4190 ( \5:TXER , \4:X_125  );
capacitor #(.c(2.667e-18)) (*
integer library_binding = "analogLib";

 *)
c4191 ( \5:TXER , \3:XTAL25_1p0  );
capacitor #(.c(2.831e-18)) (*
integer library_binding = "analogLib";

 *)
c4192 ( \5:TXER , \MR_SQUELCH_RANGE_1p0(1)  );
capacitor #(.c(2.637e-18)) (*
integer library_binding = "analogLib";

 *)
c4193 ( \5:TXER , \3:MR_SQUELCH_RANGE_1p0(0)  );
capacitor #(.c(1.571e-17)) (*
integer library_binding = "analogLib";

 *)
c4194 ( \5:TXER , \MR_SQUELCH_RANGE_1p0(0)  );
capacitor #(.c(1.969e-17)) (*
integer library_binding = "analogLib";

 *)
c4195 ( \5:TXER , X_160 );
capacitor #(.c(1.878e-17)) (*
integer library_binding = "analogLib";

 *)
c4196 ( \5:TXER , \4:MR_SQUELCH_RANGE_1p0(1)  );
capacitor #(.c(2.22e-18)) (*
integer library_binding = "analogLib";

 *)
c4197 ( \5:TXER , \3:NEG_DETECT_1p0  );
capacitor #(.c(2.399e-18)) (*
integer library_binding = "analogLib";

 *)
c4198 ( \5:TXER , MR_SQUELCH_DISB_1p0 );
capacitor #(.c(1.396e-17)) (*
integer library_binding = "analogLib";

 *)
c4199 ( \5:TXER , NEG_DETECT_1p0 );
capacitor #(.c(1.453e-17)) (*
integer library_binding = "analogLib";

 *)
c4200 ( \5:TXER , \4:MR_SQUELCH_DISB_1p0  );
capacitor #(.c(1.986e-17)) (*
integer library_binding = "analogLib";

 *)
c4201 ( \5:TXER , POS_DETECT_1p0 );
capacitor #(.c(1.716e-17)) (*
integer library_binding = "analogLib";

 *)
c4202 ( \5:TXER , XTAL25_1p0 );
capacitor #(.c(1.959e-17)) (*
integer library_binding = "analogLib";

 *)
c4203 ( \5:TXER , \FLASH_1p0(1)  );
capacitor #(.c(1.959e-17)) (*
integer library_binding = "analogLib";

 *)
c4204 ( \5:TXER , \1:ADC_1p0(4)  );
capacitor #(.c(1.717e-17)) (*
integer library_binding = "analogLib";

 *)
c4205 ( \5:TXER , \2:ADC_1p0(0)  );
capacitor #(.c(1.31e-17)) (*
integer library_binding = "analogLib";

 *)
c4206 ( \5:TXER , \1:RCLK125_1p0  );
capacitor #(.c(1.778e-17)) (*
integer library_binding = "analogLib";

 *)
c4207 ( \5:TXER , \2:ADC_1p0(3)  );
capacitor #(.c(2.135e-17)) (*
integer library_binding = "analogLib";

 *)
c4208 ( RX10_PRESENT_1p0, \TX_AMPTRIM_1p0(1)  );
capacitor #(.c(6.205e-16)) (*
integer library_binding = "analogLib";

 *)
c4209 ( RX10_PRESENT_1p0, \7:ADC_1p0(3)  );
capacitor #(.c(1.485e-17)) (*
integer library_binding = "analogLib";

 *)
c4210 ( RX10_PRESENT_1p0, \7:FLASH_1p0(1)  );
capacitor #(.c(1.65e-18)) (*
integer library_binding = "analogLib";

 *)
c4211 ( RX10_PRESENT_1p0, \FLASH_1p0(1)  );
capacitor #(.c(2.108e-17)) (*
integer library_binding = "analogLib";

 *)
c4212 ( RX10_PRESENT_1p0, \3:TX_AMPTRIM_1p0(0)  );
capacitor #(.c(1.195e-16)) (*
integer library_binding = "analogLib";

 *)
c4213 ( RX10_PRESENT_1p0, \2:ADC_1p0(3)  );
capacitor #(.c(6.023e-17)) (*
integer library_binding = "analogLib";

 *)
c4214 ( RX10_PRESENT_1p0, \1:RCLK125_1p0  );
capacitor #(.c(6.886e-17)) (*
integer library_binding = "analogLib";

 *)
c4215 ( RX10_PRESENT_1p0, \2:ADC_1p0(0)  );
capacitor #(.c(7.213e-18)) (*
integer library_binding = "analogLib";

 *)
c4216 ( RX10_PRESENT_1p0, X_125 );
capacitor #(.c(1.591e-18)) (*
integer library_binding = "analogLib";

 *)
c4217 ( RX10_PRESENT_1p0, \1:ADC_1p0(4)  );
capacitor #(.c(1.491e-17)) (*
integer library_binding = "analogLib";

 *)
c4218 ( RX10_PRESENT_1p0, \7:ADC_1p0(4)  );
capacitor #(.c(1.304e-18)) (*
integer library_binding = "analogLib";

 *)
c4219 ( RX10_PRESENT_1p0, \4:X_125  );
capacitor #(.c(2.736e-18)) (*
integer library_binding = "analogLib";

 *)
c4220 ( RX10_PRESENT_1p0, \4:TX_SLOPETRIM_1p0(1)  );
capacitor #(.c(2.554e-19)) (*
integer library_binding = "analogLib";

 *)
c4221 ( RX10_PRESENT_1p0, \4:TX_AMPTRIM_1p0(1)  );
capacitor #(.c(5.278e-19)) (*
integer library_binding = "analogLib";

 *)
c4222 ( RX10_PRESENT_1p0, \TX_AMPTRIM_1p0(0)  );
capacitor #(.c(7.688e-16)) (*
integer library_binding = "analogLib";

 *)
c4223 ( RX10_PRESENT_1p0, \TEST_MODE(2)  );
capacitor #(.c(1.615e-17)) (*
integer library_binding = "analogLib";

 *)
c4224 ( RX10_PRESENT_1p0, \TX_SLOPETRIM_1p0(1)  );
capacitor #(.c(4.159e-16)) (*
integer library_binding = "analogLib";

 *)
c4225 ( RX10_PRESENT_1p0, \7:ADC_1p0(0)  );
capacitor #(.c(2.83e-15)) (*
integer library_binding = "analogLib";

 *)
c4226 ( RX10_PRESENT_1p0, \3:TEST_MODE(2)  );
capacitor #(.c(3.579e-16)) (*
integer library_binding = "analogLib";

 *)
c4227 ( RX10_PRESENT_1p0, \7:RCLK125_1p0  );
capacitor #(.c(1.162e-16)) (*
integer library_binding = "analogLib";

 *)
c4228 ( \4:RX10_PRESENT_1p0 , \7:ADC_1p0(3)  );
capacitor #(.c(2.779e-18)) (*
integer library_binding = "analogLib";

 *)
c4229 ( \4:RX10_PRESENT_1p0 , \7:FLASH_1p0(1)  );
capacitor #(.c(3.089e-19)) (*
integer library_binding = "analogLib";

 *)
c4230 ( \4:RX10_PRESENT_1p0 , \FLASH_1p0(1)  );
capacitor #(.c(1.35e-18)) (*
integer library_binding = "analogLib";

 *)
c4231 ( \4:RX10_PRESENT_1p0 , X_125 );
capacitor #(.c(2.978e-19)) (*
integer library_binding = "analogLib";

 *)
c4232 ( \4:RX10_PRESENT_1p0 , \1:ADC_1p0(4)  );
capacitor #(.c(2.791e-18)) (*
integer library_binding = "analogLib";

 *)
c4233 ( \4:RX10_PRESENT_1p0 , \7:ADC_1p0(4)  );
capacitor #(.c(2.441e-19)) (*
integer library_binding = "analogLib";

 *)
c4234 ( \4:RX10_PRESENT_1p0 , \4:X_125  );
capacitor #(.c(3.023e-18)) (*
integer library_binding = "analogLib";

 *)
c4235 ( \4:RX10_PRESENT_1p0 , \TX_SLOPETRIM_1p0(1)  );
capacitor #(.c(7.785e-17)) (*
integer library_binding = "analogLib";

 *)
c4236 ( \4:RX10_PRESENT_1p0 , \7:ADC_1p0(0)  );
capacitor #(.c(6.699e-17)) (*
integer library_binding = "analogLib";

 *)
c4237 ( \4:RX10_PRESENT_1p0 , \7:RCLK125_1p0  );
capacitor #(.c(5.302e-16)) (*
integer library_binding = "analogLib";

 *)
c4238 ( \4:RX10_PRESENT_1p0 , \3:TEST_MODE(2)  );
capacitor #(.c(4.111e-15)) (*
integer library_binding = "analogLib";

 *)
c4239 ( \4:RX10_PRESENT_1p0 , \TEST_MODE(2)  );
capacitor #(.c(4.572e-16)) (*
integer library_binding = "analogLib";

 *)
c4240 ( \4:RX10_PRESENT_1p0 , \1:RCLK125_1p0  );
capacitor #(.c(6.004e-16)) (*
integer library_binding = "analogLib";

 *)
c4241 ( \4:RX10_PRESENT_1p0 , \2:ADC_1p0(0)  );
capacitor #(.c(1.678e-17)) (*
integer library_binding = "analogLib";

 *)
c4242 ( \4:RX10_PRESENT_1p0 , \TX_AMPTRIM_1p0(0)  );
capacitor #(.c(1.678e-17)) (*
integer library_binding = "analogLib";

 *)
c4243 ( \4:RX10_PRESENT_1p0 , \4:TX_AMPTRIM_1p0(1)  );
capacitor #(.c(1.73e-17)) (*
integer library_binding = "analogLib";

 *)
c4244 ( \4:RX10_PRESENT_1p0 , \4:TX_SLOPETRIM_1p0(1)  );
capacitor #(.c(8.44e-16)) (*
integer library_binding = "analogLib";

 *)
c4245 ( \4:RX10_PRESENT_1p0 , \2:ADC_1p0(3)  );
capacitor #(.c(1.991e-17)) (*
integer library_binding = "analogLib";

 *)
c4246 ( \TX_AMPTRIM_1p0(1) , \3:POS_DETECT_1p0  );
capacitor #(.c(2.171e-17)) (*
integer library_binding = "analogLib";

 *)
c4247 ( \TX_AMPTRIM_1p0(1) , \3:TX_AMPTRIM_1p0(0)  );
capacitor #(.c(1.727e-17)) (*
integer library_binding = "analogLib";

 *)
c4248 ( \TX_AMPTRIM_1p0(1) , MR_SQUELCH_DISB_1p0 );
capacitor #(.c(2.174e-17)) (*
integer library_binding = "analogLib";

 *)
c4249 ( \TX_AMPTRIM_1p0(1) , \MR_SQUELCH_RANGE_1p0(1)  );
capacitor #(.c(1.986e-17)) (*
integer library_binding = "analogLib";

 *)
c4250 ( \TX_AMPTRIM_1p0(1) , \3:NEG_DETECT_1p0  );
capacitor #(.c(1.997e-17)) (*
integer library_binding = "analogLib";

 *)
c4251 ( \TX_AMPTRIM_1p0(1) , \3:XTAL25_1p0  );
capacitor #(.c(1.953e-17)) (*
integer library_binding = "analogLib";

 *)
c4252 ( \TX_AMPTRIM_1p0(1) , SLICER_OUT_1p0 );
capacitor #(.c(1.953e-17)) (*
integer library_binding = "analogLib";

 *)
c4253 ( \TX_AMPTRIM_1p0(1) , X_125 );
capacitor #(.c(2.135e-17)) (*
integer library_binding = "analogLib";

 *)
c4254 ( \TX_AMPTRIM_1p0(1) , \3:TEST_MODE(2)  );
capacitor #(.c(1.993e-17)) (*
integer library_binding = "analogLib";

 *)
c4255 ( \TX_AMPTRIM_1p0(1) , \3:X_160  );
capacitor #(.c(1.95e-17)) (*
integer library_binding = "analogLib";

 *)
c4256 ( \TX_AMPTRIM_1p0(1) , \MLT3_TDATA_1p0(0)  );
capacitor #(.c(2.834e-18)) (*
integer library_binding = "analogLib";

 *)
c4257 ( \TX_AMPTRIM_1p0(1) , XTAL25_1p0 );
capacitor #(.c(2.914e-18)) (*
integer library_binding = "analogLib";

 *)
c4258 ( \TX_AMPTRIM_1p0(1) , POS_DETECT_1p0 );
capacitor #(.c(2.132e-18)) (*
integer library_binding = "analogLib";

 *)
c4259 ( \TX_AMPTRIM_1p0(1) , \4:MR_SQUELCH_DISB_1p0  );
capacitor #(.c(2.049e-18)) (*
integer library_binding = "analogLib";

 *)
c4260 ( \TX_AMPTRIM_1p0(1) , NEG_DETECT_1p0 );
capacitor #(.c(2.555e-18)) (*
integer library_binding = "analogLib";

 *)
c4261 ( \TX_AMPTRIM_1p0(1) , \4:MR_SQUELCH_RANGE_1p0(1)  );
capacitor #(.c(2.889e-18)) (*
integer library_binding = "analogLib";

 *)
c4262 ( \TX_AMPTRIM_1p0(1) , X_160 );
capacitor #(.c(3.58e-18)) (*
integer library_binding = "analogLib";

 *)
c4263 ( \TX_AMPTRIM_1p0(1) , \MR_SQUELCH_RANGE_1p0(0)  );
capacitor #(.c(3.326e-17)) (*
integer library_binding = "analogLib";

 *)
c4264 ( \TX_AMPTRIM_1p0(1) , \3:MR_SQUELCH_RANGE_1p0(0)  );
capacitor #(.c(2.275e-18)) (*
integer library_binding = "analogLib";

 *)
c4265 ( \TX_AMPTRIM_1p0(1) , \TX_AMPTRIM_1p0(0)  );
capacitor #(.c(1.993e-17)) (*
integer library_binding = "analogLib";

 *)
c4266 ( \4:TX_AMPTRIM_1p0(1) , \4:MLT3_TDATA_1p0(0)  );
capacitor #(.c(6.29e-19)) (*
integer library_binding = "analogLib";

 *)
c4267 ( \4:TX_AMPTRIM_1p0(1) , \MLT3_TDATA_1p0(0)  );
capacitor #(.c(2.306e-18)) (*
integer library_binding = "analogLib";

 *)
c4268 ( \4:TX_AMPTRIM_1p0(1) , \3:TX_AMPTRIM_1p0(0)  );
capacitor #(.c(2.554e-19)) (*
integer library_binding = "analogLib";

 *)
c4269 ( \4:TX_AMPTRIM_1p0(1) , \3:TEST_MODE(2)  );
capacitor #(.c(5.14e-19)) (*
integer library_binding = "analogLib";

 *)
c4270 ( \4:TX_AMPTRIM_1p0(1) , SLICER_OUT_1p0 );
capacitor #(.c(2.566e-18)) (*
integer library_binding = "analogLib";

 *)
c4271 ( \4:TX_AMPTRIM_1p0(1) , \3:X_160  );
capacitor #(.c(1.644e-17)) (*
integer library_binding = "analogLib";

 *)
c4272 ( \4:TX_AMPTRIM_1p0(1) , \TEST_MODE(2)  );
capacitor #(.c(1.853e-17)) (*
integer library_binding = "analogLib";

 *)
c4273 ( \4:TX_AMPTRIM_1p0(1) , \4:SLICER_OUT_1p0  );
capacitor #(.c(2.417e-18)) (*
integer library_binding = "analogLib";

 *)
c4274 ( \4:TX_AMPTRIM_1p0(1) , \3:POS_DETECT_1p0  );
capacitor #(.c(1.962e-17)) (*
integer library_binding = "analogLib";

 *)
c4275 ( \4:TX_AMPTRIM_1p0(1) , \4:X_125  );
capacitor #(.c(2.341e-19)) (*
integer library_binding = "analogLib";

 *)
c4276 ( \4:TX_AMPTRIM_1p0(1) , X_125 );
capacitor #(.c(2.794e-18)) (*
integer library_binding = "analogLib";

 *)
c4277 ( \4:TX_AMPTRIM_1p0(1) , \3:XTAL25_1p0  );
capacitor #(.c(1.323e-17)) (*
integer library_binding = "analogLib";

 *)
c4278 ( \4:TX_AMPTRIM_1p0(1) , \TX_AMPTRIM_1p0(0)  );
capacitor #(.c(2.495e-18)) (*
integer library_binding = "analogLib";

 *)
c4279 ( \4:TX_AMPTRIM_1p0(1) , \MR_SQUELCH_RANGE_1p0(1)  );
capacitor #(.c(3.633e-18)) (*
integer library_binding = "analogLib";

 *)
c4280 ( \4:TX_AMPTRIM_1p0(1) , \3:MR_SQUELCH_RANGE_1p0(0)  );
capacitor #(.c(1.932e-17)) (*
integer library_binding = "analogLib";

 *)
c4281 ( \4:TX_AMPTRIM_1p0(1) , \MR_SQUELCH_RANGE_1p0(0)  );
capacitor #(.c(1.68e-17)) (*
integer library_binding = "analogLib";

 *)
c4282 ( \4:TX_AMPTRIM_1p0(1) , X_160 );
capacitor #(.c(1.486e-17)) (*
integer library_binding = "analogLib";

 *)
c4283 ( \4:TX_AMPTRIM_1p0(1) , \4:MR_SQUELCH_RANGE_1p0(1)  );
capacitor #(.c(2.127e-18)) (*
integer library_binding = "analogLib";

 *)
c4284 ( \4:TX_AMPTRIM_1p0(1) , \3:NEG_DETECT_1p0  );
capacitor #(.c(2.248e-18)) (*
integer library_binding = "analogLib";

 *)
c4285 ( \4:TX_AMPTRIM_1p0(1) , MR_SQUELCH_DISB_1p0 );
capacitor #(.c(1.192e-17)) (*
integer library_binding = "analogLib";

 *)
c4286 ( \4:TX_AMPTRIM_1p0(1) , NEG_DETECT_1p0 );
capacitor #(.c(1.24e-17)) (*
integer library_binding = "analogLib";

 *)
c4287 ( \4:TX_AMPTRIM_1p0(1) , \4:MR_SQUELCH_DISB_1p0  );
capacitor #(.c(1.695e-17)) (*
integer library_binding = "analogLib";

 *)
c4288 ( \4:TX_AMPTRIM_1p0(1) , POS_DETECT_1p0 );
capacitor #(.c(1.648e-17)) (*
integer library_binding = "analogLib";

 *)
c4289 ( \4:TX_AMPTRIM_1p0(1) , XTAL25_1p0 );
capacitor #(.c(1.717e-17)) (*
integer library_binding = "analogLib";

 *)
c4290 ( \4:TX_AMPTRIM_1p0(1) , \2:ADC_1p0(0)  );
capacitor #(.c(1.31e-17)) (*
integer library_binding = "analogLib";

 *)
c4291 ( \4:TX_AMPTRIM_1p0(1) , \1:RCLK125_1p0  );
capacitor #(.c(1.778e-17)) (*
integer library_binding = "analogLib";

 *)
c4292 ( \4:TX_AMPTRIM_1p0(1) , \2:ADC_1p0(3)  );
capacitor #(.c(1.959e-17)) (*
integer library_binding = "analogLib";

 *)
c4293 ( \4:TX_AMPTRIM_1p0(1) , \FLASH_1p0(1)  );
capacitor #(.c(1.959e-17)) (*
integer library_binding = "analogLib";

 *)
c4294 ( \4:TX_AMPTRIM_1p0(1) , \1:ADC_1p0(4)  );
capacitor #(.c(9.031e-15)) (*
integer library_binding = "analogLib";

 *)
c4295 ( \ADC_1p0(3) , \ADC_1p0(4)  );
capacitor #(.c(4.872e-17)) (*
integer library_binding = "analogLib";

 *)
c4296 ( \ADC_1p0(3) , \3:FLASH_1p0(1)  );
capacitor #(.c(2.499e-16)) (*
integer library_binding = "analogLib";

 *)
c4297 ( \ADC_1p0(3) , \3:ADC_1p0(4)  );
capacitor #(.c(4.202e-15)) (*
integer library_binding = "analogLib";

 *)
c4298 ( \ADC_1p0(3) , \3:ADC_1p0(0)  );
capacitor #(.c(2.175e-19)) (*
integer library_binding = "analogLib";

 *)
c4299 ( \3:ADC_1p0(3) , \6:ADC_1p0(4)  );
capacitor #(.c(1.667e-19)) (*
integer library_binding = "analogLib";

 *)
c4300 ( \3:ADC_1p0(3) , RCLK125_1p0 );
capacitor #(.c(1.406e-17)) (*
integer library_binding = "analogLib";

 *)
c4301 ( \3:ADC_1p0(3) , \7:I_REXT_50(0)  );
capacitor #(.c(1.973e-18)) (*
integer library_binding = "analogLib";

 *)
c4302 ( \3:ADC_1p0(3) , \I_REXT_50(0)  );
capacitor #(.c(8.811e-15)) (*
integer library_binding = "analogLib";

 *)
c4303 ( \3:ADC_1p0(3) , \3:ADC_1p0(4)  );
capacitor #(.c(1.899e-17)) (*
integer library_binding = "analogLib";

 *)
c4304 ( \3:ADC_1p0(3) , \ADC_1p0(0)  );
capacitor #(.c(1.197e-17)) (*
integer library_binding = "analogLib";

 *)
c4305 ( \3:ADC_1p0(3) , \4:I_RPOLY_100(5)  );
capacitor #(.c(2.105e-17)) (*
integer library_binding = "analogLib";

 *)
c4306 ( \6:ADC_1p0(3) , \6:ADC_1p0(4)  );
capacitor #(.c(3.364e-19)) (*
integer library_binding = "analogLib";

 *)
c4307 ( \6:ADC_1p0(3) , \3:ADC_1p0(4)  );
capacitor #(.c(1.116e-19)) (*
integer library_binding = "analogLib";

 *)
c4308 ( \6:ADC_1p0(3) , \4:RCLK125_1p0  );
capacitor #(.c(1.613e-17)) (*
integer library_binding = "analogLib";

 *)
c4309 ( \6:ADC_1p0(3) , RCLK125_1p0 );
capacitor #(.c(1.851e-18)) (*
integer library_binding = "analogLib";

 *)
c4310 ( \2:ADC_1p0(3) , \7:ADC_1p0(0)  );
capacitor #(.c(1.692e-18)) (*
integer library_binding = "analogLib";

 *)
c4311 ( \2:ADC_1p0(3) , \3:TEST_MODE(2)  );
capacitor #(.c(3.219e-19)) (*
integer library_binding = "analogLib";

 *)
c4312 ( \2:ADC_1p0(3) , \TEST_MODE(2)  );
capacitor #(.c(2.448e-19)) (*
integer library_binding = "analogLib";

 *)
c4313 ( \2:ADC_1p0(3) , \FLASH_1p0(1)  );
capacitor #(.c(2.203e-18)) (*
integer library_binding = "analogLib";

 *)
c4314 ( \2:ADC_1p0(3) , \7:FLASH_1p0(1)  );
capacitor #(.c(4.63e-16)) (*
integer library_binding = "analogLib";

 *)
c4315 ( \2:ADC_1p0(3) , \7:RCLK125_1p0  );
capacitor #(.c(1.981e-19)) (*
integer library_binding = "analogLib";

 *)
c4316 ( \2:ADC_1p0(3) , \TX_SLOPETRIM_1p0(1)  );
capacitor #(.c(1.206e-15)) (*
integer library_binding = "analogLib";

 *)
c4317 ( \2:ADC_1p0(3) , \4:X_125  );
capacitor #(.c(3.716e-16)) (*
integer library_binding = "analogLib";

 *)
c4318 ( \2:ADC_1p0(3) , X_125 );
capacitor #(.c(1.778e-17)) (*
integer library_binding = "analogLib";

 *)
c4319 ( \2:ADC_1p0(3) , POS_DETECT_1p0 );
capacitor #(.c(1.778e-17)) (*
integer library_binding = "analogLib";

 *)
c4320 ( \2:ADC_1p0(3) , X_160 );
capacitor #(.c(4.359e-15)) (*
integer library_binding = "analogLib";

 *)
c4321 ( \2:ADC_1p0(3) , \2:ADC_1p0(0)  );
capacitor #(.c(2.853e-17)) (*
integer library_binding = "analogLib";

 *)
c4322 ( \2:ADC_1p0(3) , \4:TX_SLOPETRIM_1p0(1)  );
capacitor #(.c(1.778e-17)) (*
integer library_binding = "analogLib";

 *)
c4323 ( \2:ADC_1p0(3) , \4:MR_SQUELCH_DISB_1p0  );
capacitor #(.c(4.219e-15)) (*
integer library_binding = "analogLib";

 *)
c4324 ( \2:ADC_1p0(3) , \1:RCLK125_1p0  );
capacitor #(.c(1.778e-17)) (*
integer library_binding = "analogLib";

 *)
c4325 ( \2:ADC_1p0(3) , NEG_DETECT_1p0 );
capacitor #(.c(1.778e-17)) (*
integer library_binding = "analogLib";

 *)
c4326 ( \2:ADC_1p0(3) , XTAL25_1p0 );
capacitor #(.c(1.778e-17)) (*
integer library_binding = "analogLib";

 *)
c4327 ( \2:ADC_1p0(3) , \TX_AMPTRIM_1p0(0)  );
capacitor #(.c(1.411e-16)) (*
integer library_binding = "analogLib";

 *)
c4328 ( \2:ADC_1p0(3) , \3:ADC_1p0(0)  );
capacitor #(.c(1.778e-17)) (*
integer library_binding = "analogLib";

 *)
c4329 ( \2:ADC_1p0(3) , \4:MR_SQUELCH_RANGE_1p0(1)  );
capacitor #(.c(1.778e-17)) (*
integer library_binding = "analogLib";

 *)
c4330 ( \2:ADC_1p0(3) , \4:MLT3_TDATA_1p0(0)  );
capacitor #(.c(1.778e-17)) (*
integer library_binding = "analogLib";

 *)
c4331 ( \2:ADC_1p0(3) , \4:SLICER_OUT_1p0  );
capacitor #(.c(1.778e-17)) (*
integer library_binding = "analogLib";

 *)
c4332 ( \2:ADC_1p0(3) , \MR_SQUELCH_RANGE_1p0(0)  );
capacitor #(.c(7.201e-16)) (*
integer library_binding = "analogLib";

 *)
c4333 ( \7:ADC_1p0(3) , X_125 );
capacitor #(.c(1.302e-16)) (*
integer library_binding = "analogLib";

 *)
c4334 ( \7:ADC_1p0(3) , \4:X_125  );
capacitor #(.c(1.971e-18)) (*
integer library_binding = "analogLib";

 *)
c4335 ( \7:ADC_1p0(3) , \2:ADC_1p0(0)  );
capacitor #(.c(1.449e-17)) (*
integer library_binding = "analogLib";

 *)
c4336 ( \7:ADC_1p0(3) , \7:ADC_1p0(0)  );
capacitor #(.c(1.324e-17)) (*
integer library_binding = "analogLib";

 *)
c4337 ( \7:ADC_1p0(3) , \3:TEST_MODE(2)  );
capacitor #(.c(2.52e-18)) (*
integer library_binding = "analogLib";

 *)
c4338 ( \7:ADC_1p0(3) , \TEST_MODE(2)  );
capacitor #(.c(4.128e-16)) (*
integer library_binding = "analogLib";

 *)
c4339 ( \7:ADC_1p0(3) , \1:RCLK125_1p0  );
capacitor #(.c(3.27e-15)) (*
integer library_binding = "analogLib";

 *)
c4340 ( \7:ADC_1p0(3) , \7:RCLK125_1p0  );
capacitor #(.c(1.916e-18)) (*
integer library_binding = "analogLib";

 *)
c4341 ( \7:ADC_1p0(3) , \FLASH_1p0(1)  );
capacitor #(.c(1.724e-17)) (*
integer library_binding = "analogLib";

 *)
c4342 ( \7:ADC_1p0(3) , \7:FLASH_1p0(1)  );
capacitor #(.c(1.261e-19)) (*
integer library_binding = "analogLib";

 *)
c4343 ( RESET_DSP, \MLT3_TDATA_2p5(1)  );
capacitor #(.c(4.606e-18)) (*
integer library_binding = "analogLib";

 *)
c4344 ( RESET_DSP, \3:MR_SQUELCH_DISB_2p5  );
capacitor #(.c(8.304e-18)) (*
integer library_binding = "analogLib";

 *)
c4345 ( RESET_DSP, MR_SQUELCH_DISB_2p5 );
capacitor #(.c(1.321e-19)) (*
integer library_binding = "analogLib";

 *)
c4346 ( RESET_DSP, \3:TP_DISC_2p5  );
capacitor #(.c(1.037e-17)) (*
integer library_binding = "analogLib";

 *)
c4347 ( RESET_DSP, TP_DISC_2p5 );
capacitor #(.c(2.455e-18)) (*
integer library_binding = "analogLib";

 *)
c4348 ( RESET_DSP, \9:TX100_DIS_2p5  );
capacitor #(.c(9.477e-18)) (*
integer library_binding = "analogLib";

 *)
c4349 ( RESET_DSP, \2:TX100_DIS_2p5  );
capacitor #(.c(4.993e-19)) (*
integer library_binding = "analogLib";

 *)
c4350 ( RESET_DSP, \5:ADC_DIS_2p5  );
capacitor #(.c(1.123e-17)) (*
integer library_binding = "analogLib";

 *)
c4351 ( RESET_DSP, BLW_DIS_2p5 );
capacitor #(.c(1.453e-18)) (*
integer library_binding = "analogLib";

 *)
c4352 ( RESET_DSP, \5:BLW_DIS_2p5  );
capacitor #(.c(3.924e-18)) (*
integer library_binding = "analogLib";

 *)
c4353 ( RESET_DSP, RX10_PRESENT_2p5 );
capacitor #(.c(1.889e-17)) (*
integer library_binding = "analogLib";

 *)
c4354 ( RESET_DSP, ADC_DIS_2p5 );
capacitor #(.c(1.612e-17)) (*
integer library_binding = "analogLib";

 *)
c4355 ( RESET_DSP, \6:RX10_PRESENT_2p5  );
capacitor #(.c(1.635e-18)) (*
integer library_binding = "analogLib";

 *)
c4356 ( RESET_DSP, \4:PHASE_IN(10)  );
capacitor #(.c(1.108e-17)) (*
integer library_binding = "analogLib";

 *)
c4357 ( RESET_DSP, \7:PHASE_IN(10)  );
capacitor #(.c(1.204e-19)) (*
integer library_binding = "analogLib";

 *)
c4358 ( RESET_DSP, \1:PLL_160_IN  );
capacitor #(.c(1.896e-17)) (*
integer library_binding = "analogLib";

 *)
c4359 ( RESET_DSP, \4:PLL_160_IN  );
capacitor #(.c(3.051e-20)) (*
integer library_binding = "analogLib";

 *)
c4360 ( RESET_DSP, \3:XTAL25  );
capacitor #(.c(7.324e-18)) (*
integer library_binding = "analogLib";

 *)
c4361 ( RESET_DSP, \6:XTAL25  );
capacitor #(.c(4.212e-17)) (*
integer library_binding = "analogLib";

 *)
c4362 ( RESET_DSP, \25:VDDTX  );
capacitor #(.c(4.118e-18)) (*
integer library_binding = "analogLib";

 *)
c4363 ( RESET_DSP, \5:BASEFX_DIS  );
capacitor #(.c(4.209e-18)) (*
integer library_binding = "analogLib";

 *)
c4364 ( RESET_DSP, \9:BASEFX_DIS  );
capacitor #(.c(1.046e-18)) (*
integer library_binding = "analogLib";

 *)
c4365 ( RESET_DSP, AEQ_DIS_2p5 );
capacitor #(.c(1.9e-17)) (*
integer library_binding = "analogLib";

 *)
c4366 ( RESET_DSP, \6:AEQ_DIS_2p5  );
capacitor #(.c(1.884e-16)) (*
integer library_binding = "analogLib";

 *)
c4367 ( RESET_DSP, \4:RCLK125_TST  );
capacitor #(.c(7.252e-18)) (*
integer library_binding = "analogLib";

 *)
c4368 ( RESET_DSP, \MR_SQUELCH_RANGE_2p5(1)  );
capacitor #(.c(2.792e-18)) (*
integer library_binding = "analogLib";

 *)
c4369 ( RESET_DSP, \3:MR_SQUELCH_RANGE_2p5(1)  );
capacitor #(.c(1.48e-17)) (*
integer library_binding = "analogLib";

 *)
c4370 ( RESET_DSP, \4:MLT3_TDATA_2p5(1)  );
capacitor #(.c(1.042e-17)) (*
integer library_binding = "analogLib";

 *)
c4371 ( RESET_DSP, \3:X10_DIS_2p5  );
capacitor #(.c(2.004e-17)) (*
integer library_binding = "analogLib";

 *)
c4372 ( RESET_DSP, \2:I_REXT_50(0)  );
capacitor #(.c(8.86e-16)) (*
integer library_binding = "analogLib";

 *)
c4373 ( RESET_DSP, RCLK125_TST );
capacitor #(.c(2.608e-18)) (*
integer library_binding = "analogLib";

 *)
c4374 ( \6:RESET_DSP , \4:PHASE_IN(10)  );
capacitor #(.c(1.767e-17)) (*
integer library_binding = "analogLib";

 *)
c4375 ( \6:RESET_DSP , \7:PHASE_IN(10)  );
capacitor #(.c(4.865e-20)) (*
integer library_binding = "analogLib";

 *)
c4376 ( \6:RESET_DSP , \3:XTAL25  );
capacitor #(.c(1.168e-17)) (*
integer library_binding = "analogLib";

 *)
c4377 ( \6:RESET_DSP , \6:XTAL25  );
capacitor #(.c(6.717e-17)) (*
integer library_binding = "analogLib";

 *)
c4378 ( \6:RESET_DSP , \25:VDDTX  );
capacitor #(.c(6.567e-18)) (*
integer library_binding = "analogLib";

 *)
c4379 ( \6:RESET_DSP , \5:BASEFX_DIS  );
capacitor #(.c(6.713e-18)) (*
integer library_binding = "analogLib";

 *)
c4380 ( \6:RESET_DSP , \9:BASEFX_DIS  );
capacitor #(.c(2.653e-19)) (*
integer library_binding = "analogLib";

 *)
c4381 ( \ADC_1p0(0) , \6:ADC_1p0(4)  );
capacitor #(.c(1.389e-17)) (*
integer library_binding = "analogLib";

 *)
c4382 ( \ADC_1p0(0) , \7:I_REXT_50(0)  );
capacitor #(.c(1.95e-18)) (*
integer library_binding = "analogLib";

 *)
c4383 ( \ADC_1p0(0) , \I_REXT_50(0)  );
capacitor #(.c(1.573e-17)) (*
integer library_binding = "analogLib";

 *)
c4384 ( \ADC_1p0(0) , \4:I_RPOLY_100(5)  );
capacitor #(.c(1.246e-17)) (*
integer library_binding = "analogLib";

 *)
c4385 ( \ADC_1p0(0) , \I_RPOLY_100(4)  );
capacitor #(.c(1.246e-17)) (*
integer library_binding = "analogLib";

 *)
c4386 ( \ADC_1p0(0) , \4:I_RPOLY_100(3)  );
capacitor #(.c(1.246e-17)) (*
integer library_binding = "analogLib";

 *)
c4387 ( \ADC_1p0(0) , \4:I_REXT_100(4)  );
capacitor #(.c(1.246e-17)) (*
integer library_binding = "analogLib";

 *)
c4388 ( \ADC_1p0(0) , \4:I_RPOLY_100(2)  );
capacitor #(.c(1.246e-17)) (*
integer library_binding = "analogLib";

 *)
c4389 ( \ADC_1p0(0) , \4:I_REXT_100(3)  );
capacitor #(.c(1.246e-17)) (*
integer library_binding = "analogLib";

 *)
c4390 ( \ADC_1p0(0) , \4:I_REXT_100(2)  );
capacitor #(.c(2.1e-17)) (*
integer library_binding = "analogLib";

 *)
c4391 ( \6:ADC_1p0(0) , \6:ADC_1p0(4)  );
capacitor #(.c(3.357e-19)) (*
integer library_binding = "analogLib";

 *)
c4392 ( \6:ADC_1p0(0) , \3:ADC_1p0(4)  );
capacitor #(.c(2.146e-17)) (*
integer library_binding = "analogLib";

 *)
c4393 ( \6:ADC_1p0(0) , RCLK125_1p0 );
capacitor #(.c(1.484e-19)) (*
integer library_binding = "analogLib";

 *)
c4394 ( \6:ADC_1p0(0) , \4:RCLK125_1p0  );
capacitor #(.c(1.502e-17)) (*
integer library_binding = "analogLib";

 *)
c4395 ( \3:ADC_1p0(0) , \3:FLASH_1p0(1)  );
capacitor #(.c(2.328e-18)) (*
integer library_binding = "analogLib";

 *)
c4396 ( \2:ADC_1p0(0) , \7:FLASH_1p0(1)  );
capacitor #(.c(2.588e-19)) (*
integer library_binding = "analogLib";

 *)
c4397 ( \2:ADC_1p0(0) , \FLASH_1p0(1)  );
capacitor #(.c(8.02e-16)) (*
integer library_binding = "analogLib";

 *)
c4398 ( \2:ADC_1p0(0) , \7:RCLK125_1p0  );
capacitor #(.c(1.29e-16)) (*
integer library_binding = "analogLib";

 *)
c4399 ( \2:ADC_1p0(0) , \3:TEST_MODE(2)  );
capacitor #(.c(1.204e-15)) (*
integer library_binding = "analogLib";

 *)
c4400 ( \2:ADC_1p0(0) , \TEST_MODE(2)  );
capacitor #(.c(1.741e-17)) (*
integer library_binding = "analogLib";

 *)
c4401 ( \2:ADC_1p0(0) , \4:X_125  );
capacitor #(.c(1.832e-17)) (*
integer library_binding = "analogLib";

 *)
c4402 ( \2:ADC_1p0(0) , \4:MR_SQUELCH_DISB_1p0  );
capacitor #(.c(1.832e-17)) (*
integer library_binding = "analogLib";

 *)
c4403 ( \2:ADC_1p0(0) , NEG_DETECT_1p0 );
capacitor #(.c(2.2e-17)) (*
integer library_binding = "analogLib";

 *)
c4404 ( \2:ADC_1p0(0) , XTAL25_1p0 );
capacitor #(.c(1.717e-17)) (*
integer library_binding = "analogLib";

 *)
c4405 ( \2:ADC_1p0(0) , \TX_AMPTRIM_1p0(0)  );
capacitor #(.c(1.832e-17)) (*
integer library_binding = "analogLib";

 *)
c4406 ( \2:ADC_1p0(0) , \4:MR_SQUELCH_RANGE_1p0(1)  );
capacitor #(.c(1.832e-17)) (*
integer library_binding = "analogLib";

 *)
c4407 ( \2:ADC_1p0(0) , \4:MLT3_TDATA_1p0(0)  );
capacitor #(.c(1.832e-17)) (*
integer library_binding = "analogLib";

 *)
c4408 ( \2:ADC_1p0(0) , \4:SLICER_OUT_1p0  );
capacitor #(.c(1.832e-17)) (*
integer library_binding = "analogLib";

 *)
c4409 ( \2:ADC_1p0(0) , \MR_SQUELCH_RANGE_1p0(0)  );
capacitor #(.c(1.832e-17)) (*
integer library_binding = "analogLib";

 *)
c4410 ( \2:ADC_1p0(0) , POS_DETECT_1p0 );
capacitor #(.c(2.2e-17)) (*
integer library_binding = "analogLib";

 *)
c4411 ( \2:ADC_1p0(0) , X_160 );
capacitor #(.c(7.645e-15)) (*
integer library_binding = "analogLib";

 *)
c4412 ( \2:ADC_1p0(0) , \1:RCLK125_1p0  );
capacitor #(.c(1.717e-17)) (*
integer library_binding = "analogLib";

 *)
c4413 ( \2:ADC_1p0(0) , \4:TX_SLOPETRIM_1p0(1)  );
capacitor #(.c(1.712e-17)) (*
integer library_binding = "analogLib";

 *)
c4414 ( \7:ADC_1p0(0) , \7:FLASH_1p0(1)  );
capacitor #(.c(1.903e-18)) (*
integer library_binding = "analogLib";

 *)
c4415 ( \7:ADC_1p0(0) , \FLASH_1p0(1)  );
capacitor #(.c(5.896e-15)) (*
integer library_binding = "analogLib";

 *)
c4416 ( \7:ADC_1p0(0) , \7:RCLK125_1p0  );
capacitor #(.c(9.476e-16)) (*
integer library_binding = "analogLib";

 *)
c4417 ( \7:ADC_1p0(0) , \3:TEST_MODE(2)  );
capacitor #(.c(8.056e-16)) (*
integer library_binding = "analogLib";

 *)
c4418 ( \7:ADC_1p0(0) , \1:RCLK125_1p0  );
capacitor #(.c(2.22e-16)) (*
integer library_binding = "analogLib";

 *)
c4419 ( \7:ADC_1p0(0) , \TEST_MODE(2)  );
capacitor #(.c(4.568e-18)) (*
integer library_binding = "analogLib";

 *)
c4420 ( \TENBT_FILTER_1p0(2) , \PHASE_IN(8)  );
capacitor #(.c(1.949e-18)) (*
integer library_binding = "analogLib";

 *)
c4421 ( \TENBT_FILTER_1p0(2) , \2:PHASE_IN(2)  );
capacitor #(.c(6.337e-18)) (*
integer library_binding = "analogLib";

 *)
c4422 ( \TENBT_FILTER_1p0(2) , \1:PHASE_IN(1)  );
capacitor #(.c(1.323e-17)) (*
integer library_binding = "analogLib";

 *)
c4423 ( \TENBT_FILTER_1p0(2) , \1:PLL_160_IN  );
capacitor #(.c(2.639e-18)) (*
integer library_binding = "analogLib";

 *)
c4424 ( \TENBT_FILTER_1p0(2) , \2:PHASE_IN(9)  );
capacitor #(.c(3.827e-18)) (*
integer library_binding = "analogLib";

 *)
c4425 ( \TENBT_FILTER_1p0(2) , \1:PHASE_IN(5)  );
capacitor #(.c(2.844e-18)) (*
integer library_binding = "analogLib";

 *)
c4426 ( \TENBT_FILTER_1p0(2) , \3:PHASE_IN(7)  );
capacitor #(.c(1.756e-18)) (*
integer library_binding = "analogLib";

 *)
c4427 ( \TENBT_FILTER_1p0(2) , \3:XTAL25  );
capacitor #(.c(1.249e-18)) (*
integer library_binding = "analogLib";

 *)
c4428 ( \TENBT_FILTER_1p0(2) , \TENBT_FILTER_1p0(1)  );
capacitor #(.c(4.915e-20)) (*
integer library_binding = "analogLib";

 *)
c4429 ( \TENBT_FILTER_1p0(2) , \5:TENBT_FILTER_1p0(1)  );
capacitor #(.c(4.694e-16)) (*
integer library_binding = "analogLib";

 *)
c4430 ( \TENBT_FILTER_1p0(2) , \24:VDDTX  );
capacitor #(.c(2.474e-17)) (*
integer library_binding = "analogLib";

 *)
c4431 ( \6:TENBT_FILTER_1p0(2) , \PHASE_IN(8)  );
capacitor #(.c(1.429e-17)) (*
integer library_binding = "analogLib";

 *)
c4432 ( \6:TENBT_FILTER_1p0(2) , \2:PHASE_IN(9)  );
capacitor #(.c(2.073e-17)) (*
integer library_binding = "analogLib";

 *)
c4433 ( \6:TENBT_FILTER_1p0(2) , \1:PHASE_IN(5)  );
capacitor #(.c(1.54e-17)) (*
integer library_binding = "analogLib";

 *)
c4434 ( \6:TENBT_FILTER_1p0(2) , \3:PHASE_IN(7)  );
capacitor #(.c(5.224e-19)) (*
integer library_binding = "analogLib";

 *)
c4435 ( \6:TENBT_FILTER_1p0(2) , \5:TENBT_FILTER_1p0(1)  );
capacitor #(.c(5.039e-17)) (*
integer library_binding = "analogLib";

 *)
c4436 ( \6:TENBT_FILTER_1p0(2) , \1:PHASE_IN(1)  );
capacitor #(.c(7.719e-17)) (*
integer library_binding = "analogLib";

 *)
c4437 ( \6:TENBT_FILTER_1p0(2) , \1:PLL_160_IN  );
capacitor #(.c(1.459e-17)) (*
integer library_binding = "analogLib";

 *)
c4438 ( \6:TENBT_FILTER_1p0(2) , \2:PHASE_IN(2)  );
capacitor #(.c(1.328e-17)) (*
integer library_binding = "analogLib";

 *)
c4439 ( \6:TENBT_FILTER_1p0(2) , \TENBT_FILTER_1p0(1)  );
capacitor #(.c(2.639e-17)) (*
integer library_binding = "analogLib";

 *)
c4440 ( \6:TENBT_FILTER_1p0(2) , \3:XTAL25  );
capacitor #(.c(2.773e-16)) (*
integer library_binding = "analogLib";

 *)
c4441 ( \PHASE_IN(2) , \5:PHASE_IN(5)  );
capacitor #(.c(1.113e-17)) (*
integer library_binding = "analogLib";

 *)
c4442 ( \PHASE_IN(2) , \24:VDDTX  );
capacitor #(.c(5.846e-17)) (*
integer library_binding = "analogLib";

 *)
c4443 ( \PHASE_IN(2) , \25:VDDTX  );
capacitor #(.c(4.433e-17)) (*
integer library_binding = "analogLib";

 *)
c4444 ( \PHASE_IN(2) , \4:PHASE_IN(3)  );
capacitor #(.c(3.993e-18)) (*
integer library_binding = "analogLib";

 *)
c4445 ( \PHASE_IN(2) , \7:PHASE_IN(8)  );
capacitor #(.c(2.548e-18)) (*
integer library_binding = "analogLib";

 *)
c4446 ( \PHASE_IN(2) , \4:PHASE_IN(8)  );
capacitor #(.c(2.063e-16)) (*
integer library_binding = "analogLib";

 *)
c4447 ( \PHASE_IN(2) , \2:PHASE_IN(5)  );
capacitor #(.c(2.893e-18)) (*
integer library_binding = "analogLib";

 *)
c4448 ( \PHASE_IN(2) , \4:PHASE_IN(9)  );
capacitor #(.c(4.906e-18)) (*
integer library_binding = "analogLib";

 *)
c4449 ( \PHASE_IN(2) , \7:PHASE_IN(9)  );
capacitor #(.c(5.925e-17)) (*
integer library_binding = "analogLib";

 *)
c4450 ( \PHASE_IN(2) , \2:PHASE_IN(1)  );
capacitor #(.c(1.861e-18)) (*
integer library_binding = "analogLib";

 *)
c4451 ( \PHASE_IN(2) , \5:PHASE_IN(7)  );
capacitor #(.c(9.052e-18)) (*
integer library_binding = "analogLib";

 *)
c4452 ( \PHASE_IN(2) , \7:PHASE_IN(7)  );
capacitor #(.c(3.175e-16)) (*
integer library_binding = "analogLib";

 *)
c4453 ( \PHASE_IN(2) , \5:PHASE_IN(1)  );
capacitor #(.c(2.435e-16)) (*
integer library_binding = "analogLib";

 *)
c4454 ( \PHASE_IN(2) , \7:PHASE_IN(3)  );
capacitor #(.c(5.814e-18)) (*
integer library_binding = "analogLib";

 *)
c4455 ( \4:PHASE_IN(2) , \WANDER_CNT(4)  );
capacitor #(.c(2.078e-16)) (*
integer library_binding = "analogLib";

 *)
c4456 ( \4:PHASE_IN(2) , \5:PHASE_IN(5)  );
capacitor #(.c(4.678e-17)) (*
integer library_binding = "analogLib";

 *)
c4457 ( \4:PHASE_IN(2) , \24:VDDTX  );
capacitor #(.c(2.456e-16)) (*
integer library_binding = "analogLib";

 *)
c4458 ( \4:PHASE_IN(2) , \25:VDDTX  );
capacitor #(.c(9.833e-16)) (*
integer library_binding = "analogLib";

 *)
c4459 ( \4:PHASE_IN(2) , \4:PLL_160_IN  );
capacitor #(.c(3.749e-16)) (*
integer library_binding = "analogLib";

 *)
c4460 ( \4:PHASE_IN(2) , \6:XTAL25  );
capacitor #(.c(2.64e-17)) (*
integer library_binding = "analogLib";

 *)
c4461 ( \4:PHASE_IN(2) , \7:PHASE_IN(3)  );
capacitor #(.c(2.992e-18)) (*
integer library_binding = "analogLib";

 *)
c4462 ( \4:PHASE_IN(2) , \7:PHASE_IN(8)  );
capacitor #(.c(6.128e-17)) (*
integer library_binding = "analogLib";

 *)
c4463 ( \4:PHASE_IN(2) , \5:PHASE_IN(1)  );
capacitor #(.c(2.167e-18)) (*
integer library_binding = "analogLib";

 *)
c4464 ( \4:PHASE_IN(2) , \4:PHASE_IN(9)  );
capacitor #(.c(3.676e-18)) (*
integer library_binding = "analogLib";

 *)
c4465 ( \4:PHASE_IN(2) , \7:PHASE_IN(9)  );
capacitor #(.c(6.837e-17)) (*
integer library_binding = "analogLib";

 *)
c4466 ( \4:PHASE_IN(2) , \5:WANDER_CNT(4)  );
capacitor #(.c(3.675e-17)) (*
integer library_binding = "analogLib";

 *)
c4467 ( \4:PHASE_IN(2) , \1:PLL_160_IN  );
capacitor #(.c(2.044e-14)) (*
integer library_binding = "analogLib";

 *)
c4468 ( \4:PHASE_IN(2) , \4:PHASE_IN(8)  );
capacitor #(.c(4.987e-17)) (*
integer library_binding = "analogLib";

 *)
c4469 ( \4:PHASE_IN(2) , \3:XTAL25  );
capacitor #(.c(2.563e-17)) (*
integer library_binding = "analogLib";

 *)
c4470 ( \4:PHASE_IN(2) , \4:PHASE_IN(3)  );
capacitor #(.c(1.204e-17)) (*
integer library_binding = "analogLib";

 *)
c4471 ( \4:PHASE_IN(2) , \4:PHASE_IN(10)  );
capacitor #(.c(1.464e-15)) (*
integer library_binding = "analogLib";

 *)
c4472 ( \4:PHASE_IN(2) , \2:PHASE_IN(1)  );
capacitor #(.c(1.122e-15)) (*
integer library_binding = "analogLib";

 *)
c4473 ( \4:PHASE_IN(2) , \2:PHASE_IN(5)  );
capacitor #(.c(1.963e-17)) (*
integer library_binding = "analogLib";

 *)
c4474 ( \4:PHASE_IN(2) , \5:BASEFX_DIS  );
capacitor #(.c(2.297e-17)) (*
integer library_binding = "analogLib";

 *)
c4475 ( \2:PHASE_IN(2) , RESET_10BT );
capacitor #(.c(1.06e-18)) (*
integer library_binding = "analogLib";

 *)
c4476 ( \2:PHASE_IN(2) , \6:PHASE_IN(10)  );
capacitor #(.c(5.633e-18)) (*
integer library_binding = "analogLib";

 *)
c4477 ( \2:PHASE_IN(2) , \PHASE_IN(3)  );
capacitor #(.c(1.037e-17)) (*
integer library_binding = "analogLib";

 *)
c4478 ( \2:PHASE_IN(2) , \TENBT_FILTER_1p0(1)  );
capacitor #(.c(8.998e-19)) (*
integer library_binding = "analogLib";

 *)
c4479 ( \2:PHASE_IN(2) , \5:TENBT_FILTER_1p0(1)  );
capacitor #(.c(2.113e-18)) (*
integer library_binding = "analogLib";

 *)
c4480 ( \2:PHASE_IN(2) , \TENBT_FILTER_1p0(0)  );
capacitor #(.c(1.696e-17)) (*
integer library_binding = "analogLib";

 *)
c4481 ( \2:PHASE_IN(2) , \6:TENBT_FILTER_1p0(0)  );
capacitor #(.c(1.943e-18)) (*
integer library_binding = "analogLib";

 *)
c4482 ( \2:PHASE_IN(2) , TENBT_CLK160_1p0 );
capacitor #(.c(3.007e-18)) (*
integer library_binding = "analogLib";

 *)
c4483 ( \2:PHASE_IN(2) , \5:RESET_10BT  );
capacitor #(.c(1.459e-17)) (*
integer library_binding = "analogLib";

 *)
c4484 ( \2:PHASE_IN(2) , \6:TENBT_CLK160_1p0  );
capacitor #(.c(2.901e-17)) (*
integer library_binding = "analogLib";

 *)
c4485 ( \2:PHASE_IN(2) , \4:PHASE_IN(8)  );
capacitor #(.c(2.398e-17)) (*
integer library_binding = "analogLib";

 *)
c4486 ( \2:PHASE_IN(2) , \2:PHASE_IN(3)  );
capacitor #(.c(1.74e-17)) (*
integer library_binding = "analogLib";

 *)
c4487 ( \2:PHASE_IN(2) , \2:PHASE_IN(1)  );
capacitor #(.c(2.049e-14)) (*
integer library_binding = "analogLib";

 *)
c4488 ( \2:PHASE_IN(2) , \PHASE_IN(8)  );
capacitor #(.c(5.061e-16)) (*
integer library_binding = "analogLib";

 *)
c4489 ( \2:PHASE_IN(2) , \3:XTAL25  );
capacitor #(.c(1.06e-15)) (*
integer library_binding = "analogLib";

 *)
c4490 ( \2:PHASE_IN(2) , \1:PLL_160_IN  );
capacitor #(.c(1.565e-15)) (*
integer library_binding = "analogLib";

 *)
c4491 ( \2:PHASE_IN(2) , \1:PHASE_IN(1)  );
capacitor #(.c(2.055e-17)) (*
integer library_binding = "analogLib";

 *)
c4492 ( \6:PHASE_IN(2) , \6:PHASE_IN(10)  );
capacitor #(.c(5.744e-18)) (*
integer library_binding = "analogLib";

 *)
c4493 ( \6:PHASE_IN(2) , \2:PHASE_IN(3)  );
capacitor #(.c(2.19e-16)) (*
integer library_binding = "analogLib";

 *)
c4494 ( \6:PHASE_IN(2) , \PHASE_IN(3)  );
capacitor #(.c(5.261e-17)) (*
integer library_binding = "analogLib";

 *)
c4495 ( \6:PHASE_IN(2) , \PHASE_IN(1)  );
capacitor #(.c(3.36e-18)) (*
integer library_binding = "analogLib";

 *)
c4496 ( X_160, \3:TX_AMPTRIM_1p0(0)  );
capacitor #(.c(1.103e-18)) (*
integer library_binding = "analogLib";

 *)
c4497 ( X_160, SLICER_OUT_1p0 );
capacitor #(.c(1.853e-17)) (*
integer library_binding = "analogLib";

 *)
c4498 ( X_160, \4:SLICER_OUT_1p0  );
capacitor #(.c(3.033e-18)) (*
integer library_binding = "analogLib";

 *)
c4499 ( X_160, \3:POS_DETECT_1p0  );
capacitor #(.c(1.962e-17)) (*
integer library_binding = "analogLib";

 *)
c4500 ( X_160, \4:X_125  );
capacitor #(.c(8.235e-19)) (*
integer library_binding = "analogLib";

 *)
c4501 ( X_160, X_125 );
capacitor #(.c(1.706e-17)) (*
integer library_binding = "analogLib";

 *)
c4502 ( X_160, \TX_AMPTRIM_1p0(0)  );
capacitor #(.c(3.294e-18)) (*
integer library_binding = "analogLib";

 *)
c4503 ( X_160, \MR_SQUELCH_RANGE_1p0(1)  );
capacitor #(.c(2.83e-18)) (*
integer library_binding = "analogLib";

 *)
c4504 ( X_160, \3:MR_SQUELCH_RANGE_1p0(0)  );
capacitor #(.c(1.686e-17)) (*
integer library_binding = "analogLib";

 *)
c4505 ( X_160, \MR_SQUELCH_RANGE_1p0(0)  );
capacitor #(.c(1.747e-17)) (*
integer library_binding = "analogLib";

 *)
c4506 ( X_160, POS_DETECT_1p0 );
capacitor #(.c(1.69e-17)) (*
integer library_binding = "analogLib";

 *)
c4507 ( X_160, \4:MR_SQUELCH_DISB_1p0  );
capacitor #(.c(2.789e-18)) (*
integer library_binding = "analogLib";

 *)
c4508 ( X_160, MR_SQUELCH_DISB_1p0 );
capacitor #(.c(1.713e-17)) (*
integer library_binding = "analogLib";

 *)
c4509 ( X_160, \4:MR_SQUELCH_RANGE_1p0(1)  );
capacitor #(.c(1.729e-17)) (*
integer library_binding = "analogLib";

 *)
c4510 ( X_160, \1:RCLK125_1p0  );
capacitor #(.c(1.959e-17)) (*
integer library_binding = "analogLib";

 *)
c4511 ( X_160, \FLASH_1p0(1)  );
capacitor #(.c(1.959e-17)) (*
integer library_binding = "analogLib";

 *)
c4512 ( X_160, \1:ADC_1p0(4)  );
capacitor #(.c(1.92e-17)) (*
integer library_binding = "analogLib";

 *)
c4513 ( \3:X_160 , \3:TX_AMPTRIM_1p0(0)  );
capacitor #(.c(2.16e-17)) (*
integer library_binding = "analogLib";

 *)
c4514 ( \3:X_160 , SLICER_OUT_1p0 );
capacitor #(.c(2.16e-17)) (*
integer library_binding = "analogLib";

 *)
c4515 ( \3:X_160 , X_125 );
capacitor #(.c(2.907e-18)) (*
integer library_binding = "analogLib";

 *)
c4516 ( \3:X_160 , \4:MR_SQUELCH_RANGE_1p0(1)  );
capacitor #(.c(3.383e-18)) (*
integer library_binding = "analogLib";

 *)
c4517 ( \3:X_160 , POS_DETECT_1p0 );
capacitor #(.c(1.914e-17)) (*
integer library_binding = "analogLib";

 *)
c4518 ( \3:X_160 , \MR_SQUELCH_RANGE_1p0(1)  );
capacitor #(.c(2.838e-18)) (*
integer library_binding = "analogLib";

 *)
c4519 ( \3:X_160 , \TX_AMPTRIM_1p0(0)  );
capacitor #(.c(2.095e-17)) (*
integer library_binding = "analogLib";

 *)
c4520 ( \3:X_160 , \3:POS_DETECT_1p0  );
capacitor #(.c(2.485e-18)) (*
integer library_binding = "analogLib";

 *)
c4521 ( \3:X_160 , \MR_SQUELCH_RANGE_1p0(0)  );
capacitor #(.c(1.859e-17)) (*
integer library_binding = "analogLib";

 *)
c4522 ( \3:X_160 , \3:MR_SQUELCH_RANGE_1p0(0)  );
capacitor #(.c(1.701e-17)) (*
integer library_binding = "analogLib";

 *)
c4523 ( \3:X_160 , MR_SQUELCH_DISB_1p0 );
capacitor #(.c(2.66e-18)) (*
integer library_binding = "analogLib";

 *)
c4524 ( \3:X_160 , \4:MR_SQUELCH_DISB_1p0  );
capacitor #(.c(8.528e-20)) (*
integer library_binding = "analogLib";

 *)
c4525 ( AEQ_BYPASS, \5:WANDER_CNT(4)  );
capacitor #(.c(2.591e-17)) (*
integer library_binding = "analogLib";

 *)
c4526 ( AEQ_BYPASS, \WANDER_CNT(4)  );
capacitor #(.c(5.6e-16)) (*
integer library_binding = "analogLib";

 *)
c4527 ( AEQ_BYPASS, \4:WANDER_CNT(0)  );
capacitor #(.c(3.092e-16)) (*
integer library_binding = "analogLib";

 *)
c4528 ( AEQ_BYPASS, ADC_DIS_2p5 );
capacitor #(.c(6.395e-16)) (*
integer library_binding = "analogLib";

 *)
c4529 ( AEQ_BYPASS, \WANDER_CNT(0)  );
capacitor #(.c(9.037e-16)) (*
integer library_binding = "analogLib";

 *)
c4530 ( AEQ_BYPASS, \5:ADC_DIS_2p5  );
capacitor #(.c(9.489e-19)) (*
integer library_binding = "analogLib";

 *)
c4531 ( \6:AEQ_BYPASS , \WANDER_CNT(4)  );
capacitor #(.c(1.052e-16)) (*
integer library_binding = "analogLib";

 *)
c4532 ( \6:AEQ_BYPASS , \5:ADC_DIS_2p5  );
capacitor #(.c(6.862e-16)) (*
integer library_binding = "analogLib";

 *)
c4533 ( \6:AEQ_BYPASS , \WANDER_CNT(0)  );
capacitor #(.c(6.278e-17)) (*
integer library_binding = "analogLib";

 *)
c4534 ( \6:AEQ_BYPASS , \4:WANDER_CNT(0)  );
capacitor #(.c(1.735e-17)) (*
integer library_binding = "analogLib";

 *)
c4535 ( \6:AEQ_BYPASS , \24:VDDTX  );
capacitor #(.c(9.109e-17)) (*
integer library_binding = "analogLib";

 *)
c4536 ( \6:AEQ_BYPASS , \25:VDDTX  );
capacitor #(.c(5.265e-16)) (*
integer library_binding = "analogLib";

 *)
c4537 ( \6:AEQ_BYPASS , ADC_DIS_2p5 );
capacitor #(.c(4.985e-18)) (*
integer library_binding = "analogLib";

 *)
c4538 ( \6:AEQ_BYPASS , \5:WANDER_CNT(4)  );
capacitor #(.c(1.102e-17)) (*
integer library_binding = "analogLib";

 *)
c4539 ( \6:AEQ_BYPASS , \5:BASEFX_DIS  );
capacitor #(.c(2.033e-17)) (*
integer library_binding = "analogLib";

 *)
c4540 ( \PHASE_IN(3) , \6:PHASE_IN(10)  );
capacitor #(.c(2.148e-17)) (*
integer library_binding = "analogLib";

 *)
c4541 ( \PHASE_IN(3) , \PHASE_IN(1)  );
capacitor #(.c(1.274e-18)) (*
integer library_binding = "analogLib";

 *)
c4542 ( \2:PHASE_IN(3) , \6:PHASE_IN(10)  );
capacitor #(.c(6.886e-19)) (*
integer library_binding = "analogLib";

 *)
c4543 ( \2:PHASE_IN(3) , \TENBT_FILTER_1p0(0)  );
capacitor #(.c(9.399e-18)) (*
integer library_binding = "analogLib";

 *)
c4544 ( \2:PHASE_IN(3) , \6:TENBT_FILTER_1p0(0)  );
capacitor #(.c(7.859e-19)) (*
integer library_binding = "analogLib";

 *)
c4545 ( \2:PHASE_IN(3) , \5:RESET_10BT  );
capacitor #(.c(9.33e-18)) (*
integer library_binding = "analogLib";

 *)
c4546 ( \2:PHASE_IN(3) , RESET_10BT );
capacitor #(.c(1.344e-17)) (*
integer library_binding = "analogLib";

 *)
c4547 ( \2:PHASE_IN(3) , \2:PHASE_IN(1)  );
capacitor #(.c(2.085e-15)) (*
integer library_binding = "analogLib";

 *)
c4548 ( \2:PHASE_IN(3) , \3:XTAL25  );
capacitor #(.c(9.571e-15)) (*
integer library_binding = "analogLib";

 *)
c4549 ( \2:PHASE_IN(3) , \PHASE_IN(10)  );
capacitor #(.c(6.232e-16)) (*
integer library_binding = "analogLib";

 *)
c4550 ( \2:PHASE_IN(3) , \1:PHASE_IN(1)  );
capacitor #(.c(4.604e-17)) (*
integer library_binding = "analogLib";

 *)
c4551 ( \4:PHASE_IN(3) , \24:VDDTX  );
capacitor #(.c(2.417e-16)) (*
integer library_binding = "analogLib";

 *)
c4552 ( \4:PHASE_IN(3) , \25:VDDTX  );
capacitor #(.c(1.608e-15)) (*
integer library_binding = "analogLib";

 *)
c4553 ( \4:PHASE_IN(3) , \6:XTAL25  );
capacitor #(.c(2.767e-18)) (*
integer library_binding = "analogLib";

 *)
c4554 ( \4:PHASE_IN(3) , \7:PHASE_IN(7)  );
capacitor #(.c(5.689e-19)) (*
integer library_binding = "analogLib";

 *)
c4555 ( \4:PHASE_IN(3) , \5:PHASE_IN(7)  );
capacitor #(.c(2.381e-18)) (*
integer library_binding = "analogLib";

 *)
c4556 ( \4:PHASE_IN(3) , \5:PHASE_IN(1)  );
capacitor #(.c(9.045e-16)) (*
integer library_binding = "analogLib";

 *)
c4557 ( \4:PHASE_IN(3) , \PHASE_IN(10)  );
capacitor #(.c(4.97e-16)) (*
integer library_binding = "analogLib";

 *)
c4558 ( \4:PHASE_IN(3) , \2:PHASE_IN(1)  );
capacitor #(.c(1.085e-17)) (*
integer library_binding = "analogLib";

 *)
c4559 ( \4:PHASE_IN(3) , \4:PHASE_IN(9)  );
capacitor #(.c(1.007e-14)) (*
integer library_binding = "analogLib";

 *)
c4560 ( \4:PHASE_IN(3) , \4:PHASE_IN(10)  );
capacitor #(.c(1.958e-16)) (*
integer library_binding = "analogLib";

 *)
c4561 ( \4:PHASE_IN(3) , \3:XTAL25  );
capacitor #(.c(2.003e-17)) (*
integer library_binding = "analogLib";

 *)
c4562 ( \4:PHASE_IN(3) , \5:BASEFX_DIS  );
capacitor #(.c(1.374e-17)) (*
integer library_binding = "analogLib";

 *)
c4563 ( \7:PHASE_IN(3) , \24:VDDTX  );
capacitor #(.c(7.212e-17)) (*
integer library_binding = "analogLib";

 *)
c4564 ( \7:PHASE_IN(3) , \25:VDDTX  );
capacitor #(.c(5.755e-18)) (*
integer library_binding = "analogLib";

 *)
c4565 ( \7:PHASE_IN(3) , \7:PHASE_IN(7)  );
capacitor #(.c(1.183e-18)) (*
integer library_binding = "analogLib";

 *)
c4566 ( \7:PHASE_IN(3) , \5:PHASE_IN(7)  );
capacitor #(.c(4.018e-18)) (*
integer library_binding = "analogLib";

 *)
c4567 ( \7:PHASE_IN(3) , \2:PHASE_IN(1)  );
capacitor #(.c(4.951e-18)) (*
integer library_binding = "analogLib";

 *)
c4568 ( \7:PHASE_IN(3) , \5:PHASE_IN(1)  );
capacitor #(.c(1.422e-17)) (*
integer library_binding = "analogLib";

 *)
c4569 ( \MR_SQUELCH_RANGE_2p5(1) , \PHASE_250(2)  );
capacitor #(.c(1.035e-17)) (*
integer library_binding = "analogLib";

 *)
c4570 ( \MR_SQUELCH_RANGE_2p5(1) , \4:PHASE_250(2)  );
capacitor #(.c(4.165e-18)) (*
integer library_binding = "analogLib";

 *)
c4571 ( \MR_SQUELCH_RANGE_2p5(1) , \PHASE_250(8)  );
capacitor #(.c(3.24e-18)) (*
integer library_binding = "analogLib";

 *)
c4572 ( \MR_SQUELCH_RANGE_2p5(1) , \3:MR_SQUELCH_DISB_2p5  );
capacitor #(.c(9.552e-17)) (*
integer library_binding = "analogLib";

 *)
c4573 ( \MR_SQUELCH_RANGE_2p5(1) , \3:PHASE_250(1)  );
capacitor #(.c(6.021e-17)) (*
integer library_binding = "analogLib";

 *)
c4574 ( \MR_SQUELCH_RANGE_2p5(1) , \PHASE_250(1)  );
capacitor #(.c(9.194e-16)) (*
integer library_binding = "analogLib";

 *)
c4575 ( \MR_SQUELCH_RANGE_2p5(1) , \2:TX100_DIS_2p5  );
capacitor #(.c(9.758e-18)) (*
integer library_binding = "analogLib";

 *)
c4576 ( \MR_SQUELCH_RANGE_2p5(1) , \5:ADC_DIS_2p5  );
capacitor #(.c(4.225e-16)) (*
integer library_binding = "analogLib";

 *)
c4577 ( \MR_SQUELCH_RANGE_2p5(1) , \9:TX100_DIS_2p5  );
capacitor #(.c(2.068e-17)) (*
integer library_binding = "analogLib";

 *)
c4578 ( \MR_SQUELCH_RANGE_2p5(1) , \4:PHASE_250(8)  );
capacitor #(.c(3.556e-18)) (*
integer library_binding = "analogLib";

 *)
c4579 ( \MR_SQUELCH_RANGE_2p5(1) , RX10_PRESENT_2p5 );
capacitor #(.c(1.333e-17)) (*
integer library_binding = "analogLib";

 *)
c4580 ( \MR_SQUELCH_RANGE_2p5(1) , \PHASE_250(6)  );
capacitor #(.c(1.233e-16)) (*
integer library_binding = "analogLib";

 *)
c4581 ( \MR_SQUELCH_RANGE_2p5(1) , ADC_DIS_2p5 );
capacitor #(.c(6.328e-20)) (*
integer library_binding = "analogLib";

 *)
c4582 ( \MR_SQUELCH_RANGE_2p5(1) , \3:XTAL25  );
capacitor #(.c(1.519e-17)) (*
integer library_binding = "analogLib";

 *)
c4583 ( \MR_SQUELCH_RANGE_2p5(1) , \6:XTAL25  );
capacitor #(.c(2.374e-17)) (*
integer library_binding = "analogLib";

 *)
c4584 ( \MR_SQUELCH_RANGE_2p5(1) , \4:PHASE_250(6)  );
capacitor #(.c(2.874e-18)) (*
integer library_binding = "analogLib";

 *)
c4585 ( \MR_SQUELCH_RANGE_2p5(1) , \5:BLW_DIS_2p5  );
capacitor #(.c(5.739e-18)) (*
integer library_binding = "analogLib";

 *)
c4586 ( \MR_SQUELCH_RANGE_2p5(1) , RCLK125_TST );
capacitor #(.c(4.641e-18)) (*
integer library_binding = "analogLib";

 *)
c4587 ( \MR_SQUELCH_RANGE_2p5(1) , \PHASE_250(10)  );
capacitor #(.c(2.001e-17)) (*
integer library_binding = "analogLib";

 *)
c4588 ( \MR_SQUELCH_RANGE_2p5(1) , MR_SQUELCH_DISB_2p5 );
capacitor #(.c(2.581e-17)) (*
integer library_binding = "analogLib";

 *)
c4589 ( \MR_SQUELCH_RANGE_2p5(1) , \6:AEQ_DIS_2p5  );
capacitor #(.c(2.021e-17)) (*
integer library_binding = "analogLib";

 *)
c4590 ( \MR_SQUELCH_RANGE_2p5(1) , BLW_DIS_2p5 );
capacitor #(.c(1.72e-17)) (*
integer library_binding = "analogLib";

 *)
c4591 ( \MR_SQUELCH_RANGE_2p5(1) , \4:PHASE_250(10)  );
capacitor #(.c(1.689e-17)) (*
integer library_binding = "analogLib";

 *)
c4592 ( \MR_SQUELCH_RANGE_2p5(1) , \4:RCLK125_TST  );
capacitor #(.c(2.621e-17)) (*
integer library_binding = "analogLib";

 *)
c4593 ( \MR_SQUELCH_RANGE_2p5(1) , \6:RX10_PRESENT_2p5  );
capacitor #(.c(7.287e-18)) (*
integer library_binding = "analogLib";

 *)
c4594 ( \MR_SQUELCH_RANGE_2p5(1) , \3:X10_DIS_2p5  );
capacitor #(.c(1.56e-17)) (*
integer library_binding = "analogLib";

 *)
c4595 ( \MR_SQUELCH_RANGE_2p5(1) , \2:I_REXT_50(0)  );
capacitor #(.c(7.388e-18)) (*
integer library_binding = "analogLib";

 *)
c4596 ( \MR_SQUELCH_RANGE_2p5(1) , TIMING_UP_ANLG );
capacitor #(.c(2.819e-18)) (*
integer library_binding = "analogLib";

 *)
c4597 ( \MR_SQUELCH_RANGE_2p5(1) , AEQ_DIS_2p5 );
capacitor #(.c(2.606e-17)) (*
integer library_binding = "analogLib";

 *)
c4598 ( \MR_SQUELCH_RANGE_2p5(1) , \4:PHASE_250(4)  );
capacitor #(.c(2.072e-17)) (*
integer library_binding = "analogLib";

 *)
c4599 ( \MR_SQUELCH_RANGE_2p5(1) , \PHASE_250(4)  );
capacitor #(.c(1.123e-19)) (*
integer library_binding = "analogLib";

 *)
c4600 ( \3:MR_SQUELCH_RANGE_2p5(1) , \PHASE_250(2)  );
capacitor #(.c(8.175e-20)) (*
integer library_binding = "analogLib";

 *)
c4601 ( \3:MR_SQUELCH_RANGE_2p5(1) , \4:PHASE_250(2)  );
capacitor #(.c(1.609e-18)) (*
integer library_binding = "analogLib";

 *)
c4602 ( \3:MR_SQUELCH_RANGE_2p5(1) , \4:PHASE_250(8)  );
capacitor #(.c(1.412e-18)) (*
integer library_binding = "analogLib";

 *)
c4603 ( \3:MR_SQUELCH_RANGE_2p5(1) , \PHASE_250(8)  );
capacitor #(.c(1.248e-18)) (*
integer library_binding = "analogLib";

 *)
c4604 ( \3:MR_SQUELCH_RANGE_2p5(1) , \3:MR_SQUELCH_DISB_2p5  );
capacitor #(.c(1.738e-18)) (*
integer library_binding = "analogLib";

 *)
c4605 ( \3:MR_SQUELCH_RANGE_2p5(1) , \3:PHASE_250(1)  );
capacitor #(.c(1.096e-18)) (*
integer library_binding = "analogLib";

 *)
c4606 ( \3:MR_SQUELCH_RANGE_2p5(1) , \PHASE_250(1)  );
capacitor #(.c(1.799e-16)) (*
integer library_binding = "analogLib";

 *)
c4607 ( \3:MR_SQUELCH_RANGE_2p5(1) , \2:TX100_DIS_2p5  );
capacitor #(.c(3.177e-18)) (*
integer library_binding = "analogLib";

 *)
c4608 ( \3:MR_SQUELCH_RANGE_2p5(1) , \5:ADC_DIS_2p5  );
capacitor #(.c(4.997e-17)) (*
integer library_binding = "analogLib";

 *)
c4609 ( \3:MR_SQUELCH_RANGE_2p5(1) , \9:TX100_DIS_2p5  );
capacitor #(.c(1.185e-18)) (*
integer library_binding = "analogLib";

 *)
c4610 ( \3:MR_SQUELCH_RANGE_2p5(1) , RX10_PRESENT_2p5 );
capacitor #(.c(4.841e-18)) (*
integer library_binding = "analogLib";

 *)
c4611 ( \3:MR_SQUELCH_RANGE_2p5(1) , \PHASE_250(6)  );
capacitor #(.c(2.55e-17)) (*
integer library_binding = "analogLib";

 *)
c4612 ( \3:MR_SQUELCH_RANGE_2p5(1) , ADC_DIS_2p5 );
capacitor #(.c(4.566e-18)) (*
integer library_binding = "analogLib";

 *)
c4613 ( \3:MR_SQUELCH_RANGE_2p5(1) , \4:PHASE_250(6)  );
capacitor #(.c(1.107e-18)) (*
integer library_binding = "analogLib";

 *)
c4614 ( \3:MR_SQUELCH_RANGE_2p5(1) , \5:BLW_DIS_2p5  );
capacitor #(.c(1.846e-18)) (*
integer library_binding = "analogLib";

 *)
c4615 ( \3:MR_SQUELCH_RANGE_2p5(1) , RCLK125_TST );
capacitor #(.c(1.458e-18)) (*
integer library_binding = "analogLib";

 *)
c4616 ( \3:MR_SQUELCH_RANGE_2p5(1) , \PHASE_250(10)  );
capacitor #(.c(2.507e-18)) (*
integer library_binding = "analogLib";

 *)
c4617 ( \3:MR_SQUELCH_RANGE_2p5(1) , MR_SQUELCH_DISB_2p5 );
capacitor #(.c(4.741e-18)) (*
integer library_binding = "analogLib";

 *)
c4618 ( \3:MR_SQUELCH_RANGE_2p5(1) , \6:AEQ_DIS_2p5  );
capacitor #(.c(2.586e-18)) (*
integer library_binding = "analogLib";

 *)
c4619 ( \3:MR_SQUELCH_RANGE_2p5(1) , BLW_DIS_2p5 );
capacitor #(.c(1.817e-18)) (*
integer library_binding = "analogLib";

 *)
c4620 ( \3:MR_SQUELCH_RANGE_2p5(1) , \4:PHASE_250(10)  );
capacitor #(.c(1.226e-18)) (*
integer library_binding = "analogLib";

 *)
c4621 ( \3:MR_SQUELCH_RANGE_2p5(1) , \4:RCLK125_TST  );
capacitor #(.c(5.08e-18)) (*
integer library_binding = "analogLib";

 *)
c4622 ( \3:MR_SQUELCH_RANGE_2p5(1) , \6:RX10_PRESENT_2p5  );
capacitor #(.c(4.742e-19)) (*
integer library_binding = "analogLib";

 *)
c4623 ( \3:MR_SQUELCH_RANGE_2p5(1) , \4:PHASE_250(4)  );
capacitor #(.c(3.77e-19)) (*
integer library_binding = "analogLib";

 *)
c4624 ( \3:MR_SQUELCH_RANGE_2p5(1) , \PHASE_250(4)  );
capacitor #(.c(1.086e-18)) (*
integer library_binding = "analogLib";

 *)
c4625 ( \3:MR_SQUELCH_RANGE_2p5(1) , AEQ_DIS_2p5 );
capacitor #(.c(2.845e-18)) (*
integer library_binding = "analogLib";

 *)
c4626 ( \3:MR_SQUELCH_RANGE_2p5(1) , TIMING_UP_ANLG );
capacitor #(.c(6.007e-18)) (*
integer library_binding = "analogLib";

 *)
c4627 ( \3:MR_SQUELCH_RANGE_2p5(1) , \2:I_REXT_50(0)  );
capacitor #(.c(2.806e-18)) (*
integer library_binding = "analogLib";

 *)
c4628 ( \3:MR_SQUELCH_RANGE_2p5(1) , \3:X10_DIS_2p5  );
capacitor #(.c(9.182e-18)) (*
integer library_binding = "analogLib";

 *)
c4629 ( \PHASE_250(3) , \PHASE_250(2)  );
capacitor #(.c(6.682e-18)) (*
integer library_binding = "analogLib";

 *)
c4630 ( \PHASE_250(3) , \4:PHASE_250(2)  );
capacitor #(.c(1.682e-18)) (*
integer library_binding = "analogLib";

 *)
c4631 ( \PHASE_250(3) , \3:MR_SQUELCH_DISB_2p5  );
capacitor #(.c(7.245e-18)) (*
integer library_binding = "analogLib";

 *)
c4632 ( \PHASE_250(3) , \3:PHASE_250(1)  );
capacitor #(.c(1.821e-19)) (*
integer library_binding = "analogLib";

 *)
c4633 ( \PHASE_250(3) , \2:TX100_DIS_2p5  );
capacitor #(.c(9.002e-18)) (*
integer library_binding = "analogLib";

 *)
c4634 ( \PHASE_250(3) , \PHASE_250(1)  );
capacitor #(.c(4.971e-18)) (*
integer library_binding = "analogLib";

 *)
c4635 ( \PHASE_250(3) , \9:TX100_DIS_2p5  );
capacitor #(.c(1.709e-18)) (*
integer library_binding = "analogLib";

 *)
c4636 ( \PHASE_250(3) , \5:BLW_DIS_2p5  );
capacitor #(.c(6.679e-19)) (*
integer library_binding = "analogLib";

 *)
c4637 ( \PHASE_250(3) , RX10_PRESENT_2p5 );
capacitor #(.c(1.135e-18)) (*
integer library_binding = "analogLib";

 *)
c4638 ( \PHASE_250(3) , AEQ_DIS_2p5 );
capacitor #(.c(2.06e-17)) (*
integer library_binding = "analogLib";

 *)
c4639 ( \PHASE_250(3) , \6:AEQ_DIS_2p5  );
capacitor #(.c(1.039e-17)) (*
integer library_binding = "analogLib";

 *)
c4640 ( \PHASE_250(3) , \3:PHASE_250(9)  );
capacitor #(.c(1.819e-17)) (*
integer library_binding = "analogLib";

 *)
c4641 ( \PHASE_250(3) , \6:RX10_PRESENT_2p5  );
capacitor #(.c(2.139e-17)) (*
integer library_binding = "analogLib";

 *)
c4642 ( \PHASE_250(3) , BLW_DIS_2p5 );
capacitor #(.c(1.027e-15)) (*
integer library_binding = "analogLib";

 *)
c4643 ( \PHASE_250(3) , \2:I_REXT_50(0)  );
capacitor #(.c(2.164e-17)) (*
integer library_binding = "analogLib";

 *)
c4644 ( \PHASE_250(3) , MR_SQUELCH_DISB_2p5 );
capacitor #(.c(4.816e-18)) (*
integer library_binding = "analogLib";

 *)
c4645 ( \PHASE_250(3) , \PHASE_250(9)  );
capacitor #(.c(1.266e-17)) (*
integer library_binding = "analogLib";

 *)
c4646 ( \PHASE_250(3) , \3:X10_DIS_2p5  );
capacitor #(.c(8.596e-18)) (*
integer library_binding = "analogLib";

 *)
c4647 ( \4:PHASE_250(3) , \PHASE_250(2)  );
capacitor #(.c(6.156e-17)) (*
integer library_binding = "analogLib";

 *)
c4648 ( \4:PHASE_250(3) , \4:PHASE_250(2)  );
capacitor #(.c(7.266e-18)) (*
integer library_binding = "analogLib";

 *)
c4649 ( \4:PHASE_250(3) , \3:PHASE_250(1)  );
capacitor #(.c(1.272e-18)) (*
integer library_binding = "analogLib";

 *)
c4650 ( \4:PHASE_250(3) , \2:TX100_DIS_2p5  );
capacitor #(.c(3.555e-17)) (*
integer library_binding = "analogLib";

 *)
c4651 ( \4:PHASE_250(3) , \PHASE_250(1)  );
capacitor #(.c(3.472e-17)) (*
integer library_binding = "analogLib";

 *)
c4652 ( \4:PHASE_250(3) , \9:TX100_DIS_2p5  );
capacitor #(.c(3.96e-19)) (*
integer library_binding = "analogLib";

 *)
c4653 ( \4:PHASE_250(3) , RX10_PRESENT_2p5 );
capacitor #(.c(2.238e-19)) (*
integer library_binding = "analogLib";

 *)
c4654 ( \4:PHASE_250(3) , \3:XTAL25  );
capacitor #(.c(5.372e-17)) (*
integer library_binding = "analogLib";

 *)
c4655 ( \4:PHASE_250(3) , \6:XTAL25  );
capacitor #(.c(6.727e-19)) (*
integer library_binding = "analogLib";

 *)
c4656 ( \4:PHASE_250(3) , AEQ_DIS_2p5 );
capacitor #(.c(1.221e-17)) (*
integer library_binding = "analogLib";

 *)
c4657 ( \4:PHASE_250(3) , \6:AEQ_DIS_2p5  );
capacitor #(.c(6.16e-18)) (*
integer library_binding = "analogLib";

 *)
c4658 ( \4:PHASE_250(3) , \3:PHASE_250(9)  );
capacitor #(.c(1.078e-17)) (*
integer library_binding = "analogLib";

 *)
c4659 ( \4:PHASE_250(3) , \6:RX10_PRESENT_2p5  );
capacitor #(.c(4.845e-18)) (*
integer library_binding = "analogLib";

 *)
c4660 ( \4:PHASE_250(3) , BLW_DIS_2p5 );
capacitor #(.c(4.845e-18)) (*
integer library_binding = "analogLib";

 *)
c4661 ( \4:PHASE_250(3) , MR_SQUELCH_DISB_2p5 );
capacitor #(.c(1.721e-15)) (*
integer library_binding = "analogLib";

 *)
c4662 ( \4:PHASE_250(3) , \2:I_REXT_50(0)  );
capacitor #(.c(1.335e-17)) (*
integer library_binding = "analogLib";

 *)
c4663 ( \4:PHASE_250(3) , \PHASE_250(9)  );
capacitor #(.c(1.274e-17)) (*
integer library_binding = "analogLib";

 *)
c4664 ( \I_RPOLY_100(4) , \7:I_REXT_50(0)  );
capacitor #(.c(1.352e-14)) (*
integer library_binding = "analogLib";

 *)
c4665 ( \I_RPOLY_100(4) , \4:I_RPOLY_100(5)  );
capacitor #(.c(1.289e-14)) (*
integer library_binding = "analogLib";

 *)
c4666 ( \I_RPOLY_100(4) , \4:I_RPOLY_100(3)  );
capacitor #(.c(3.146e-17)) (*
integer library_binding = "analogLib";

 *)
c4667 ( \I_RPOLY_100(4) , \2:I_RPOLY_100(5)  );
capacitor #(.c(1.508e-17)) (*
integer library_binding = "analogLib";

 *)
c4668 ( \I_RPOLY_100(4) , \3:ADC_1p0(4)  );
capacitor #(.c(4.9e-16)) (*
integer library_binding = "analogLib";

 *)
c4669 ( \2:I_RPOLY_100(4) , \I_RPOLY_100(5)  );
capacitor #(.c(5.439e-16)) (*
integer library_binding = "analogLib";

 *)
c4670 ( \2:I_RPOLY_100(4) , \I_RPOLY_100(3)  );
capacitor #(.c(1.658e-14)) (*
integer library_binding = "analogLib";

 *)
c4671 ( \2:I_RPOLY_100(4) , \2:I_RPOLY_100(3)  );
capacitor #(.c(4.544e-17)) (*
integer library_binding = "analogLib";

 *)
c4672 ( \2:I_RPOLY_100(4) , \4:I_RPOLY_100(3)  );
capacitor #(.c(1.645e-14)) (*
integer library_binding = "analogLib";

 *)
c4673 ( \2:I_RPOLY_100(4) , \2:I_RPOLY_100(5)  );
capacitor #(.c(1.597e-15)) (*
integer library_binding = "analogLib";

 *)
c4674 ( \3:I_RPOLY_100(4) , \I_RPOLY_100(5)  );
capacitor #(.c(5.438e-16)) (*
integer library_binding = "analogLib";

 *)
c4675 ( \3:I_RPOLY_100(4) , \2:I_RPOLY_100(5)  );
capacitor #(.c(4.894e-16)) (*
integer library_binding = "analogLib";

 *)
c4676 ( \3:I_RPOLY_100(4) , \2:I_RPOLY_100(3)  );
capacitor #(.c(1.607e-15)) (*
integer library_binding = "analogLib";

 *)
c4677 ( \3:I_RPOLY_100(4) , \I_RPOLY_100(3)  );
capacitor #(.c(9.445e-17)) (*
integer library_binding = "analogLib";

 *)
c4678 ( BASE10_TX_DIS_1p0, \24:VDDTX  );
capacitor #(.c(4.714e-16)) (*
integer library_binding = "analogLib";

 *)
c4679 ( \5:BASE10_TX_DIS_1p0 , \24:VDDTX  );
capacitor #(.c(1.26e-17)) (*
integer library_binding = "analogLib";

 *)
c4680 ( \5:BASEFX_DIS , \6:I_REXT_50(0)  );
capacitor #(.c(1.622e-18)) (*
integer library_binding = "analogLib";

 *)
c4681 ( \5:BASEFX_DIS , \WANDER_CNT(4)  );
capacitor #(.c(2.008e-18)) (*
integer library_binding = "analogLib";

 *)
c4682 ( \5:BASEFX_DIS , \AEQ_CNT_ANLG(4)  );
capacitor #(.c(5.615e-18)) (*
integer library_binding = "analogLib";

 *)
c4683 ( \5:BASEFX_DIS , TIMING_DN_ANLG );
capacitor #(.c(3.456e-18)) (*
integer library_binding = "analogLib";

 *)
c4684 ( \5:BASEFX_DIS , \5:TIMING_DN_ANLG  );
capacitor #(.c(1.923e-17)) (*
integer library_binding = "analogLib";

 *)
c4685 ( \5:BASEFX_DIS , \WANDER_CNT(0)  );
capacitor #(.c(1.81e-18)) (*
integer library_binding = "analogLib";

 *)
c4686 ( \5:BASEFX_DIS , \4:WANDER_CNT(0)  );
capacitor #(.c(2.618e-16)) (*
integer library_binding = "analogLib";

 *)
c4687 ( \5:BASEFX_DIS , \24:VDDTX  );
capacitor #(.c(1.086e-15)) (*
integer library_binding = "analogLib";

 *)
c4688 ( \5:BASEFX_DIS , RX10_PRESENT_2p5 );
capacitor #(.c(1.536e-17)) (*
integer library_binding = "analogLib";

 *)
c4689 ( \5:BASEFX_DIS , \AEQ_CNT_ANLG(0)  );
capacitor #(.c(1.526e-18)) (*
integer library_binding = "analogLib";

 *)
c4690 ( \5:BASEFX_DIS , \4:AEQ_CNT_ANLG(0)  );
capacitor #(.c(3.977e-15)) (*
integer library_binding = "analogLib";

 *)
c4691 ( \5:BASEFX_DIS , \6:RX10_PRESENT_2p5  );
capacitor #(.c(9.65e-20)) (*
integer library_binding = "analogLib";

 *)
c4692 ( \5:BASEFX_DIS , \1:PLL_160_IN  );
capacitor #(.c(1.521e-17)) (*
integer library_binding = "analogLib";

 *)
c4693 ( \5:BASEFX_DIS , \4:PLL_160_IN  );
capacitor #(.c(5.84e-20)) (*
integer library_binding = "analogLib";

 *)
c4694 ( \5:BASEFX_DIS , \3:XTAL25  );
capacitor #(.c(1.402e-17)) (*
integer library_binding = "analogLib";

 *)
c4695 ( \5:BASEFX_DIS , \6:XTAL25  );
capacitor #(.c(1.421e-17)) (*
integer library_binding = "analogLib";

 *)
c4696 ( \5:BASEFX_DIS , \6:AEQ_DIS_2p5  );
capacitor #(.c(3.29e-18)) (*
integer library_binding = "analogLib";

 *)
c4697 ( \5:BASEFX_DIS , TIMING_UP_ANLG );
capacitor #(.c(5.297e-18)) (*
integer library_binding = "analogLib";

 *)
c4698 ( \5:BASEFX_DIS , \6:TIMING_UP_ANLG  );
capacitor #(.c(1.376e-15)) (*
integer library_binding = "analogLib";

 *)
c4699 ( \5:BASEFX_DIS , \25:VDDTX  );
capacitor #(.c(6.378e-16)) (*
integer library_binding = "analogLib";

 *)
c4700 ( \5:BASEFX_DIS , T2_MODE );
capacitor #(.c(3.888e-18)) (*
integer library_binding = "analogLib";

 *)
c4701 ( \5:BASEFX_DIS , AEQ_DIS_2p5 );
capacitor #(.c(1.908e-17)) (*
integer library_binding = "analogLib";

 *)
c4702 ( \5:BASEFX_DIS , \5:WANDER_CNT(4)  );
capacitor #(.c(8.062e-18)) (*
integer library_binding = "analogLib";

 *)
c4703 ( \5:BASEFX_DIS , \5:PHASE_IN(7)  );
capacitor #(.c(9.911e-18)) (*
integer library_binding = "analogLib";

 *)
c4704 ( \5:BASEFX_DIS , \4:PHASE_IN(10)  );
capacitor #(.c(1.869e-17)) (*
integer library_binding = "analogLib";

 *)
c4705 ( \5:BASEFX_DIS , \5:AEQ_CNT_ANLG(4)  );
capacitor #(.c(1.461e-15)) (*
integer library_binding = "analogLib";

 *)
c4706 ( \5:BASEFX_DIS , \6:T2_MODE  );
capacitor #(.c(5.022e-17)) (*
integer library_binding = "analogLib";

 *)
c4707 ( \5:BASEFX_DIS , \2:I_REXT_50(0)  );
capacitor #(.c(3.446e-17)) (*
integer library_binding = "analogLib";

 *)
c4708 ( \5:BASEFX_DIS , \2:PHASE_IN(1)  );
capacitor #(.c(3.516e-17)) (*
integer library_binding = "analogLib";

 *)
c4709 ( \5:BASEFX_DIS , \4:PHASE_IN(9)  );
capacitor #(.c(1.806e-17)) (*
integer library_binding = "analogLib";

 *)
c4710 ( \5:BASEFX_DIS , \2:PHASE_IN(5)  );
capacitor #(.c(1.029e-17)) (*
integer library_binding = "analogLib";

 *)
c4711 ( \5:BASEFX_DIS , MR_BYPASS10RX_FILTER );
capacitor #(.c(1.578e-17)) (*
integer library_binding = "analogLib";

 *)
c4712 ( \5:BASEFX_DIS , \4:PHASE_IN(8)  );
capacitor #(.c(5.74e-18)) (*
integer library_binding = "analogLib";

 *)
c4713 ( \9:BASEFX_DIS , TIMING_DN_ANLG );
capacitor #(.c(3.532e-18)) (*
integer library_binding = "analogLib";

 *)
c4714 ( \9:BASEFX_DIS , \5:TIMING_DN_ANLG  );
capacitor #(.c(3.364e-18)) (*
integer library_binding = "analogLib";

 *)
c4715 ( \9:BASEFX_DIS , TIMING_UP_ANLG );
capacitor #(.c(5.415e-18)) (*
integer library_binding = "analogLib";

 *)
c4716 ( \9:BASEFX_DIS , \6:TIMING_UP_ANLG  );
capacitor #(.c(1.463e-16)) (*
integer library_binding = "analogLib";

 *)
c4717 ( \9:BASEFX_DIS , \25:VDDTX  );
capacitor #(.c(1.013e-17)) (*
integer library_binding = "analogLib";

 *)
c4718 ( \9:BASEFX_DIS , \4:PHASE_IN(10)  );
capacitor #(.c(8.241e-18)) (*
integer library_binding = "analogLib";

 *)
c4719 ( \9:BASEFX_DIS , \5:PHASE_IN(7)  );
capacitor #(.c(1.869e-17)) (*
integer library_binding = "analogLib";

 *)
c4720 ( \7:BASEFX_DIS , AEQ_DIS_2p5 );
capacitor #(.c(8.232e-17)) (*
integer library_binding = "analogLib";

 *)
c4721 ( \7:BASEFX_DIS , \6:T2_MODE  );
capacitor #(.c(1.981e-15)) (*
integer library_binding = "analogLib";

 *)
c4722 ( \7:BASEFX_DIS , T2_MODE );
capacitor #(.c(1.412e-17)) (*
integer library_binding = "analogLib";

 *)
c4723 ( \7:BASEFX_DIS , \4:WANDER_CNT(0)  );
capacitor #(.c(5.992e-19)) (*
integer library_binding = "analogLib";

 *)
c4724 ( \7:BASEFX_DIS , \6:AEQ_DIS_2p5  );
capacitor #(.c(1.684e-17)) (*
integer library_binding = "analogLib";

 *)
c4725 ( \7:BASEFX_DIS , \4:AEQ_CNT_ANLG(0)  );
capacitor #(.c(2.53e-16)) (*
integer library_binding = "analogLib";

 *)
c4726 ( \7:BASEFX_DIS , \6:RX10_PRESENT_2p5  );
capacitor #(.c(7.692e-19)) (*
integer library_binding = "analogLib";

 *)
c4727 ( \7:BASEFX_DIS , \AEQ_CNT_ANLG(0)  );
capacitor #(.c(4.946e-15)) (*
integer library_binding = "analogLib";

 *)
c4728 ( \7:BASEFX_DIS , RX10_PRESENT_2p5 );
capacitor #(.c(1.274e-19)) (*
integer library_binding = "analogLib";

 *)
c4729 ( \7:BASEFX_DIS , \WANDER_CNT(0)  );
capacitor #(.c(5.068e-17)) (*
integer library_binding = "analogLib";

 *)
c4730 ( \7:BASEFX_DIS , \2:I_REXT_50(0)  );
capacitor #(.c(5.226e-16)) (*
integer library_binding = "analogLib";

 *)
c4731 ( \7:BASEFX_DIS , \6:I_REXT_50(0)  );
capacitor #(.c(6.095e-20)) (*
integer library_binding = "analogLib";

 *)
c4732 ( \7:BASEFX_DIS , \5:WANDER_CNT(4)  );
capacitor #(.c(1.852e-17)) (*
integer library_binding = "analogLib";

 *)
c4733 ( \7:BASEFX_DIS , \WANDER_CNT(4)  );
capacitor #(.c(5.982e-19)) (*
integer library_binding = "analogLib";

 *)
c4734 ( \7:BASEFX_DIS , ADC_DIS_2p5 );
capacitor #(.c(1.295e-16)) (*
integer library_binding = "analogLib";

 *)
c4735 ( \7:BASEFX_DIS , \5:ADC_DIS_2p5  );
capacitor #(.c(4.466e-16)) (*
integer library_binding = "analogLib";

 *)
c4736 ( \I_REXT_100(4) , \2:I_REXT_100(3)  );
capacitor #(.c(1.554e-15)) (*
integer library_binding = "analogLib";

 *)
c4737 ( \I_REXT_100(4) , \I_REXT_100(3)  );
capacitor #(.c(5.027e-16)) (*
integer library_binding = "analogLib";

 *)
c4738 ( \2:I_REXT_100(4) , \I_REXT_100(3)  );
capacitor #(.c(1.616e-14)) (*
integer library_binding = "analogLib";

 *)
c4739 ( \2:I_REXT_100(4) , \2:I_REXT_100(3)  );
capacitor #(.c(6.421e-17)) (*
integer library_binding = "analogLib";

 *)
c4740 ( \2:I_REXT_100(4) , \4:I_REXT_100(3)  );
capacitor #(.c(1.276e-17)) (*
integer library_binding = "analogLib";

 *)
c4741 ( \4:I_REXT_100(4) , \7:I_REXT_50(0)  );
capacitor #(.c(1.508e-17)) (*
integer library_binding = "analogLib";

 *)
c4742 ( \4:I_REXT_100(4) , \3:ADC_1p0(4)  );
capacitor #(.c(1.278e-14)) (*
integer library_binding = "analogLib";

 *)
c4743 ( \4:I_REXT_100(4) , \4:I_REXT_100(3)  );
capacitor #(.c(1.993e-17)) (*
integer library_binding = "analogLib";

 *)
c4744 ( \TX_AMPTRIM_1p0(0) , \4:MLT3_TDATA_1p0(0)  );
capacitor #(.c(8.853e-19)) (*
integer library_binding = "analogLib";

 *)
c4745 ( \TX_AMPTRIM_1p0(0) , \MLT3_TDATA_1p0(0)  );
capacitor #(.c(5.277e-19)) (*
integer library_binding = "analogLib";

 *)
c4746 ( \TX_AMPTRIM_1p0(0) , \3:TEST_MODE(2)  );
capacitor #(.c(7.18e-19)) (*
integer library_binding = "analogLib";

 *)
c4747 ( \TX_AMPTRIM_1p0(0) , SLICER_OUT_1p0 );
capacitor #(.c(1.644e-17)) (*
integer library_binding = "analogLib";

 *)
c4748 ( \TX_AMPTRIM_1p0(0) , \TEST_MODE(2)  );
capacitor #(.c(1.853e-17)) (*
integer library_binding = "analogLib";

 *)
c4749 ( \TX_AMPTRIM_1p0(0) , \4:SLICER_OUT_1p0  );
capacitor #(.c(2.653e-18)) (*
integer library_binding = "analogLib";

 *)
c4750 ( \TX_AMPTRIM_1p0(0) , \3:POS_DETECT_1p0  );
capacitor #(.c(1.962e-17)) (*
integer library_binding = "analogLib";

 *)
c4751 ( \TX_AMPTRIM_1p0(0) , \4:X_125  );
capacitor #(.c(4.899e-19)) (*
integer library_binding = "analogLib";

 *)
c4752 ( \TX_AMPTRIM_1p0(0) , X_125 );
capacitor #(.c(5.416e-16)) (*
integer library_binding = "analogLib";

 *)
c4753 ( \TX_AMPTRIM_1p0(0) , \3:XTAL25_1p0  );
capacitor #(.c(6.849e-16)) (*
integer library_binding = "analogLib";

 *)
c4754 ( \TX_AMPTRIM_1p0(0) , XTAL25_1p0 );
capacitor #(.c(1.719e-17)) (*
integer library_binding = "analogLib";

 *)
c4755 ( \TX_AMPTRIM_1p0(0) , POS_DETECT_1p0 );
capacitor #(.c(3.935e-16)) (*
integer library_binding = "analogLib";

 *)
c4756 ( \TX_AMPTRIM_1p0(0) , NEG_DETECT_1p0 );
capacitor #(.c(4.363e-16)) (*
integer library_binding = "analogLib";

 *)
c4757 ( \TX_AMPTRIM_1p0(0) , \3:NEG_DETECT_1p0  );
capacitor #(.c(2.023e-15)) (*
integer library_binding = "analogLib";

 *)
c4758 ( \TX_AMPTRIM_1p0(0) , \4:MR_SQUELCH_RANGE_1p0(1)  );
capacitor #(.c(8.174e-16)) (*
integer library_binding = "analogLib";

 *)
c4759 ( \TX_AMPTRIM_1p0(0) , \MR_SQUELCH_RANGE_1p0(1)  );
capacitor #(.c(1.959e-17)) (*
integer library_binding = "analogLib";

 *)
c4760 ( \TX_AMPTRIM_1p0(0) , \1:ADC_1p0(4)  );
capacitor #(.c(1.31e-17)) (*
integer library_binding = "analogLib";

 *)
c4761 ( \TX_AMPTRIM_1p0(0) , \1:RCLK125_1p0  );
capacitor #(.c(1.959e-17)) (*
integer library_binding = "analogLib";

 *)
c4762 ( \TX_AMPTRIM_1p0(0) , \FLASH_1p0(1)  );
capacitor #(.c(1.748e-17)) (*
integer library_binding = "analogLib";

 *)
c4763 ( \3:TX_AMPTRIM_1p0(0) , SLICER_OUT_1p0 );
capacitor #(.c(1.955e-17)) (*
integer library_binding = "analogLib";

 *)
c4764 ( \3:TX_AMPTRIM_1p0(0) , X_125 );
capacitor #(.c(2.108e-17)) (*
integer library_binding = "analogLib";

 *)
c4765 ( \3:TX_AMPTRIM_1p0(0) , \3:TEST_MODE(2)  );
capacitor #(.c(1.955e-17)) (*
integer library_binding = "analogLib";

 *)
c4766 ( \3:TX_AMPTRIM_1p0(0) , \MLT3_TDATA_1p0(0)  );
capacitor #(.c(1.782e-17)) (*
integer library_binding = "analogLib";

 *)
c4767 ( \3:TX_AMPTRIM_1p0(0) , \3:POS_DETECT_1p0  );
capacitor #(.c(7.26e-17)) (*
integer library_binding = "analogLib";

 *)
c4768 ( \3:TX_AMPTRIM_1p0(0) , NEG_DETECT_1p0 );
capacitor #(.c(5.62e-16)) (*
integer library_binding = "analogLib";

 *)
c4769 ( \3:TX_AMPTRIM_1p0(0) , \3:NEG_DETECT_1p0  );
capacitor #(.c(3.859e-16)) (*
integer library_binding = "analogLib";

 *)
c4770 ( \3:TX_AMPTRIM_1p0(0) , \4:MR_SQUELCH_RANGE_1p0(1)  );
capacitor #(.c(2.682e-15)) (*
integer library_binding = "analogLib";

 *)
c4771 ( \3:TX_AMPTRIM_1p0(0) , \MR_SQUELCH_RANGE_1p0(1)  );
capacitor #(.c(2.667e-18)) (*
integer library_binding = "analogLib";

 *)
c4772 ( \3:TX_AMPTRIM_1p0(0) , POS_DETECT_1p0 );
capacitor #(.c(1.271e-16)) (*
integer library_binding = "analogLib";

 *)
c4773 ( \3:TX_AMPTRIM_1p0(0) , XTAL25_1p0 );
capacitor #(.c(9.311e-16)) (*
integer library_binding = "analogLib";

 *)
c4774 ( \3:TX_AMPTRIM_1p0(0) , \3:XTAL25_1p0  );
capacitor #(.c(6.41e-20)) (*
integer library_binding = "analogLib";

 *)
c4775 ( \1:PLL_160_IN , \4:PHASE_250(8)  );
capacitor #(.c(5.626e-20)) (*
integer library_binding = "analogLib";

 *)
c4776 ( \1:PLL_160_IN , \PHASE_250(8)  );
capacitor #(.c(9.559e-20)) (*
integer library_binding = "analogLib";

 *)
c4777 ( \1:PLL_160_IN , \5:WANDER_CNT(2)  );
capacitor #(.c(5.474e-19)) (*
integer library_binding = "analogLib";

 *)
c4778 ( \1:PLL_160_IN , \24:VDDTX  );
capacitor #(.c(2.874e-18)) (*
integer library_binding = "analogLib";

 *)
c4779 ( \1:PLL_160_IN , \25:VDDTX  );
capacitor #(.c(1.848e-19)) (*
integer library_binding = "analogLib";

 *)
c4780 ( \1:PLL_160_IN , \PHASE_250(6)  );
capacitor #(.c(1.661e-19)) (*
integer library_binding = "analogLib";

 *)
c4781 ( \1:PLL_160_IN , \4:PHASE_250(6)  );
capacitor #(.c(6.312e-18)) (*
integer library_binding = "analogLib";

 *)
c4782 ( \1:PLL_160_IN , \5:TENBT_FILTER_1p0(1)  );
capacitor #(.c(9.348e-20)) (*
integer library_binding = "analogLib";

 *)
c4783 ( \1:PLL_160_IN , \AEQ_CNT_ANLG(0)  );
capacitor #(.c(9.623e-20)) (*
integer library_binding = "analogLib";

 *)
c4784 ( \1:PLL_160_IN , \5:TIMING_DN_ANLG  );
capacitor #(.c(9.782e-20)) (*
integer library_binding = "analogLib";

 *)
c4785 ( \1:PLL_160_IN , TIMING_UP_ANLG );
capacitor #(.c(4.877e-18)) (*
integer library_binding = "analogLib";

 *)
c4786 ( \1:PLL_160_IN , \5:PHASE_IN(7)  );
capacitor #(.c(6.452e-20)) (*
integer library_binding = "analogLib";

 *)
c4787 ( \1:PLL_160_IN , \5:AEQ_CNT_ANLG(4)  );
capacitor #(.c(7.704e-20)) (*
integer library_binding = "analogLib";

 *)
c4788 ( \1:PLL_160_IN , \5:WANDER_CNT(4)  );
capacitor #(.c(1.018e-19)) (*
integer library_binding = "analogLib";

 *)
c4789 ( \1:PLL_160_IN , \5:WANDER_CNT(6)  );
capacitor #(.c(6.452e-18)) (*
integer library_binding = "analogLib";

 *)
c4790 ( \1:PLL_160_IN , \TENBT_FILTER_1p0(0)  );
capacitor #(.c(8.496e-17)) (*
integer library_binding = "analogLib";

 *)
c4791 ( \1:PLL_160_IN , \TENBT_FILTER_1p0(1)  );
capacitor #(.c(1.336e-17)) (*
integer library_binding = "analogLib";

 *)
c4792 ( \1:PLL_160_IN , TENBT_CLK160_1p0 );
capacitor #(.c(5.884e-17)) (*
integer library_binding = "analogLib";

 *)
c4793 ( \1:PLL_160_IN , \6:TENBT_FILTER_1p0(0)  );
capacitor #(.c(1.022e-17)) (*
integer library_binding = "analogLib";

 *)
c4794 ( \1:PLL_160_IN , \5:RESET_10BT  );
capacitor #(.c(7.81e-17)) (*
integer library_binding = "analogLib";

 *)
c4795 ( \1:PLL_160_IN , \6:TENBT_CLK160_1p0  );
capacitor #(.c(9.409e-17)) (*
integer library_binding = "analogLib";

 *)
c4796 ( \1:PLL_160_IN , RESET_10BT );
capacitor #(.c(1.136e-14)) (*
integer library_binding = "analogLib";

 *)
c4797 ( \1:PLL_160_IN , \2:PHASE_IN(9)  );
capacitor #(.c(2.294e-17)) (*
integer library_binding = "analogLib";

 *)
c4798 ( \1:PLL_160_IN , \3:XTAL25  );
capacitor #(.c(1.603e-15)) (*
integer library_binding = "analogLib";

 *)
c4799 ( \1:PLL_160_IN , \1:PHASE_IN(5)  );
capacitor #(.c(2.161e-17)) (*
integer library_binding = "analogLib";

 *)
c4800 ( \1:PLL_160_IN , \5:XTAL25  );
capacitor #(.c(7.851e-17)) (*
integer library_binding = "analogLib";

 *)
c4801 ( \1:PLL_160_IN , \4:PHASE_IN(8)  );
capacitor #(.c(3.733e-16)) (*
integer library_binding = "analogLib";

 *)
c4802 ( \1:PLL_160_IN , \4:PHASE_IN(9)  );
capacitor #(.c(2.179e-15)) (*
integer library_binding = "analogLib";

 *)
c4803 ( \1:PLL_160_IN , \PHASE_IN(8)  );
capacitor #(.c(7.846e-16)) (*
integer library_binding = "analogLib";

 *)
c4804 ( \1:PLL_160_IN , \3:PHASE_IN(7)  );
capacitor #(.c(6.754e-17)) (*
integer library_binding = "analogLib";

 *)
c4805 ( \1:PLL_160_IN , \2:PHASE_IN(5)  );
capacitor #(.c(1.032e-18)) (*
integer library_binding = "analogLib";

 *)
c4806 ( \4:PLL_160_IN , \WANDER_CNT(4)  );
capacitor #(.c(1.949e-17)) (*
integer library_binding = "analogLib";

 *)
c4807 ( \4:PLL_160_IN , \4:PHASE_250(8)  );
capacitor #(.c(1.711e-17)) (*
integer library_binding = "analogLib";

 *)
c4808 ( \4:PLL_160_IN , \PHASE_250(8)  );
capacitor #(.c(7.424e-19)) (*
integer library_binding = "analogLib";

 *)
c4809 ( \4:PLL_160_IN , \WANDER_CNT(2)  );
capacitor #(.c(1.506e-17)) (*
integer library_binding = "analogLib";

 *)
c4810 ( \4:PLL_160_IN , \5:WANDER_CNT(2)  );
capacitor #(.c(1.092e-18)) (*
integer library_binding = "analogLib";

 *)
c4811 ( \4:PLL_160_IN , \AEQ_CNT_ANLG(4)  );
capacitor #(.c(8.626e-17)) (*
integer library_binding = "analogLib";

 *)
c4812 ( \4:PLL_160_IN , \24:VDDTX  );
capacitor #(.c(4.529e-16)) (*
integer library_binding = "analogLib";

 *)
c4813 ( \4:PLL_160_IN , \25:VDDTX  );
capacitor #(.c(2.911e-17)) (*
integer library_binding = "analogLib";

 *)
c4814 ( \4:PLL_160_IN , \PHASE_250(6)  );
capacitor #(.c(2.617e-17)) (*
integer library_binding = "analogLib";

 *)
c4815 ( \4:PLL_160_IN , \4:PHASE_250(6)  );
capacitor #(.c(1.473e-17)) (*
integer library_binding = "analogLib";

 *)
c4816 ( \4:PLL_160_IN , \AEQ_CNT_ANLG(0)  );
capacitor #(.c(1.075e-18)) (*
integer library_binding = "analogLib";

 *)
c4817 ( \4:PLL_160_IN , \4:AEQ_CNT_ANLG(0)  );
capacitor #(.c(1.097e-14)) (*
integer library_binding = "analogLib";

 *)
c4818 ( \4:PLL_160_IN , \4:PHASE_IN(9)  );
capacitor #(.c(1.46e-15)) (*
integer library_binding = "analogLib";

 *)
c4819 ( \4:PLL_160_IN , \2:PHASE_IN(5)  );
capacitor #(.c(1.516e-17)) (*
integer library_binding = "analogLib";

 *)
c4820 ( \4:PLL_160_IN , \5:TIMING_DN_ANLG  );
capacitor #(.c(1.541e-17)) (*
integer library_binding = "analogLib";

 *)
c4821 ( \4:PLL_160_IN , TIMING_UP_ANLG );
capacitor #(.c(7.684e-16)) (*
integer library_binding = "analogLib";

 *)
c4822 ( \4:PLL_160_IN , \5:PHASE_IN(7)  );
capacitor #(.c(1.998e-15)) (*
integer library_binding = "analogLib";

 *)
c4823 ( \4:PLL_160_IN , \4:PHASE_IN(8)  );
capacitor #(.c(1.017e-17)) (*
integer library_binding = "analogLib";

 *)
c4824 ( \4:PLL_160_IN , \5:AEQ_CNT_ANLG(4)  );
capacitor #(.c(1.214e-17)) (*
integer library_binding = "analogLib";

 *)
c4825 ( \4:PLL_160_IN , \5:WANDER_CNT(4)  );
capacitor #(.c(1.082e-18)) (*
integer library_binding = "analogLib";

 *)
c4826 ( \4:PLL_160_IN , \WANDER_CNT(6)  );
capacitor #(.c(1.605e-17)) (*
integer library_binding = "analogLib";

 *)
c4827 ( \4:PLL_160_IN , \5:WANDER_CNT(6)  );
capacitor #(.c(6.373e-20)) (*
integer library_binding = "analogLib";

 *)
c4828 ( \4:PLL_160_IN , \3:XTAL25  );
capacitor #(.c(1.53e-17)) (*
integer library_binding = "analogLib";

 *)
c4829 ( \4:PLL_160_IN , \6:XTAL25  );
capacitor #(.c(1.505e-18)) (*
integer library_binding = "analogLib";

 *)
c4830 ( \3:XTAL25 , \PHASE_250(8)  );
capacitor #(.c(5.745e-20)) (*
integer library_binding = "analogLib";

 *)
c4831 ( \3:XTAL25 , \5:WANDER_CNT(2)  );
capacitor #(.c(3.66e-20)) (*
integer library_binding = "analogLib";

 *)
c4832 ( \3:XTAL25 , TIMING_DN_ANLG );
capacitor #(.c(2.253e-20)) (*
integer library_binding = "analogLib";

 *)
c4833 ( \3:XTAL25 , \5:TIMING_DN_ANLG  );
capacitor #(.c(4.791e-18)) (*
integer library_binding = "analogLib";

 *)
c4834 ( \3:XTAL25 , \4:PHASE_250(8)  );
capacitor #(.c(3.033e-19)) (*
integer library_binding = "analogLib";

 *)
c4835 ( \3:XTAL25 , \24:VDDTX  );
capacitor #(.c(1.592e-18)) (*
integer library_binding = "analogLib";

 *)
c4836 ( \3:XTAL25 , \25:VDDTX  );
capacitor #(.c(7.782e-19)) (*
integer library_binding = "analogLib";

 *)
c4837 ( \3:XTAL25 , \5:TENBT_FILTER_1p0(1)  );
capacitor #(.c(5.619e-20)) (*
integer library_binding = "analogLib";

 *)
c4838 ( \3:XTAL25 , \AEQ_CNT_ANLG(0)  );
capacitor #(.c(7.547e-20)) (*
integer library_binding = "analogLib";

 *)
c4839 ( \3:XTAL25 , \PHASE_250(9)  );
capacitor #(.c(6.373e-20)) (*
integer library_binding = "analogLib";

 *)
c4840 ( \3:XTAL25 , \4:MLT3_TDATA_2p5(1)  );
capacitor #(.c(6.373e-20)) (*
integer library_binding = "analogLib";

 *)
c4841 ( \3:XTAL25 , \6:AEQ_DIS_2p5  );
capacitor #(.c(7.564e-20)) (*
integer library_binding = "analogLib";

 *)
c4842 ( \3:XTAL25 , \4:PHASE_250(10)  );
capacitor #(.c(7.142e-20)) (*
integer library_binding = "analogLib";

 *)
c4843 ( \3:XTAL25 , \4:PHASE_IN(9)  );
capacitor #(.c(8.962e-20)) (*
integer library_binding = "analogLib";

 *)
c4844 ( \3:XTAL25 , \PHASE_250(1)  );
capacitor #(.c(7.564e-20)) (*
integer library_binding = "analogLib";

 *)
c4845 ( \3:XTAL25 , MR_SQUELCH_DISB_2p5 );
capacitor #(.c(2.035e-19)) (*
integer library_binding = "analogLib";

 *)
c4846 ( \3:XTAL25 , \4:PHASE_250(2)  );
capacitor #(.c(6.373e-20)) (*
integer library_binding = "analogLib";

 *)
c4847 ( \3:XTAL25 , BLW_DIS_2p5 );
capacitor #(.c(7.373e-20)) (*
integer library_binding = "analogLib";

 *)
c4848 ( \3:XTAL25 , \4:RCLK125_TST  );
capacitor #(.c(8.948e-20)) (*
integer library_binding = "analogLib";

 *)
c4849 ( \3:XTAL25 , \4:PHASE_250(4)  );
capacitor #(.c(6.106e-20)) (*
integer library_binding = "analogLib";

 *)
c4850 ( \3:XTAL25 , \2:PHASE_IN(5)  );
capacitor #(.c(6.373e-20)) (*
integer library_binding = "analogLib";

 *)
c4851 ( \3:XTAL25 , TP_DISC_2p5 );
capacitor #(.c(8.945e-20)) (*
integer library_binding = "analogLib";

 *)
c4852 ( \3:XTAL25 , \4:PHASE_250(6)  );
capacitor #(.c(6.373e-20)) (*
integer library_binding = "analogLib";

 *)
c4853 ( \3:XTAL25 , ADC_DIS_2p5 );
capacitor #(.c(5.716e-20)) (*
integer library_binding = "analogLib";

 *)
c4854 ( \3:XTAL25 , \5:PHASE_IN(7)  );
capacitor #(.c(7.548e-20)) (*
integer library_binding = "analogLib";

 *)
c4855 ( \3:XTAL25 , \6:RX10_PRESENT_2p5  );
capacitor #(.c(5.611e-20)) (*
integer library_binding = "analogLib";

 *)
c4856 ( \3:XTAL25 , \4:PHASE_IN(8)  );
capacitor #(.c(3.786e-20)) (*
integer library_binding = "analogLib";

 *)
c4857 ( \3:XTAL25 , \5:AEQ_CNT_ANLG(4)  );
capacitor #(.c(4.873e-20)) (*
integer library_binding = "analogLib";

 *)
c4858 ( \3:XTAL25 , \5:WANDER_CNT(4)  );
capacitor #(.c(3.798e-20)) (*
integer library_binding = "analogLib";

 *)
c4859 ( \3:XTAL25 , \6:TIMING_UP_ANLG  );
capacitor #(.c(2.359e-20)) (*
integer library_binding = "analogLib";

 *)
c4860 ( \3:XTAL25 , TIMING_UP_ANLG );
capacitor #(.c(6.166e-20)) (*
integer library_binding = "analogLib";

 *)
c4861 ( \3:XTAL25 , \5:WANDER_CNT(6)  );
capacitor #(.c(1.934e-18)) (*
integer library_binding = "analogLib";

 *)
c4862 ( \3:XTAL25 , \TENBT_FILTER_1p0(0)  );
capacitor #(.c(1.682e-18)) (*
integer library_binding = "analogLib";

 *)
c4863 ( \3:XTAL25 , TENBT_CLK160_1p0 );
capacitor #(.c(2.419e-17)) (*
integer library_binding = "analogLib";

 *)
c4864 ( \3:XTAL25 , \6:TENBT_FILTER_1p0(0)  );
capacitor #(.c(1.767e-18)) (*
integer library_binding = "analogLib";

 *)
c4865 ( \3:XTAL25 , \5:RESET_10BT  );
capacitor #(.c(2.457e-17)) (*
integer library_binding = "analogLib";

 *)
c4866 ( \3:XTAL25 , RESET_10BT );
capacitor #(.c(4.483e-17)) (*
integer library_binding = "analogLib";

 *)
c4867 ( \3:XTAL25 , \4:PHASE_IN(10)  );
capacitor #(.c(1.876e-15)) (*
integer library_binding = "analogLib";

 *)
c4868 ( \3:XTAL25 , \PHASE_IN(10)  );
capacitor #(.c(2.904e-14)) (*
integer library_binding = "analogLib";

 *)
c4869 ( \3:XTAL25 , \1:PHASE_IN(1)  );
capacitor #(.c(2.523e-17)) (*
integer library_binding = "analogLib";

 *)
c4870 ( \3:XTAL25 , \TENBT_FILTER_1p0(1)  );
capacitor #(.c(3.781e-15)) (*
integer library_binding = "analogLib";

 *)
c4871 ( \3:XTAL25 , \2:PHASE_IN(1)  );
capacitor #(.c(1.686e-17)) (*
integer library_binding = "analogLib";

 *)
c4872 ( \3:XTAL25 , \2:PHASE_IN(9)  );
capacitor #(.c(2.379e-17)) (*
integer library_binding = "analogLib";

 *)
c4873 ( \3:XTAL25 , \6:TENBT_CLK160_1p0  );
capacitor #(.c(2.8e-17)) (*
integer library_binding = "analogLib";

 *)
c4874 ( \3:XTAL25 , \PHASE_IN(8)  );
capacitor #(.c(3.164e-17)) (*
integer library_binding = "analogLib";

 *)
c4875 ( \3:XTAL25 , \3:PHASE_IN(7)  );
capacitor #(.c(1.498e-18)) (*
integer library_binding = "analogLib";

 *)
c4876 ( \6:XTAL25 , \PHASE_250(2)  );
capacitor #(.c(9.948e-19)) (*
integer library_binding = "analogLib";

 *)
c4877 ( \6:XTAL25 , \WANDER_CNT(4)  );
capacitor #(.c(3.613e-16)) (*
integer library_binding = "analogLib";

 *)
c4878 ( \6:XTAL25 , \PHASE_250(8)  );
capacitor #(.c(6.8e-19)) (*
integer library_binding = "analogLib";

 *)
c4879 ( \6:XTAL25 , \WANDER_CNT(2)  );
capacitor #(.c(1.379e-17)) (*
integer library_binding = "analogLib";

 *)
c4880 ( \6:XTAL25 , \5:WANDER_CNT(2)  );
capacitor #(.c(9.761e-19)) (*
integer library_binding = "analogLib";

 *)
c4881 ( \6:XTAL25 , \AEQ_CNT_ANLG(4)  );
capacitor #(.c(8.788e-18)) (*
integer library_binding = "analogLib";

 *)
c4882 ( \6:XTAL25 , TIMING_DN_ANLG );
capacitor #(.c(5.408e-18)) (*
integer library_binding = "analogLib";

 *)
c4883 ( \6:XTAL25 , \5:TIMING_DN_ANLG  );
capacitor #(.c(1.15e-15)) (*
integer library_binding = "analogLib";

 *)
c4884 ( \6:XTAL25 , \4:PHASE_250(8)  );
capacitor #(.c(7.281e-17)) (*
integer library_binding = "analogLib";

 *)
c4885 ( \6:XTAL25 , \24:VDDTX  );
capacitor #(.c(3.823e-16)) (*
integer library_binding = "analogLib";

 *)
c4886 ( \6:XTAL25 , \25:VDDTX  );
capacitor #(.c(1.349e-17)) (*
integer library_binding = "analogLib";

 *)
c4887 ( \6:XTAL25 , \AEQ_CNT_ANLG(0)  );
capacitor #(.c(9.846e-19)) (*
integer library_binding = "analogLib";

 *)
c4888 ( \6:XTAL25 , \4:AEQ_CNT_ANLG(0)  );
capacitor #(.c(1.812e-17)) (*
integer library_binding = "analogLib";

 *)
c4889 ( \6:XTAL25 , \PHASE_250(9)  );
capacitor #(.c(1.53e-17)) (*
integer library_binding = "analogLib";

 *)
c4890 ( \6:XTAL25 , \4:MLT3_TDATA_2p5(1)  );
capacitor #(.c(1.53e-17)) (*
integer library_binding = "analogLib";

 *)
c4891 ( \6:XTAL25 , \6:AEQ_DIS_2p5  );
capacitor #(.c(1.816e-17)) (*
integer library_binding = "analogLib";

 *)
c4892 ( \6:XTAL25 , \4:PHASE_250(10)  );
capacitor #(.c(1.715e-17)) (*
integer library_binding = "analogLib";

 *)
c4893 ( \6:XTAL25 , \4:PHASE_IN(9)  );
capacitor #(.c(2.152e-17)) (*
integer library_binding = "analogLib";

 *)
c4894 ( \6:XTAL25 , \PHASE_250(1)  );
capacitor #(.c(1.816e-17)) (*
integer library_binding = "analogLib";

 *)
c4895 ( \6:XTAL25 , MR_SQUELCH_DISB_2p5 );
capacitor #(.c(1.744e-15)) (*
integer library_binding = "analogLib";

 *)
c4896 ( \6:XTAL25 , \4:PHASE_IN(10)  );
capacitor #(.c(4.885e-17)) (*
integer library_binding = "analogLib";

 *)
c4897 ( \6:XTAL25 , \4:PHASE_250(2)  );
capacitor #(.c(1.53e-17)) (*
integer library_binding = "analogLib";

 *)
c4898 ( \6:XTAL25 , BLW_DIS_2p5 );
capacitor #(.c(1.77e-17)) (*
integer library_binding = "analogLib";

 *)
c4899 ( \6:XTAL25 , \4:RCLK125_TST  );
capacitor #(.c(2.148e-17)) (*
integer library_binding = "analogLib";

 *)
c4900 ( \6:XTAL25 , \4:PHASE_250(4)  );
capacitor #(.c(2.519e-14)) (*
integer library_binding = "analogLib";

 *)
c4901 ( \6:XTAL25 , \2:PHASE_IN(1)  );
capacitor #(.c(1.466e-17)) (*
integer library_binding = "analogLib";

 *)
c4902 ( \6:XTAL25 , \2:PHASE_IN(5)  );
capacitor #(.c(1.53e-17)) (*
integer library_binding = "analogLib";

 *)
c4903 ( \6:XTAL25 , TP_DISC_2p5 );
capacitor #(.c(2.148e-17)) (*
integer library_binding = "analogLib";

 *)
c4904 ( \6:XTAL25 , \4:PHASE_250(6)  );
capacitor #(.c(1.53e-17)) (*
integer library_binding = "analogLib";

 *)
c4905 ( \6:XTAL25 , ADC_DIS_2p5 );
capacitor #(.c(1.372e-17)) (*
integer library_binding = "analogLib";

 *)
c4906 ( \6:XTAL25 , \5:PHASE_IN(7)  );
capacitor #(.c(1.812e-17)) (*
integer library_binding = "analogLib";

 *)
c4907 ( \6:XTAL25 , \6:RX10_PRESENT_2p5  );
capacitor #(.c(1.347e-17)) (*
integer library_binding = "analogLib";

 *)
c4908 ( \6:XTAL25 , \4:PHASE_IN(8)  );
capacitor #(.c(9.089e-18)) (*
integer library_binding = "analogLib";

 *)
c4909 ( \6:XTAL25 , \5:AEQ_CNT_ANLG(4)  );
capacitor #(.c(1.17e-17)) (*
integer library_binding = "analogLib";

 *)
c4910 ( \6:XTAL25 , \5:WANDER_CNT(4)  );
capacitor #(.c(9.118e-18)) (*
integer library_binding = "analogLib";

 *)
c4911 ( \6:XTAL25 , \6:TIMING_UP_ANLG  );
capacitor #(.c(5.664e-18)) (*
integer library_binding = "analogLib";

 *)
c4912 ( \6:XTAL25 , TIMING_UP_ANLG );
capacitor #(.c(9.981e-19)) (*
integer library_binding = "analogLib";

 *)
c4913 ( \6:XTAL25 , \WANDER_CNT(6)  );
capacitor #(.c(1.48e-17)) (*
integer library_binding = "analogLib";

 *)
c4914 ( \6:XTAL25 , \5:WANDER_CNT(6)  );
capacitor #(.c(1.679e-17)) (*
integer library_binding = "analogLib";

 *)
c4915 ( \TENBT_FILTER_1p0(1) , \3:PHASE_IN(7)  );
capacitor #(.c(2.612e-17)) (*
integer library_binding = "analogLib";

 *)
c4916 ( \TENBT_FILTER_1p0(1) , \PHASE_IN(8)  );
capacitor #(.c(1.558e-17)) (*
integer library_binding = "analogLib";

 *)
c4917 ( \TENBT_FILTER_1p0(1) , \2:PHASE_IN(9)  );
capacitor #(.c(2.232e-17)) (*
integer library_binding = "analogLib";

 *)
c4918 ( \TENBT_FILTER_1p0(1) , \1:PHASE_IN(5)  );
capacitor #(.c(6.883e-17)) (*
integer library_binding = "analogLib";

 *)
c4919 ( \TENBT_FILTER_1p0(1) , \TENBT_FILTER_1p0(0)  );
capacitor #(.c(5.405e-17)) (*
integer library_binding = "analogLib";

 *)
c4920 ( \TENBT_FILTER_1p0(1) , \1:PHASE_IN(1)  );
capacitor #(.c(5.47e-16)) (*
integer library_binding = "analogLib";

 *)
c4921 ( \TENBT_FILTER_1p0(1) , \6:TENBT_FILTER_1p0(0)  );
capacitor #(.c(3.191e-18)) (*
integer library_binding = "analogLib";

 *)
c4922 ( \5:TENBT_FILTER_1p0(1) , \1:PHASE_IN(1)  );
capacitor #(.c(1.456e-18)) (*
integer library_binding = "analogLib";

 *)
c4923 ( \5:TENBT_FILTER_1p0(1) , \3:PHASE_IN(7)  );
capacitor #(.c(2.266e-18)) (*
integer library_binding = "analogLib";

 *)
c4924 ( \5:TENBT_FILTER_1p0(1) , \PHASE_IN(8)  );
capacitor #(.c(1.351e-18)) (*
integer library_binding = "analogLib";

 *)
c4925 ( \5:TENBT_FILTER_1p0(1) , \2:PHASE_IN(9)  );
capacitor #(.c(1.936e-18)) (*
integer library_binding = "analogLib";

 *)
c4926 ( \5:TENBT_FILTER_1p0(1) , \1:PHASE_IN(5)  );
capacitor #(.c(4.636e-17)) (*
integer library_binding = "analogLib";

 *)
c4927 ( \5:TENBT_FILTER_1p0(1) , \6:TENBT_FILTER_1p0(0)  );
capacitor #(.c(4.795e-16)) (*
integer library_binding = "analogLib";

 *)
c4928 ( \5:TENBT_FILTER_1p0(1) , \TENBT_FILTER_1p0(0)  );
capacitor #(.c(4.694e-16)) (*
integer library_binding = "analogLib";

 *)
c4929 ( \5:TENBT_FILTER_1p0(1) , \24:VDDTX  );
capacitor #(.c(1.676e-17)) (*
integer library_binding = "analogLib";

 *)
c4930 ( X10_DIS_2p5, \3:TP_DISC_2p5  );
capacitor #(.c(4.35e-15)) (*
integer library_binding = "analogLib";

 *)
c4931 ( X10_DIS_2p5, TX100_DIS_2p5 );
capacitor #(.c(3.28e-17)) (*
integer library_binding = "analogLib";

 *)
c4932 ( X10_DIS_2p5, \2:TX100_DIS_2p5  );
capacitor #(.c(6.273e-16)) (*
integer library_binding = "analogLib";

 *)
c4933 ( \3:X10_DIS_2p5 , \3:MR_SQUELCH_DISB_2p5  );
capacitor #(.c(2.285e-16)) (*
integer library_binding = "analogLib";

 *)
c4934 ( \3:X10_DIS_2p5 , \5:ADC_DIS_2p5  );
capacitor #(.c(1.232e-16)) (*
integer library_binding = "analogLib";

 *)
c4935 ( \3:X10_DIS_2p5 , \WANDER_CNT(0)  );
capacitor #(.c(9.411e-18)) (*
integer library_binding = "analogLib";

 *)
c4936 ( \3:X10_DIS_2p5 , \4:WANDER_CNT(0)  );
capacitor #(.c(2.281e-15)) (*
integer library_binding = "analogLib";

 *)
c4937 ( \3:X10_DIS_2p5 , BLW_DIS_2p5 );
capacitor #(.c(5.616e-16)) (*
integer library_binding = "analogLib";

 *)
c4938 ( \3:X10_DIS_2p5 , ADC_DIS_2p5 );
capacitor #(.c(1.032e-19)) (*
integer library_binding = "analogLib";

 *)
c4939 ( \3:X10_DIS_2p5 , \3:TP_DISC_2p5  );
capacitor #(.c(1.994e-15)) (*
integer library_binding = "analogLib";

 *)
c4940 ( \3:X10_DIS_2p5 , MR_SQUELCH_DISB_2p5 );
capacitor #(.c(6.225e-16)) (*
integer library_binding = "analogLib";

 *)
c4941 ( \3:X10_DIS_2p5 , \5:BLW_DIS_2p5  );
capacitor #(.c(7.392e-17)) (*
integer library_binding = "analogLib";

 *)
c4942 ( \3:X10_DIS_2p5 , TX100_DIS_2p5 );
capacitor #(.c(1.314e-16)) (*
integer library_binding = "analogLib";

 *)
c4943 ( \3:X10_DIS_2p5 , \8:TX100_DIS_2p5  );
capacitor #(.c(8.555e-15)) (*
integer library_binding = "analogLib";

 *)
c4944 ( \3:X10_DIS_2p5 , \2:TX100_DIS_2p5  );
capacitor #(.c(1.266e-17)) (*
integer library_binding = "analogLib";

 *)
c4945 ( \3:X10_DIS_2p5 , \PHASE_250(10)  );
capacitor #(.c(1.058e-17)) (*
integer library_binding = "analogLib";

 *)
c4946 ( \3:X10_DIS_2p5 , \PHASE_250(6)  );
capacitor #(.c(1.102e-17)) (*
integer library_binding = "analogLib";

 *)
c4947 ( \3:X10_DIS_2p5 , TIMING_UP_ANLG );
capacitor #(.c(1.266e-17)) (*
integer library_binding = "analogLib";

 *)
c4948 ( \3:X10_DIS_2p5 , \PHASE_250(4)  );
capacitor #(.c(1.042e-17)) (*
integer library_binding = "analogLib";

 *)
c4949 ( \3:X10_DIS_2p5 , RCLK125_TST );
capacitor #(.c(1.266e-17)) (*
integer library_binding = "analogLib";

 *)
c4950 ( \3:X10_DIS_2p5 , \PHASE_250(2)  );
capacitor #(.c(1.266e-17)) (*
integer library_binding = "analogLib";

 *)
c4951 ( \3:X10_DIS_2p5 , \3:PHASE_250(9)  );
capacitor #(.c(1.266e-17)) (*
integer library_binding = "analogLib";

 *)
c4952 ( \3:X10_DIS_2p5 , \3:PHASE_250(1)  );
capacitor #(.c(1.266e-17)) (*
integer library_binding = "analogLib";

 *)
c4953 ( \3:X10_DIS_2p5 , \PHASE_250(8)  );
capacitor #(.c(2.786e-19)) (*
integer library_binding = "analogLib";

 *)
c4954 ( \6:X10_DIS_2p5 , \5:AEQ_CNT_ANLG(4)  );
capacitor #(.c(1.661e-17)) (*
integer library_binding = "analogLib";

 *)
c4955 ( \6:X10_DIS_2p5 , \AEQ_CNT_ANLG(4)  );
capacitor #(.c(6.526e-16)) (*
integer library_binding = "analogLib";

 *)
c4956 ( \6:X10_DIS_2p5 , \5:ADC_DIS_2p5  );
capacitor #(.c(6.518e-18)) (*
integer library_binding = "analogLib";

 *)
c4957 ( \6:X10_DIS_2p5 , ADC_DIS_2p5 );
capacitor #(.c(2.896e-17)) (*
integer library_binding = "analogLib";

 *)
c4958 ( \6:X10_DIS_2p5 , \WANDER_CNT(0)  );
capacitor #(.c(3e-19)) (*
integer library_binding = "analogLib";
 *)

c4959 ( \6:X10_DIS_2p5 , BLW_DIS_2p5 );
capacitor #(.c(2.131e-17)) (*
integer library_binding = "analogLib";

 *)
c4960 ( \6:X10_DIS_2p5 , \5:BLW_DIS_2p5  );
capacitor #(.c(9.234e-17)) (*
integer library_binding = "analogLib";

 *)
c4961 ( \6:X10_DIS_2p5 , \4:WANDER_CNT(0)  );
capacitor #(.c(3.572e-15)) (*
integer library_binding = "analogLib";

 *)
c4962 ( \6:X10_DIS_2p5 , \8:TX100_DIS_2p5  );
capacitor #(.c(6.159e-17)) (*
integer library_binding = "analogLib";

 *)
c4963 ( \6:X10_DIS_2p5 , \2:TX100_DIS_2p5  );
capacitor #(.c(1.688e-17)) (*
integer library_binding = "analogLib";

 *)
c4964 ( \6:X10_DIS_2p5 , T2_MODE );
capacitor #(.c(1.941e-17)) (*
integer library_binding = "analogLib";

 *)
c4965 ( \6:X10_DIS_2p5 , RX10_PRESENT_2p5 );
capacitor #(.c(8.602e-17)) (*
integer library_binding = "analogLib";

 *)
c4966 ( \6:X10_DIS_2p5 , AEQ_DIS_2p5 );
capacitor #(.c(1.941e-17)) (*
integer library_binding = "analogLib";

 *)
c4967 ( \6:X10_DIS_2p5 , \4:AEQ_CNT_ANLG(0)  );
capacitor #(.c(1.008e-16)) (*
integer library_binding = "analogLib";

 *)
c4968 ( \7:X10_DIS_2p5 , MR_SQUELCH_DISB_2p5 );
capacitor #(.c(1.259e-17)) (*
integer library_binding = "analogLib";

 *)
c4969 ( \7:X10_DIS_2p5 , \3:MR_SQUELCH_DISB_2p5  );
capacitor #(.c(6.153e-19)) (*
integer library_binding = "analogLib";

 *)
c4970 ( \7:X10_DIS_2p5 , \2:TX100_DIS_2p5  );
capacitor #(.c(1.679e-17)) (*
integer library_binding = "analogLib";

 *)
c4971 ( \7:X10_DIS_2p5 , \9:TX100_DIS_2p5  );
capacitor #(.c(2.161e-17)) (*
integer library_binding = "analogLib";

 *)
c4972 ( \7:X10_DIS_2p5 , \2:I_REXT_50(0)  );
capacitor #(.c(4.832e-16)) (*
integer library_binding = "analogLib";

 *)
c4973 ( \I_RPOLY_100(2) , \I_RPOLY_100(3)  );
capacitor #(.c(1.654e-14)) (*
integer library_binding = "analogLib";

 *)
c4974 ( \I_RPOLY_100(2) , \2:I_RPOLY_100(3)  );
capacitor #(.c(1.6e-15)) (*
integer library_binding = "analogLib";

 *)
c4975 ( \3:I_RPOLY_100(2) , \I_RPOLY_100(3)  );
capacitor #(.c(5.381e-16)) (*
integer library_binding = "analogLib";

 *)
c4976 ( \3:I_RPOLY_100(2) , \2:I_RPOLY_100(3)  );
capacitor #(.c(1.276e-17)) (*
integer library_binding = "analogLib";

 *)
c4977 ( \4:I_RPOLY_100(2) , \7:I_REXT_50(0)  );
capacitor #(.c(1.508e-17)) (*
integer library_binding = "analogLib";

 *)
c4978 ( \4:I_RPOLY_100(2) , \3:ADC_1p0(4)  );
capacitor #(.c(4.544e-17)) (*
integer library_binding = "analogLib";

 *)
c4979 ( \4:I_RPOLY_100(2) , \2:I_RPOLY_100(3)  );
capacitor #(.c(1.287e-14)) (*
integer library_binding = "analogLib";

 *)
c4980 ( \4:I_RPOLY_100(2) , \4:I_RPOLY_100(3)  );
capacitor #(.c(2.725e-19)) (*
integer library_binding = "analogLib";

 *)
c4981 ( \FLASH_1p0(1) , \4:MLT3_TDATA_1p0(0)  );
capacitor #(.c(1.659e-18)) (*
integer library_binding = "analogLib";

 *)
c4982 ( \FLASH_1p0(1) , X_125 );
capacitor #(.c(1.687e-18)) (*
integer library_binding = "analogLib";

 *)
c4983 ( \FLASH_1p0(1) , \MLT3_TDATA_1p0(0)  );
capacitor #(.c(3e-19)) (*
integer library_binding = "analogLib";
 *)

c4984 ( \FLASH_1p0(1) , \4:X_125  );
capacitor #(.c(2.812e-19)) (*
integer library_binding = "analogLib";

 *)
c4985 ( \FLASH_1p0(1) , \4:SLICER_OUT_1p0  );
capacitor #(.c(1.678e-18)) (*
integer library_binding = "analogLib";

 *)
c4986 ( \FLASH_1p0(1) , SLICER_OUT_1p0 );
capacitor #(.c(1.676e-18)) (*
integer library_binding = "analogLib";

 *)
c4987 ( \FLASH_1p0(1) , \TX_SLOPETRIM_1p0(1)  );
capacitor #(.c(2.837e-19)) (*
integer library_binding = "analogLib";

 *)
c4988 ( \FLASH_1p0(1) , \4:TX_SLOPETRIM_1p0(1)  );
capacitor #(.c(1.646e-18)) (*
integer library_binding = "analogLib";

 *)
c4989 ( \FLASH_1p0(1) , \3:TEST_MODE(2)  );
capacitor #(.c(3.132e-19)) (*
integer library_binding = "analogLib";

 *)
c4990 ( \FLASH_1p0(1) , \TEST_MODE(2)  );
capacitor #(.c(2.423e-19)) (*
integer library_binding = "analogLib";

 *)
c4991 ( \FLASH_1p0(1) , \1:RCLK125_1p0  );
capacitor #(.c(1.919e-18)) (*
integer library_binding = "analogLib";

 *)
c4992 ( \FLASH_1p0(1) , \7:RCLK125_1p0  );
capacitor #(.c(8.21e-16)) (*
integer library_binding = "analogLib";

 *)
c4993 ( \FLASH_1p0(1) , \7:ADC_1p0(4)  );
capacitor #(.c(6.254e-15)) (*
integer library_binding = "analogLib";

 *)
c4994 ( \FLASH_1p0(1) , \1:ADC_1p0(4)  );
capacitor #(.c(1.959e-17)) (*
integer library_binding = "analogLib";

 *)
c4995 ( \FLASH_1p0(1) , \4:MR_SQUELCH_RANGE_1p0(1)  );
capacitor #(.c(1.959e-17)) (*
integer library_binding = "analogLib";

 *)
c4996 ( \FLASH_1p0(1) , \MR_SQUELCH_RANGE_1p0(0)  );
capacitor #(.c(1.959e-17)) (*
integer library_binding = "analogLib";

 *)
c4997 ( \FLASH_1p0(1) , POS_DETECT_1p0 );
capacitor #(.c(1.959e-17)) (*
integer library_binding = "analogLib";

 *)
c4998 ( \FLASH_1p0(1) , \4:MR_SQUELCH_DISB_1p0  );
capacitor #(.c(1.959e-17)) (*
integer library_binding = "analogLib";

 *)
c4999 ( \FLASH_1p0(1) , NEG_DETECT_1p0 );
capacitor #(.c(1.959e-17)) (*
integer library_binding = "analogLib";

 *)
c5000 ( \FLASH_1p0(1) , XTAL25_1p0 );
capacitor #(.c(2.452e-18)) (*
integer library_binding = "analogLib";

 *)
c5001 ( \7:FLASH_1p0(1) , \4:MLT3_TDATA_1p0(0)  );
capacitor #(.c(1.493e-17)) (*
integer library_binding = "analogLib";

 *)
c5002 ( \7:FLASH_1p0(1) , X_125 );
capacitor #(.c(5.016e-16)) (*
integer library_binding = "analogLib";

 *)
c5003 ( \7:FLASH_1p0(1) , \1:ADC_1p0(4)  );
capacitor #(.c(4.7e-15)) (*
integer library_binding = "analogLib";

 *)
c5004 ( \7:FLASH_1p0(1) , \7:ADC_1p0(4)  );
capacitor #(.c(1.518e-17)) (*
integer library_binding = "analogLib";

 *)
c5005 ( \7:FLASH_1p0(1) , \MLT3_TDATA_1p0(0)  );
capacitor #(.c(2.699e-18)) (*
integer library_binding = "analogLib";

 *)
c5006 ( \7:FLASH_1p0(1) , \4:X_125  );
capacitor #(.c(2.53e-18)) (*
integer library_binding = "analogLib";

 *)
c5007 ( \7:FLASH_1p0(1) , \4:SLICER_OUT_1p0  );
capacitor #(.c(1.51e-17)) (*
integer library_binding = "analogLib";

 *)
c5008 ( \7:FLASH_1p0(1) , SLICER_OUT_1p0 );
capacitor #(.c(1.508e-17)) (*
integer library_binding = "analogLib";

 *)
c5009 ( \7:FLASH_1p0(1) , \TX_SLOPETRIM_1p0(1)  );
capacitor #(.c(2.553e-18)) (*
integer library_binding = "analogLib";

 *)
c5010 ( \7:FLASH_1p0(1) , \4:TX_SLOPETRIM_1p0(1)  );
capacitor #(.c(1.481e-17)) (*
integer library_binding = "analogLib";

 *)
c5011 ( \7:FLASH_1p0(1) , \3:TEST_MODE(2)  );
capacitor #(.c(2.818e-18)) (*
integer library_binding = "analogLib";

 *)
c5012 ( \7:FLASH_1p0(1) , \TEST_MODE(2)  );
capacitor #(.c(2.18e-18)) (*
integer library_binding = "analogLib";

 *)
c5013 ( \7:FLASH_1p0(1) , \1:RCLK125_1p0  );
capacitor #(.c(1.727e-17)) (*
integer library_binding = "analogLib";

 *)
c5014 ( \7:FLASH_1p0(1) , \7:RCLK125_1p0  );
capacitor #(.c(7.062e-18)) (*
integer library_binding = "analogLib";

 *)
c5015 ( \3:FLASH_1p0(1) , \1:RCLK125_1p0  );
capacitor #(.c(6.534e-18)) (*
integer library_binding = "analogLib";

 *)
c5016 ( \3:FLASH_1p0(1) , \4:RCLK125_1p0  );
capacitor #(.c(1.354e-16)) (*
integer library_binding = "analogLib";

 *)
c5017 ( \3:FLASH_1p0(1) , \ADC_1p0(4)  );
capacitor #(.c(1.42e-19)) (*
integer library_binding = "analogLib";

 *)
c5018 ( \4:FLASH_1p0(1) , RCLK125_1p0 );
capacitor #(.c(1.895e-17)) (*
integer library_binding = "analogLib";

 *)
c5019 ( \4:FLASH_1p0(1) , \7:I_REXT_50(0)  );
capacitor #(.c(2.659e-18)) (*
integer library_binding = "analogLib";

 *)
c5020 ( \4:FLASH_1p0(1) , \I_REXT_50(0)  );
capacitor #(.c(1.023e-17)) (*
integer library_binding = "analogLib";

 *)
c5021 ( \4:FLASH_1p0(1) , \4:RCLK125_1p0  );
capacitor #(.c(1.117e-19)) (*
integer library_binding = "analogLib";

 *)
c5022 ( \6:FLASH_1p0(1) , \4:RCLK125_1p0  );
capacitor #(.c(1.616e-17)) (*
integer library_binding = "analogLib";

 *)
c5023 ( \6:FLASH_1p0(1) , RCLK125_1p0 );
capacitor #(.c(1.953e-17)) (*
integer library_binding = "analogLib";

 *)
c5024 ( RCLK125_1p0, \6:ADC_1p0(4)  );
capacitor #(.c(1.351e-19)) (*
integer library_binding = "analogLib";

 *)
c5025 ( \4:RCLK125_1p0 , \6:ADC_1p0(4)  );
capacitor #(.c(1.692e-17)) (*
integer library_binding = "analogLib";

 *)
c5026 ( \4:RCLK125_1p0 , \7:I_REXT_50(0)  );
capacitor #(.c(2.374e-18)) (*
integer library_binding = "analogLib";

 *)
c5027 ( \4:RCLK125_1p0 , \I_REXT_50(0)  );
capacitor #(.c(1.315e-17)) (*
integer library_binding = "analogLib";

 *)
c5028 ( \4:RCLK125_1p0 , \4:I_RPOLY_100(5)  );
capacitor #(.c(4.947e-17)) (*
integer library_binding = "analogLib";

 *)
c5029 ( \1:RCLK125_1p0 , \3:TEST_MODE(2)  );
capacitor #(.c(4.585e-16)) (*
integer library_binding = "analogLib";

 *)
c5030 ( \1:RCLK125_1p0 , \TEST_MODE(2)  );
capacitor #(.c(1.334e-17)) (*
integer library_binding = "analogLib";

 *)
c5031 ( \1:RCLK125_1p0 , \4:X_125  );
capacitor #(.c(1.729e-17)) (*
integer library_binding = "analogLib";

 *)
c5032 ( \1:RCLK125_1p0 , POS_DETECT_1p0 );
capacitor #(.c(1.31e-17)) (*
integer library_binding = "analogLib";

 *)
c5033 ( \1:RCLK125_1p0 , \4:TX_SLOPETRIM_1p0(1)  );
capacitor #(.c(1.729e-17)) (*
integer library_binding = "analogLib";

 *)
c5034 ( \1:RCLK125_1p0 , \4:MR_SQUELCH_DISB_1p0  );
capacitor #(.c(1.729e-17)) (*
integer library_binding = "analogLib";

 *)
c5035 ( \1:RCLK125_1p0 , NEG_DETECT_1p0 );
capacitor #(.c(1.729e-17)) (*
integer library_binding = "analogLib";

 *)
c5036 ( \1:RCLK125_1p0 , XTAL25_1p0 );
capacitor #(.c(1.729e-17)) (*
integer library_binding = "analogLib";

 *)
c5037 ( \1:RCLK125_1p0 , \4:MR_SQUELCH_RANGE_1p0(1)  );
capacitor #(.c(1.729e-17)) (*
integer library_binding = "analogLib";

 *)
c5038 ( \1:RCLK125_1p0 , \4:MLT3_TDATA_1p0(0)  );
capacitor #(.c(1.729e-17)) (*
integer library_binding = "analogLib";

 *)
c5039 ( \1:RCLK125_1p0 , \4:SLICER_OUT_1p0  );
capacitor #(.c(1.729e-17)) (*
integer library_binding = "analogLib";

 *)
c5040 ( \1:RCLK125_1p0 , \MR_SQUELCH_RANGE_1p0(0)  );
capacitor #(.c(8.51e-17)) (*
integer library_binding = "analogLib";

 *)
c5041 ( \7:RCLK125_1p0 , \TEST_MODE(2)  );
capacitor #(.c(3.916e-16)) (*
integer library_binding = "analogLib";

 *)
c5042 ( \7:RCLK125_1p0 , \3:TEST_MODE(2)  );
capacitor #(.c(2.096e-17)) (*
integer library_binding = "analogLib";

 *)
c5043 ( \PHASE_IN(8) , RESET_10BT );
capacitor #(.c(2.206e-18)) (*
integer library_binding = "analogLib";

 *)
c5044 ( \PHASE_IN(8) , \TENBT_FILTER_1p0(0)  );
capacitor #(.c(1.77e-17)) (*
integer library_binding = "analogLib";

 *)
c5045 ( \PHASE_IN(8) , \6:TENBT_FILTER_1p0(0)  );
capacitor #(.c(1.99e-18)) (*
integer library_binding = "analogLib";

 *)
c5046 ( \PHASE_IN(8) , \PHASE_IN(7)  );
capacitor #(.c(8.463e-20)) (*
integer library_binding = "analogLib";

 *)
c5047 ( \PHASE_IN(8) , \3:PHASE_IN(7)  );
capacitor #(.c(5.818e-18)) (*
integer library_binding = "analogLib";

 *)
c5048 ( \PHASE_IN(8) , TENBT_CLK160_1p0 );
capacitor #(.c(3.03e-18)) (*
integer library_binding = "analogLib";

 *)
c5049 ( \PHASE_IN(8) , \PHASE_IN(9)  );
capacitor #(.c(6.757e-19)) (*
integer library_binding = "analogLib";

 *)
c5050 ( \PHASE_IN(8) , \6:PHASE_IN(10)  );
capacitor #(.c(2.992e-18)) (*
integer library_binding = "analogLib";

 *)
c5051 ( \PHASE_IN(8) , \5:RESET_10BT  );
capacitor #(.c(3.589e-17)) (*
integer library_binding = "analogLib";

 *)
c5052 ( \PHASE_IN(8) , \6:TENBT_CLK160_1p0  );
capacitor #(.c(2.254e-17)) (*
integer library_binding = "analogLib";

 *)
c5053 ( \PHASE_IN(8) , \2:PHASE_IN(9)  );
capacitor #(.c(1.111e-14)) (*
integer library_binding = "analogLib";

 *)
c5054 ( \PHASE_IN(8) , \1:PHASE_IN(5)  );
capacitor #(.c(8.627e-17)) (*
integer library_binding = "analogLib";

 *)
c5055 ( \PHASE_IN(8) , \2:PHASE_IN(5)  );
capacitor #(.c(8.215e-16)) (*
integer library_binding = "analogLib";

 *)
c5056 ( \PHASE_IN(8) , \1:PHASE_IN(1)  );
capacitor #(.c(2.978e-18)) (*
integer library_binding = "analogLib";

 *)
c5057 ( \6:PHASE_IN(8) , \3:PHASE_IN(7)  );
capacitor #(.c(1.886e-17)) (*
integer library_binding = "analogLib";

 *)
c5058 ( \6:PHASE_IN(8) , \6:PHASE_IN(10)  );
capacitor #(.c(3.154e-18)) (*
integer library_binding = "analogLib";

 *)
c5059 ( \6:PHASE_IN(8) , \2:PHASE_IN(9)  );
capacitor #(.c(1.646e-16)) (*
integer library_binding = "analogLib";

 *)
c5060 ( \6:PHASE_IN(8) , \PHASE_IN(9)  );
capacitor #(.c(1.349e-16)) (*
integer library_binding = "analogLib";

 *)
c5061 ( \6:PHASE_IN(8) , \PHASE_IN(7)  );
capacitor #(.c(3.333e-17)) (*
integer library_binding = "analogLib";

 *)
c5062 ( \6:PHASE_IN(8) , \PHASE_IN(5)  );
capacitor #(.c(1.358e-17)) (*
integer library_binding = "analogLib";

 *)
c5063 ( \6:PHASE_IN(8) , \PHASE_IN(1)  );
capacitor #(.c(8.364e-18)) (*
integer library_binding = "analogLib";

 *)
c5064 ( \4:PHASE_IN(8) , \WANDER_CNT(4)  );
capacitor #(.c(1.811e-16)) (*
integer library_binding = "analogLib";

 *)
c5065 ( \4:PHASE_IN(8) , \5:PHASE_IN(5)  );
capacitor #(.c(4.525e-17)) (*
integer library_binding = "analogLib";

 *)
c5066 ( \4:PHASE_IN(8) , \24:VDDTX  );
capacitor #(.c(2.376e-16)) (*
integer library_binding = "analogLib";

 *)
c5067 ( \4:PHASE_IN(8) , \25:VDDTX  );
capacitor #(.c(2.65e-16)) (*
integer library_binding = "analogLib";

 *)
c5068 ( \4:PHASE_IN(8) , \7:PHASE_IN(9)  );
capacitor #(.c(2.258e-18)) (*
integer library_binding = "analogLib";

 *)
c5069 ( \4:PHASE_IN(8) , \5:PHASE_IN(1)  );
capacitor #(.c(9.836e-17)) (*
integer library_binding = "analogLib";

 *)
c5070 ( \4:PHASE_IN(8) , \5:WANDER_CNT(4)  );
capacitor #(.c(1.191e-14)) (*
integer library_binding = "analogLib";

 *)
c5071 ( \4:PHASE_IN(8) , \2:PHASE_IN(5)  );
capacitor #(.c(7.793e-16)) (*
integer library_binding = "analogLib";

 *)
c5072 ( \4:PHASE_IN(8) , \2:PHASE_IN(1)  );
capacitor #(.c(1.983e-17)) (*
integer library_binding = "analogLib";

 *)
c5073 ( \4:PHASE_IN(8) , \5:PHASE_IN(7)  );
capacitor #(.c(1.003e-15)) (*
integer library_binding = "analogLib";

 *)
c5074 ( \4:PHASE_IN(8) , \4:PHASE_IN(9)  );
capacitor #(.c(1.051e-16)) (*
integer library_binding = "analogLib";

 *)
c5075 ( \4:PHASE_IN(8) , MR_BYPASS10RX_FILTER );
capacitor #(.c(1.117e-17)) (*
integer library_binding = "analogLib";

 *)
c5076 ( \4:PHASE_IN(8) , \4:PHASE_IN(10)  );
capacitor #(.c(1.662e-16)) (*
integer library_binding = "analogLib";

 *)
c5077 ( \7:PHASE_IN(8) , \2:PHASE_IN(5)  );
capacitor #(.c(2.462e-16)) (*
integer library_binding = "analogLib";

 *)
c5078 ( \7:PHASE_IN(8) , \5:PHASE_IN(5)  );
capacitor #(.c(1.001e-17)) (*
integer library_binding = "analogLib";

 *)
c5079 ( \7:PHASE_IN(8) , \24:VDDTX  );
capacitor #(.c(5.257e-17)) (*
integer library_binding = "analogLib";

 *)
c5080 ( \7:PHASE_IN(8) , \25:VDDTX  );
capacitor #(.c(1.406e-18)) (*
integer library_binding = "analogLib";

 *)
c5081 ( \7:PHASE_IN(8) , \4:PHASE_IN(10)  );
capacitor #(.c(9.523e-18)) (*
integer library_binding = "analogLib";

 *)
c5082 ( \7:PHASE_IN(8) , \7:PHASE_IN(10)  );
capacitor #(.c(2.872e-18)) (*
integer library_binding = "analogLib";

 *)
c5083 ( \7:PHASE_IN(8) , \2:PHASE_IN(1)  );
capacitor #(.c(3.539e-18)) (*
integer library_binding = "analogLib";

 *)
c5084 ( \7:PHASE_IN(8) , \5:PHASE_IN(1)  );
capacitor #(.c(1.513e-17)) (*
integer library_binding = "analogLib";

 *)
c5085 ( \7:PHASE_IN(8) , \5:PHASE_IN(7)  );
capacitor #(.c(2.486e-16)) (*
integer library_binding = "analogLib";

 *)
c5086 ( \7:PHASE_IN(8) , \4:PHASE_IN(9)  );
capacitor #(.c(6.365e-16)) (*
integer library_binding = "analogLib";

 *)
c5087 ( \7:PHASE_IN(8) , \7:PHASE_IN(9)  );
capacitor #(.c(1.493e-16)) (*
integer library_binding = "analogLib";

 *)
c5088 ( \7:PHASE_IN(8) , \7:PHASE_IN(7)  );
capacitor #(.c(1.109e-16)) (*
integer library_binding = "analogLib";

 *)
c5089 ( \7:PHASE_IN(10) , \25:VDDTX  );
capacitor #(.c(7.899e-18)) (*
integer library_binding = "analogLib";

 *)
c5090 ( \7:PHASE_IN(10) , \7:PHASE_IN(7)  );
capacitor #(.c(1.624e-18)) (*
integer library_binding = "analogLib";

 *)
c5091 ( \7:PHASE_IN(10) , \5:PHASE_IN(7)  );
capacitor #(.c(3.312e-16)) (*
integer library_binding = "analogLib";

 *)
c5092 ( \7:PHASE_IN(10) , \7:PHASE_IN(9)  );
capacitor #(.c(7.338e-18)) (*
integer library_binding = "analogLib";

 *)
c5093 ( \4:PHASE_IN(10) , TIMING_DN_ANLG );
capacitor #(.c(4.516e-18)) (*
integer library_binding = "analogLib";

 *)
c5094 ( \4:PHASE_IN(10) , \5:TIMING_DN_ANLG  );
capacitor #(.c(5.873e-17)) (*
integer library_binding = "analogLib";

 *)
c5095 ( \4:PHASE_IN(10) , \24:VDDTX  );
capacitor #(.c(2.586e-17)) (*
integer library_binding = "analogLib";

 *)
c5096 ( \4:PHASE_IN(10) , \7:PHASE_IN(9)  );
capacitor #(.c(3.247e-16)) (*
integer library_binding = "analogLib";

 *)
c5097 ( \4:PHASE_IN(10) , \25:VDDTX  );
capacitor #(.c(1.166e-18)) (*
integer library_binding = "analogLib";

 *)
c5098 ( \4:PHASE_IN(10) , \7:PHASE_IN(7)  );
capacitor #(.c(2.397e-19)) (*
integer library_binding = "analogLib";

 *)
c5099 ( \4:PHASE_IN(10) , \5:PHASE_IN(7)  );
capacitor #(.c(1.311e-17)) (*
integer library_binding = "analogLib";

 *)
c5100 ( \4:PHASE_IN(10) , \4:PHASE_IN(9)  );
capacitor #(.c(1.042e-17)) (*
integer library_binding = "analogLib";

 *)
c5101 ( \4:PHASE_IN(10) , \2:PHASE_IN(5)  );
capacitor #(.c(1.004e-17)) (*
integer library_binding = "analogLib";

 *)
c5102 ( \4:PHASE_IN(10) , \2:PHASE_IN(1)  );
capacitor #(.c(1.704e-17)) (*
integer library_binding = "analogLib";

 *)
c5103 ( \6:PHASE_IN(10) , \PHASE_IN(7)  );
capacitor #(.c(7.248e-19)) (*
integer library_binding = "analogLib";

 *)
c5104 ( \6:PHASE_IN(10) , \3:PHASE_IN(7)  );
capacitor #(.c(4.317e-18)) (*
integer library_binding = "analogLib";

 *)
c5105 ( \6:PHASE_IN(10) , \2:PHASE_IN(9)  );
capacitor #(.c(1.885e-16)) (*
integer library_binding = "analogLib";

 *)
c5106 ( \6:PHASE_IN(10) , \PHASE_IN(9)  );
capacitor #(.c(3.642e-17)) (*
integer library_binding = "analogLib";

 *)
c5107 ( \6:PHASE_IN(10) , \PHASE_IN(5)  );
capacitor #(.c(1.666e-17)) (*
integer library_binding = "analogLib";

 *)
c5108 ( \6:PHASE_IN(10) , \PHASE_IN(1)  );
capacitor #(.c(1.06e-17)) (*
integer library_binding = "analogLib";

 *)
c5109 ( \TENBT_FILTER_1p0(0) , \1:PHASE_IN(1)  );
capacitor #(.c(1.639e-18)) (*
integer library_binding = "analogLib";

 *)
c5110 ( \TENBT_FILTER_1p0(0) , \1:PHASE_IN(5)  );
capacitor #(.c(1.405e-18)) (*
integer library_binding = "analogLib";

 *)
c5111 ( \TENBT_FILTER_1p0(0) , \3:PHASE_IN(7)  );
capacitor #(.c(1.875e-18)) (*
integer library_binding = "analogLib";

 *)
c5112 ( \TENBT_FILTER_1p0(0) , \2:PHASE_IN(9)  );
capacitor #(.c(4.694e-16)) (*
integer library_binding = "analogLib";

 *)
c5113 ( \TENBT_FILTER_1p0(0) , \24:VDDTX  );
capacitor #(.c(1.315e-17)) (*
integer library_binding = "analogLib";

 *)
c5114 ( \6:TENBT_FILTER_1p0(0) , \1:PHASE_IN(5)  );
capacitor #(.c(1.128e-17)) (*
integer library_binding = "analogLib";

 *)
c5115 ( \6:TENBT_FILTER_1p0(0) , \3:PHASE_IN(7)  );
capacitor #(.c(1.505e-17)) (*
integer library_binding = "analogLib";

 *)
c5116 ( \6:TENBT_FILTER_1p0(0) , \2:PHASE_IN(9)  );
capacitor #(.c(9.882e-17)) (*
integer library_binding = "analogLib";

 *)
c5117 ( \6:TENBT_FILTER_1p0(0) , \1:PHASE_IN(1)  );
capacitor #(.c(1.602e-17)) (*
integer library_binding = "analogLib";

 *)
c5118 ( \4:I_RPOLY_100(5) , \7:I_REXT_50(0)  );
capacitor #(.c(1.834e-17)) (*
integer library_binding = "analogLib";

 *)
c5119 ( \4:I_RPOLY_100(5) , \3:ADC_1p0(4)  );
capacitor #(.c(6.668e-20)) (*
integer library_binding = "analogLib";

 *)
c5120 ( \WANDER_CNT(6) , \5:WANDER_CNT(4)  );
capacitor #(.c(2.026e-17)) (*
integer library_binding = "analogLib";

 *)
c5121 ( \WANDER_CNT(6) , \WANDER_CNT(4)  );
capacitor #(.c(5.054e-20)) (*
integer library_binding = "analogLib";

 *)
c5122 ( \WANDER_CNT(6) , \WANDER_CNT(2)  );
capacitor #(.c(1.025e-18)) (*
integer library_binding = "analogLib";

 *)
c5123 ( \WANDER_CNT(6) , \5:WANDER_CNT(2)  );
capacitor #(.c(2.325e-17)) (*
integer library_binding = "analogLib";

 *)
c5124 ( \WANDER_CNT(6) , \6:I_REXT_50(0)  );
capacitor #(.c(2.255e-18)) (*
integer library_binding = "analogLib";

 *)
c5125 ( \WANDER_CNT(6) , \2:I_REXT_50(0)  );
capacitor #(.c(1.28e-19)) (*
integer library_binding = "analogLib";

 *)
c5126 ( \WANDER_CNT(6) , \WANDER_CNT(0)  );
capacitor #(.c(2.888e-17)) (*
integer library_binding = "analogLib";

 *)
c5127 ( \WANDER_CNT(6) , \24:VDDTX  );
capacitor #(.c(1.516e-16)) (*
integer library_binding = "analogLib";

 *)
c5128 ( \WANDER_CNT(6) , \25:VDDTX  );
capacitor #(.c(1.889e-18)) (*
integer library_binding = "analogLib";

 *)
c5129 ( \WANDER_CNT(6) , \AEQ_CNT_ANLG(0)  );
capacitor #(.c(1.089e-18)) (*
integer library_binding = "analogLib";

 *)
c5130 ( \WANDER_CNT(6) , \4:PHASE_IN(9)  );
capacitor #(.c(1.002e-18)) (*
integer library_binding = "analogLib";

 *)
c5131 ( \WANDER_CNT(6) , \2:PHASE_IN(1)  );
capacitor #(.c(1.949e-17)) (*
integer library_binding = "analogLib";

 *)
c5132 ( \WANDER_CNT(6) , \4:AEQ_CNT_ANLG(0)  );
capacitor #(.c(1.617e-18)) (*
integer library_binding = "analogLib";

 *)
c5133 ( \WANDER_CNT(6) , \6:AEQ_DIS_2p5  );
capacitor #(.c(2.153e-17)) (*
integer library_binding = "analogLib";

 *)
c5134 ( \WANDER_CNT(6) , AEQ_DIS_2p5 );
capacitor #(.c(1.513e-16)) (*
integer library_binding = "analogLib";

 *)
c5135 ( \WANDER_CNT(6) , \6:T2_MODE  );
capacitor #(.c(1.378e-15)) (*
integer library_binding = "analogLib";

 *)
c5136 ( \WANDER_CNT(6) , T2_MODE );
capacitor #(.c(1.418e-17)) (*
integer library_binding = "analogLib";

 *)
c5137 ( \WANDER_CNT(6) , \4:WANDER_CNT(0)  );
capacitor #(.c(7.495e-19)) (*
integer library_binding = "analogLib";

 *)
c5138 ( \5:WANDER_CNT(6) , \WANDER_CNT(2)  );
capacitor #(.c(1.521e-17)) (*
integer library_binding = "analogLib";

 *)
c5139 ( \5:WANDER_CNT(6) , \5:WANDER_CNT(2)  );
capacitor #(.c(4.591e-19)) (*
integer library_binding = "analogLib";

 *)
c5140 ( \5:WANDER_CNT(6) , \6:I_REXT_50(0)  );
capacitor #(.c(4.452e-20)) (*
integer library_binding = "analogLib";

 *)
c5141 ( \5:WANDER_CNT(6) , \2:I_REXT_50(0)  );
capacitor #(.c(4.283e-16)) (*
integer library_binding = "analogLib";

 *)
c5142 ( \5:WANDER_CNT(6) , \24:VDDTX  );
capacitor #(.c(2.249e-15)) (*
integer library_binding = "analogLib";

 *)
c5143 ( \5:WANDER_CNT(6) , \25:VDDTX  );
capacitor #(.c(1.489e-17)) (*
integer library_binding = "analogLib";

 *)
c5144 ( \5:WANDER_CNT(6) , \AEQ_CNT_ANLG(0)  );
capacitor #(.c(1.615e-17)) (*
integer library_binding = "analogLib";

 *)
c5145 ( \5:WANDER_CNT(6) , \4:PHASE_IN(9)  );
capacitor #(.c(1.464e-15)) (*
integer library_binding = "analogLib";

 *)
c5146 ( \5:WANDER_CNT(6) , \6:T2_MODE  );
capacitor #(.c(1.487e-17)) (*
integer library_binding = "analogLib";

 *)
c5147 ( \5:WANDER_CNT(6) , \2:PHASE_IN(1)  );
capacitor #(.c(3.774e-18)) (*
integer library_binding = "analogLib";

 *)
c5148 ( \5:WANDER_CNT(6) , AEQ_DIS_2p5 );
capacitor #(.c(1.639e-15)) (*
integer library_binding = "analogLib";

 *)
c5149 ( \5:WANDER_CNT(6) , T2_MODE );
capacitor #(.c(2.8e-19)) (*
integer library_binding = "analogLib";

 *)
c5150 ( \5:WANDER_CNT(6) , \4:WANDER_CNT(0)  );
capacitor #(.c(1.386e-17)) (*
integer library_binding = "analogLib";

 *)
c5151 ( \5:WANDER_CNT(6) , \6:AEQ_DIS_2p5  );
capacitor #(.c(1.469e-18)) (*
integer library_binding = "analogLib";

 *)
c5152 ( \5:WANDER_CNT(6) , \4:AEQ_CNT_ANLG(0)  );
capacitor #(.c(1.896e-17)) (*
integer library_binding = "analogLib";

 *)
c5153 ( \MR_SQUELCH_RANGE_1p0(1) , \3:POS_DETECT_1p0  );
capacitor #(.c(7.835e-16)) (*
integer library_binding = "analogLib";

 *)
c5154 ( \MR_SQUELCH_RANGE_1p0(1) , \3:XTAL25_1p0  );
capacitor #(.c(1.949e-17)) (*
integer library_binding = "analogLib";

 *)
c5155 ( \MR_SQUELCH_RANGE_1p0(1) , SLICER_OUT_1p0 );
capacitor #(.c(1.949e-17)) (*
integer library_binding = "analogLib";

 *)
c5156 ( \MR_SQUELCH_RANGE_1p0(1) , X_125 );
capacitor #(.c(1.949e-17)) (*
integer library_binding = "analogLib";

 *)
c5157 ( \MR_SQUELCH_RANGE_1p0(1) , \MLT3_TDATA_1p0(0)  );
capacitor #(.c(3.469e-18)) (*
integer library_binding = "analogLib";

 *)
c5158 ( \MR_SQUELCH_RANGE_1p0(1) , POS_DETECT_1p0 );
capacitor #(.c(1.154e-16)) (*
integer library_binding = "analogLib";

 *)
c5159 ( \MR_SQUELCH_RANGE_1p0(1) , XTAL25_1p0 );
capacitor #(.c(2.198e-17)) (*
integer library_binding = "analogLib";

 *)
c5160 ( \4:MR_SQUELCH_RANGE_1p0(1) , \4:MLT3_TDATA_1p0(0)  );
capacitor #(.c(1.853e-17)) (*
integer library_binding = "analogLib";

 *)
c5161 ( \4:MR_SQUELCH_RANGE_1p0(1) , \4:SLICER_OUT_1p0  );
capacitor #(.c(2.75e-18)) (*
integer library_binding = "analogLib";

 *)
c5162 ( \4:MR_SQUELCH_RANGE_1p0(1) , \3:POS_DETECT_1p0  );
capacitor #(.c(1.962e-17)) (*
integer library_binding = "analogLib";

 *)
c5163 ( \4:MR_SQUELCH_RANGE_1p0(1) , \4:X_125  );
capacitor #(.c(2.746e-16)) (*
integer library_binding = "analogLib";

 *)
c5164 ( \4:MR_SQUELCH_RANGE_1p0(1) , \3:XTAL25_1p0  );
capacitor #(.c(8.319e-19)) (*
integer library_binding = "analogLib";

 *)
c5165 ( \4:MR_SQUELCH_RANGE_1p0(1) , SLICER_OUT_1p0 );
capacitor #(.c(5.52e-19)) (*
integer library_binding = "analogLib";

 *)
c5166 ( \4:MR_SQUELCH_RANGE_1p0(1) , X_125 );
capacitor #(.c(9.883e-19)) (*
integer library_binding = "analogLib";

 *)
c5167 ( \4:MR_SQUELCH_RANGE_1p0(1) , \MLT3_TDATA_1p0(0)  );
capacitor #(.c(6.444e-16)) (*
integer library_binding = "analogLib";

 *)
c5168 ( \4:MR_SQUELCH_RANGE_1p0(1) , XTAL25_1p0 );
capacitor #(.c(1.728e-17)) (*
integer library_binding = "analogLib";

 *)
c5169 ( \4:MR_SQUELCH_RANGE_1p0(1) , POS_DETECT_1p0 );
capacitor #(.c(1.959e-17)) (*
integer library_binding = "analogLib";

 *)
c5170 ( \4:MR_SQUELCH_RANGE_1p0(1) , \1:ADC_1p0(4)  );
capacitor #(.c(1.372e-17)) (*
integer library_binding = "analogLib";

 *)
c5171 ( \PHASE_IN(1) , \PHASE_IN(9)  );
capacitor #(.c(1.37e-17)) (*
integer library_binding = "analogLib";

 *)
c5172 ( \PHASE_IN(1) , \PHASE_IN(7)  );
capacitor #(.c(4.379e-15)) (*
integer library_binding = "analogLib";

 *)
c5173 ( \PHASE_IN(1) , \PHASE_IN(5)  );
capacitor #(.c(6.348e-18)) (*
integer library_binding = "analogLib";

 *)
c5174 ( \1:PHASE_IN(1) , TENBT_CLK160_1p0 );
capacitor #(.c(1.961e-17)) (*
integer library_binding = "analogLib";

 *)
c5175 ( \1:PHASE_IN(1) , \5:RESET_10BT  );
capacitor #(.c(5.036e-17)) (*
integer library_binding = "analogLib";

 *)
c5176 ( \1:PHASE_IN(1) , \6:TENBT_CLK160_1p0  );
capacitor #(.c(1.861e-16)) (*
integer library_binding = "analogLib";

 *)
c5177 ( \1:PHASE_IN(1) , RESET_10BT );
capacitor #(.c(1.984e-17)) (*
integer library_binding = "analogLib";

 *)
c5178 ( \1:PHASE_IN(1) , \3:PHASE_IN(7)  );
capacitor #(.c(1.686e-17)) (*
integer library_binding = "analogLib";

 *)
c5179 ( \1:PHASE_IN(1) , \2:PHASE_IN(9)  );
capacitor #(.c(4.521e-15)) (*
integer library_binding = "analogLib";

 *)
c5180 ( \1:PHASE_IN(1) , \1:PHASE_IN(5)  );
capacitor #(.c(1.783e-16)) (*
integer library_binding = "analogLib";

 *)
c5181 ( \1:PHASE_IN(1) , \PHASE_IN(5)  );
capacitor #(.c(1.341e-18)) (*
integer library_binding = "analogLib";

 *)
c5182 ( \2:PHASE_IN(1) , \WANDER_CNT(4)  );
capacitor #(.c(6.828e-19)) (*
integer library_binding = "analogLib";

 *)
c5183 ( \2:PHASE_IN(1) , \WANDER_CNT(2)  );
capacitor #(.c(1.385e-17)) (*
integer library_binding = "analogLib";

 *)
c5184 ( \2:PHASE_IN(1) , \5:WANDER_CNT(2)  );
capacitor #(.c(1.213e-17)) (*
integer library_binding = "analogLib";

 *)
c5185 ( \2:PHASE_IN(1) , \AEQ_CNT_ANLG(4)  );
capacitor #(.c(9.789e-17)) (*
integer library_binding = "analogLib";

 *)
c5186 ( \2:PHASE_IN(1) , \WANDER_CNT(0)  );
capacitor #(.c(7.478e-18)) (*
integer library_binding = "analogLib";

 *)
c5187 ( \2:PHASE_IN(1) , \4:WANDER_CNT(0)  );
capacitor #(.c(1.957e-18)) (*
integer library_binding = "analogLib";

 *)
c5188 ( \2:PHASE_IN(1) , \2:PHASE_IN(5)  );
capacitor #(.c(2.898e-18)) (*
integer library_binding = "analogLib";

 *)
c5189 ( \2:PHASE_IN(1) , \5:PHASE_IN(5)  );
capacitor #(.c(8.163e-17)) (*
integer library_binding = "analogLib";

 *)
c5190 ( \2:PHASE_IN(1) , \24:VDDTX  );
capacitor #(.c(4.286e-16)) (*
integer library_binding = "analogLib";

 *)
c5191 ( \2:PHASE_IN(1) , \25:VDDTX  );
capacitor #(.c(1.355e-17)) (*
integer library_binding = "analogLib";

 *)
c5192 ( \2:PHASE_IN(1) , \AEQ_CNT_ANLG(0)  );
capacitor #(.c(9.887e-19)) (*
integer library_binding = "analogLib";

 *)
c5193 ( \2:PHASE_IN(1) , \4:AEQ_CNT_ANLG(0)  );
capacitor #(.c(1.577e-17)) (*
integer library_binding = "analogLib";

 *)
c5194 ( \2:PHASE_IN(1) , \5:WANDER_CNT(4)  );
capacitor #(.c(2.111e-18)) (*
integer library_binding = "analogLib";

 *)
c5195 ( \2:PHASE_IN(1) , \4:PHASE_IN(9)  );
capacitor #(.c(3.58e-18)) (*
integer library_binding = "analogLib";

 *)
c5196 ( \2:PHASE_IN(1) , \7:PHASE_IN(9)  );
capacitor #(.c(1.129e-16)) (*
integer library_binding = "analogLib";

 *)
c5197 ( \2:PHASE_IN(1) , \5:AEQ_CNT_ANLG(4)  );
capacitor #(.c(2.411e-18)) (*
integer library_binding = "analogLib";

 *)
c5198 ( \5:PHASE_IN(1) , \2:PHASE_IN(5)  );
capacitor #(.c(3.571e-18)) (*
integer library_binding = "analogLib";

 *)
c5199 ( \5:PHASE_IN(1) , \5:PHASE_IN(5)  );
capacitor #(.c(1.049e-17)) (*
integer library_binding = "analogLib";

 *)
c5200 ( \5:PHASE_IN(1) , \24:VDDTX  );
capacitor #(.c(5.509e-17)) (*
integer library_binding = "analogLib";

 *)
c5201 ( \5:PHASE_IN(1) , \25:VDDTX  );
capacitor #(.c(2.601e-18)) (*
integer library_binding = "analogLib";

 *)
c5202 ( \5:PHASE_IN(1) , \4:PHASE_IN(9)  );
capacitor #(.c(4.411e-18)) (*
integer library_binding = "analogLib";

 *)
c5203 ( \5:PHASE_IN(1) , \7:PHASE_IN(9)  );
capacitor #(.c(1.864e-18)) (*
integer library_binding = "analogLib";

 *)
c5204 ( \5:PHASE_IN(1) , \5:PHASE_IN(7)  );
capacitor #(.c(9.065e-18)) (*
integer library_binding = "analogLib";

 *)
c5205 ( \5:PHASE_IN(1) , \7:PHASE_IN(7)  );
capacitor #(.c(1.276e-17)) (*
integer library_binding = "analogLib";

 *)
c5206 ( \4:I_RPOLY_100(3) , \7:I_REXT_50(0)  );
capacitor #(.c(1.508e-17)) (*
integer library_binding = "analogLib";

 *)
c5207 ( \4:I_RPOLY_100(3) , \3:ADC_1p0(4)  );
capacitor #(.c(9.272e-19)) (*
integer library_binding = "analogLib";

 *)
c5208 ( \WANDER_CNT(0) , \WANDER_CNT(4)  );
capacitor #(.c(4.095e-18)) (*
integer library_binding = "analogLib";

 *)
c5209 ( \WANDER_CNT(0) , \AEQ_CNT_ANLG(4)  );
capacitor #(.c(2.757e-17)) (*
integer library_binding = "analogLib";

 *)
c5210 ( \WANDER_CNT(0) , \9:TX100_DIS_2p5  );
capacitor #(.c(8.728e-16)) (*
integer library_binding = "analogLib";

 *)
c5211 ( \WANDER_CNT(0) , \2:TX100_DIS_2p5  );
capacitor #(.c(1.252e-17)) (*
integer library_binding = "analogLib";

 *)
c5212 ( \WANDER_CNT(0) , \2:I_REXT_50(0)  );
capacitor #(.c(3.712e-17)) (*
integer library_binding = "analogLib";

 *)
c5213 ( \WANDER_CNT(0) , \5:AEQ_CNT_ANLG(4)  );
capacitor #(.c(1.818e-16)) (*
integer library_binding = "analogLib";

 *)
c5214 ( \WANDER_CNT(0) , \8:TX100_DIS_2p5  );
capacitor #(.c(1.09e-17)) (*
integer library_binding = "analogLib";

 *)
c5215 ( \WANDER_CNT(0) , \5:WANDER_CNT(4)  );
capacitor #(.c(2.656e-18)) (*
integer library_binding = "analogLib";

 *)
c5216 ( \WANDER_CNT(0) , AEQ_DIS_2p5 );
capacitor #(.c(1.077e-19)) (*
integer library_binding = "analogLib";

 *)
c5217 ( \WANDER_CNT(0) , T2_MODE );
capacitor #(.c(1.44e-19)) (*
integer library_binding = "analogLib";

 *)
c5218 ( \WANDER_CNT(0) , \WANDER_CNT(2)  );
capacitor #(.c(1.395e-18)) (*
integer library_binding = "analogLib";

 *)
c5219 ( \WANDER_CNT(0) , \4:AEQ_CNT_ANLG(0)  );
capacitor #(.c(1.043e-17)) (*
integer library_binding = "analogLib";

 *)
c5220 ( \WANDER_CNT(0) , \6:AEQ_DIS_2p5  );
capacitor #(.c(2.463e-16)) (*
integer library_binding = "analogLib";

 *)
c5221 ( \WANDER_CNT(0) , \5:BLW_DIS_2p5  );
capacitor #(.c(8.994e-18)) (*
integer library_binding = "analogLib";

 *)
c5222 ( \WANDER_CNT(0) , \6:RX10_PRESENT_2p5  );
capacitor #(.c(1.739e-17)) (*
integer library_binding = "analogLib";

 *)
c5223 ( \WANDER_CNT(0) , \AEQ_CNT_ANLG(0)  );
capacitor #(.c(2.312e-18)) (*
integer library_binding = "analogLib";

 *)
c5224 ( \WANDER_CNT(0) , RX10_PRESENT_2p5 );
capacitor #(.c(5.522e-16)) (*
integer library_binding = "analogLib";

 *)
c5225 ( \WANDER_CNT(0) , \25:VDDTX  );
capacitor #(.c(1.052e-16)) (*
integer library_binding = "analogLib";

 *)
c5226 ( \WANDER_CNT(0) , \24:VDDTX  );
capacitor #(.c(2.678e-16)) (*
integer library_binding = "analogLib";

 *)
c5227 ( \WANDER_CNT(0) , BLW_DIS_2p5 );
capacitor #(.c(7.084e-20)) (*
integer library_binding = "analogLib";

 *)
c5228 ( \4:WANDER_CNT(0) , \WANDER_CNT(4)  );
capacitor #(.c(1.234e-17)) (*
integer library_binding = "analogLib";

 *)
c5229 ( \4:WANDER_CNT(0) , \AEQ_CNT_ANLG(4)  );
capacitor #(.c(2.106e-18)) (*
integer library_binding = "analogLib";

 *)
c5230 ( \4:WANDER_CNT(0) , \9:TX100_DIS_2p5  );
capacitor #(.c(9.564e-19)) (*
integer library_binding = "analogLib";

 *)
c5231 ( \4:WANDER_CNT(0) , \2:I_REXT_50(0)  );
capacitor #(.c(3.037e-18)) (*
integer library_binding = "analogLib";

 *)
c5232 ( \4:WANDER_CNT(0) , \5:AEQ_CNT_ANLG(4)  );
capacitor #(.c(8.331e-19)) (*
integer library_binding = "analogLib";

 *)
c5233 ( \4:WANDER_CNT(0) , \5:WANDER_CNT(4)  );
capacitor #(.c(7.969e-19)) (*
integer library_binding = "analogLib";

 *)
c5234 ( \4:WANDER_CNT(0) , \6:AEQ_DIS_2p5  );
capacitor #(.c(1.328e-18)) (*
integer library_binding = "analogLib";

 *)
c5235 ( \4:WANDER_CNT(0) , \AEQ_CNT_ANLG(0)  );
capacitor #(.c(4.219e-17)) (*
integer library_binding = "analogLib";

 *)
c5236 ( \4:WANDER_CNT(0) , \25:VDDTX  );
capacitor #(.c(8.035e-18)) (*
integer library_binding = "analogLib";

 *)
c5237 ( \4:WANDER_CNT(0) , \24:VDDTX  );
capacitor #(.c(2.449e-17)) (*
integer library_binding = "analogLib";

 *)
c5238 ( \4:WANDER_CNT(0) , BLW_DIS_2p5 );
capacitor #(.c(9.904e-19)) (*
integer library_binding = "analogLib";

 *)
c5239 ( \4:WANDER_CNT(0) , \6:RX10_PRESENT_2p5  );
capacitor #(.c(1.38e-17)) (*
integer library_binding = "analogLib";

 *)
c5240 ( \4:WANDER_CNT(0) , RX10_PRESENT_2p5 );
capacitor #(.c(3.056e-16)) (*
integer library_binding = "analogLib";

 *)
c5241 ( \4:WANDER_CNT(0) , \5:BLW_DIS_2p5  );
capacitor #(.c(1.403e-17)) (*
integer library_binding = "analogLib";

 *)
c5242 ( \4:WANDER_CNT(0) , \4:AEQ_CNT_ANLG(0)  );
capacitor #(.c(1.596e-17)) (*
integer library_binding = "analogLib";

 *)
c5243 ( \4:WANDER_CNT(0) , \WANDER_CNT(2)  );
capacitor #(.c(1.465e-17)) (*
integer library_binding = "analogLib";

 *)
c5244 ( \4:WANDER_CNT(0) , AEQ_DIS_2p5 );
capacitor #(.c(7.451e-17)) (*
integer library_binding = "analogLib";

 *)
c5245 ( \4:WANDER_CNT(0) , \2:TX100_DIS_2p5  );
capacitor #(.c(4.685e-16)) (*
integer library_binding = "analogLib";

 *)
c5246 ( \4:WANDER_CNT(0) , \8:TX100_DIS_2p5  );
capacitor #(.c(1.194e-17)) (*
integer library_binding = "analogLib";

 *)
c5247 ( \4:WANDER_CNT(0) , T2_MODE );
capacitor #(.c(2.72e-19)) (*
integer library_binding = "analogLib";

 *)
c5248 ( \4:WANDER_CNT(0) , \6:T2_MODE  );
capacitor #(.c(8.353e-18)) (*
integer library_binding = "analogLib";

 *)
c5249 ( \PHASE_250(1) , MR_SQUELCH_DISB_2p5 );
capacitor #(.c(8.353e-18)) (*
integer library_binding = "analogLib";

 *)
c5250 ( \PHASE_250(1) , BLW_DIS_2p5 );
capacitor #(.c(7.017e-18)) (*
integer library_binding = "analogLib";

 *)
c5251 ( \PHASE_250(1) , \2:I_REXT_50(0)  );
capacitor #(.c(1.627e-17)) (*
integer library_binding = "analogLib";

 *)
c5252 ( \PHASE_250(1) , \6:AEQ_DIS_2p5  );
capacitor #(.c(1.44e-17)) (*
integer library_binding = "analogLib";

 *)
c5253 ( \PHASE_250(1) , \6:RX10_PRESENT_2p5  );
capacitor #(.c(6.399e-18)) (*
integer library_binding = "analogLib";

 *)
c5254 ( \PHASE_250(1) , \3:PHASE_250(9)  );
capacitor #(.c(4.36e-19)) (*
integer library_binding = "analogLib";

 *)
c5255 ( \PHASE_250(1) , AEQ_DIS_2p5 );
capacitor #(.c(1.395e-16)) (*
integer library_binding = "analogLib";

 *)
c5256 ( \PHASE_250(1) , ADC_DIS_2p5 );
capacitor #(.c(5.289e-19)) (*
integer library_binding = "analogLib";

 *)
c5257 ( \PHASE_250(1) , RX10_PRESENT_2p5 );
capacitor #(.c(3.687e-18)) (*
integer library_binding = "analogLib";

 *)
c5258 ( \PHASE_250(1) , \5:ADC_DIS_2p5  );
capacitor #(.c(1.906e-17)) (*
integer library_binding = "analogLib";

 *)
c5259 ( \PHASE_250(1) , \2:TX100_DIS_2p5  );
capacitor #(.c(2.163e-17)) (*
integer library_binding = "analogLib";

 *)
c5260 ( \PHASE_250(1) , \PHASE_250(9)  );
capacitor #(.c(2.447e-16)) (*
integer library_binding = "analogLib";

 *)
c5261 ( \PHASE_250(1) , \9:TX100_DIS_2p5  );
capacitor #(.c(1.682e-18)) (*
integer library_binding = "analogLib";

 *)
c5262 ( \3:PHASE_250(1) , \3:MR_SQUELCH_DISB_2p5  );
capacitor #(.c(1.113e-17)) (*
integer library_binding = "analogLib";

 *)
c5263 ( \3:PHASE_250(1) , \2:I_REXT_50(0)  );
capacitor #(.c(2.581e-17)) (*
integer library_binding = "analogLib";

 *)
c5264 ( \3:PHASE_250(1) , \6:AEQ_DIS_2p5  );
capacitor #(.c(2.285e-17)) (*
integer library_binding = "analogLib";

 *)
c5265 ( \3:PHASE_250(1) , \6:RX10_PRESENT_2p5  );
capacitor #(.c(1.015e-17)) (*
integer library_binding = "analogLib";

 *)
c5266 ( \3:PHASE_250(1) , \3:PHASE_250(9)  );
capacitor #(.c(6.918e-19)) (*
integer library_binding = "analogLib";

 *)
c5267 ( \3:PHASE_250(1) , AEQ_DIS_2p5 );
capacitor #(.c(2.213e-16)) (*
integer library_binding = "analogLib";

 *)
c5268 ( \3:PHASE_250(1) , ADC_DIS_2p5 );
capacitor #(.c(8.391e-19)) (*
integer library_binding = "analogLib";

 *)
c5269 ( \3:PHASE_250(1) , RX10_PRESENT_2p5 );
capacitor #(.c(5.489e-17)) (*
integer library_binding = "analogLib";

 *)
c5270 ( \3:PHASE_250(1) , \9:TX100_DIS_2p5  );
capacitor #(.c(5.849e-18)) (*
integer library_binding = "analogLib";

 *)
c5271 ( \3:PHASE_250(1) , \5:ADC_DIS_2p5  );
capacitor #(.c(5.035e-18)) (*
integer library_binding = "analogLib";

 *)
c5272 ( \3:PHASE_250(1) , \PHASE_250(9)  );
capacitor #(.c(1.803e-17)) (*
integer library_binding = "analogLib";

 *)
c5273 ( \3:PHASE_250(1) , \2:TX100_DIS_2p5  );
capacitor #(.c(2.647e-17)) (*
integer library_binding = "analogLib";

 *)
c5274 ( \3:PHASE_250(1) , BLW_DIS_2p5 );
capacitor #(.c(1.709e-18)) (*
integer library_binding = "analogLib";

 *)
c5275 ( \3:PHASE_250(1) , \5:BLW_DIS_2p5  );
capacitor #(.c(2.672e-17)) (*
integer library_binding = "analogLib";

 *)
c5276 ( \3:PHASE_250(1) , MR_SQUELCH_DISB_2p5 );
capacitor #(.c(1.547e-15)) (*
integer library_binding = "analogLib";

 *)
c5277 ( \I_REXT_100(2) , \I_REXT_100(3)  );
capacitor #(.c(4.964e-16)) (*
integer library_binding = "analogLib";

 *)
c5278 ( \I_REXT_100(2) , \2:I_REXT_100(3)  );
capacitor #(.c(4.404e-16)) (*
integer library_binding = "analogLib";

 *)
c5279 ( \2:I_REXT_100(2) , \I_REXT_100(3)  );
capacitor #(.c(1.607e-14)) (*
integer library_binding = "analogLib";

 *)
c5280 ( \2:I_REXT_100(2) , \2:I_REXT_100(3)  );
capacitor #(.c(1.276e-17)) (*
integer library_binding = "analogLib";

 *)
c5281 ( \4:I_REXT_100(2) , \7:I_REXT_50(0)  );
capacitor #(.c(1.508e-17)) (*
integer library_binding = "analogLib";

 *)
c5282 ( \4:I_REXT_100(2) , \3:ADC_1p0(4)  );
capacitor #(.c(6.421e-17)) (*
integer library_binding = "analogLib";

 *)
c5283 ( \4:I_REXT_100(2) , \2:I_REXT_100(3)  );
capacitor #(.c(1.278e-14)) (*
integer library_binding = "analogLib";

 *)
c5284 ( \4:I_REXT_100(2) , \4:I_REXT_100(3)  );
capacitor #(.c(1.688e-18)) (*
integer library_binding = "analogLib";

 *)
c5285 ( \9:TX100_DIS_2p5 , \PHASE_250(2)  );
capacitor #(.c(1.228e-18)) (*
integer library_binding = "analogLib";

 *)
c5286 ( \9:TX100_DIS_2p5 , \4:PHASE_250(2)  );
capacitor #(.c(1.553e-18)) (*
integer library_binding = "analogLib";

 *)
c5287 ( \9:TX100_DIS_2p5 , \4:PHASE_250(8)  );
capacitor #(.c(1.363e-18)) (*
integer library_binding = "analogLib";

 *)
c5288 ( \9:TX100_DIS_2p5 , \PHASE_250(8)  );
capacitor #(.c(6.471e-20)) (*
integer library_binding = "analogLib";

 *)
c5289 ( \9:TX100_DIS_2p5 , \3:TP_DISC_2p5  );
capacitor #(.c(5.079e-18)) (*
integer library_binding = "analogLib";

 *)
c5290 ( \9:TX100_DIS_2p5 , TP_DISC_2p5 );
capacitor #(.c(6.495e-18)) (*
integer library_binding = "analogLib";

 *)
c5291 ( \9:TX100_DIS_2p5 , \6:AEQ_DIS_2p5  );
capacitor #(.c(2.578e-18)) (*
integer library_binding = "analogLib";

 *)
c5292 ( \9:TX100_DIS_2p5 , TIMING_UP_ANLG );
capacitor #(.c(2.916e-18)) (*
integer library_binding = "analogLib";

 *)
c5293 ( \9:TX100_DIS_2p5 , BLW_DIS_2p5 );
capacitor #(.c(4.446e-18)) (*
integer library_binding = "analogLib";

 *)
c5294 ( \9:TX100_DIS_2p5 , \2:I_REXT_50(0)  );
capacitor #(.c(6.388e-18)) (*
integer library_binding = "analogLib";

 *)
c5295 ( \9:TX100_DIS_2p5 , \6:RX10_PRESENT_2p5  );
capacitor #(.c(8.666e-19)) (*
integer library_binding = "analogLib";

 *)
c5296 ( \9:TX100_DIS_2p5 , AEQ_DIS_2p5 );
capacitor #(.c(5.318e-18)) (*
integer library_binding = "analogLib";

 *)
c5297 ( \9:TX100_DIS_2p5 , \PHASE_250(4)  );
capacitor #(.c(4.454e-18)) (*
integer library_binding = "analogLib";

 *)
c5298 ( \9:TX100_DIS_2p5 , \4:PHASE_250(4)  );
capacitor #(.c(1.392e-18)) (*
integer library_binding = "analogLib";

 *)
c5299 ( \9:TX100_DIS_2p5 , \PHASE_250(10)  );
capacitor #(.c(1.524e-18)) (*
integer library_binding = "analogLib";

 *)
c5300 ( \9:TX100_DIS_2p5 , \4:PHASE_250(10)  );
capacitor #(.c(6.497e-17)) (*
integer library_binding = "analogLib";

 *)
c5301 ( \9:TX100_DIS_2p5 , ADC_DIS_2p5 );
capacitor #(.c(3.95e-18)) (*
integer library_binding = "analogLib";

 *)
c5302 ( \9:TX100_DIS_2p5 , \4:PHASE_250(6)  );
capacitor #(.c(4.393e-18)) (*
integer library_binding = "analogLib";

 *)
c5303 ( \9:TX100_DIS_2p5 , \PHASE_250(6)  );
capacitor #(.c(9.738e-19)) (*
integer library_binding = "analogLib";

 *)
c5304 ( \9:TX100_DIS_2p5 , RX10_PRESENT_2p5 );
capacitor #(.c(7.754e-18)) (*
integer library_binding = "analogLib";

 *)
c5305 ( \9:TX100_DIS_2p5 , \5:ADC_DIS_2p5  );
capacitor #(.c(1.367e-17)) (*
integer library_binding = "analogLib";

 *)
c5306 ( \9:TX100_DIS_2p5 , MR_SQUELCH_DISB_2p5 );
capacitor #(.c(1.679e-17)) (*
integer library_binding = "analogLib";

 *)
c5307 ( \9:TX100_DIS_2p5 , \PHASE_250(9)  );
capacitor #(.c(4.631e-16)) (*
integer library_binding = "analogLib";

 *)
c5308 ( \9:TX100_DIS_2p5 , \4:RCLK125_TST  );
capacitor #(.c(1.235e-16)) (*
integer library_binding = "analogLib";

 *)
c5309 ( \9:TX100_DIS_2p5 , RCLK125_TST );
capacitor #(.c(6.514e-18)) (*
integer library_binding = "analogLib";

 *)
c5310 ( \2:TX100_DIS_2p5 , \PHASE_250(2)  );
capacitor #(.c(4.74e-18)) (*
integer library_binding = "analogLib";

 *)
c5311 ( \2:TX100_DIS_2p5 , \4:PHASE_250(2)  );
capacitor #(.c(5.994e-18)) (*
integer library_binding = "analogLib";

 *)
c5312 ( \2:TX100_DIS_2p5 , \4:PHASE_250(8)  );
capacitor #(.c(5.26e-18)) (*
integer library_binding = "analogLib";

 *)
c5313 ( \2:TX100_DIS_2p5 , \PHASE_250(8)  );
capacitor #(.c(2.815e-19)) (*
integer library_binding = "analogLib";

 *)
c5314 ( \2:TX100_DIS_2p5 , \AEQ_CNT_ANLG(4)  );
capacitor #(.c(2.498e-19)) (*
integer library_binding = "analogLib";

 *)
c5315 ( \2:TX100_DIS_2p5 , \3:TP_DISC_2p5  );
capacitor #(.c(1.961e-17)) (*
integer library_binding = "analogLib";

 *)
c5316 ( \2:TX100_DIS_2p5 , TP_DISC_2p5 );
capacitor #(.c(2.507e-17)) (*
integer library_binding = "analogLib";

 *)
c5317 ( \2:TX100_DIS_2p5 , \6:AEQ_DIS_2p5  );
capacitor #(.c(9.949e-18)) (*
integer library_binding = "analogLib";

 *)
c5318 ( \2:TX100_DIS_2p5 , TIMING_UP_ANLG );
capacitor #(.c(1.716e-17)) (*
integer library_binding = "analogLib";

 *)
c5319 ( \2:TX100_DIS_2p5 , \2:I_REXT_50(0)  );
capacitor #(.c(4.435e-16)) (*
integer library_binding = "analogLib";

 *)
c5320 ( \2:TX100_DIS_2p5 , \4:RCLK125_TST  );
capacitor #(.c(3.345e-18)) (*
integer library_binding = "analogLib";

 *)
c5321 ( \2:TX100_DIS_2p5 , AEQ_DIS_2p5 );
capacitor #(.c(2.053e-17)) (*
integer library_binding = "analogLib";

 *)
c5322 ( \2:TX100_DIS_2p5 , \PHASE_250(4)  );
capacitor #(.c(1.719e-17)) (*
integer library_binding = "analogLib";

 *)
c5323 ( \2:TX100_DIS_2p5 , \4:PHASE_250(4)  );
capacitor #(.c(5.373e-18)) (*
integer library_binding = "analogLib";

 *)
c5324 ( \2:TX100_DIS_2p5 , \PHASE_250(10)  );
capacitor #(.c(5.881e-18)) (*
integer library_binding = "analogLib";

 *)
c5325 ( \2:TX100_DIS_2p5 , \4:PHASE_250(10)  );
capacitor #(.c(3.84e-16)) (*
integer library_binding = "analogLib";

 *)
c5326 ( \2:TX100_DIS_2p5 , RCLK125_TST );
capacitor #(.c(1.524e-17)) (*
integer library_binding = "analogLib";

 *)
c5327 ( \2:TX100_DIS_2p5 , \4:PHASE_250(6)  );
capacitor #(.c(1.696e-17)) (*
integer library_binding = "analogLib";

 *)
c5328 ( \2:TX100_DIS_2p5 , \PHASE_250(6)  );
capacitor #(.c(6.153e-19)) (*
integer library_binding = "analogLib";

 *)
c5329 ( \2:TX100_DIS_2p5 , \PHASE_250(9)  );
capacitor #(.c(5.008e-19)) (*
integer library_binding = "analogLib";

 *)
c5330 ( \2:TX100_DIS_2p5 , MR_SQUELCH_DISB_2p5 );
capacitor #(.c(1.179e-16)) (*
integer library_binding = "analogLib";

 *)
c5331 ( \2:TX100_DIS_2p5 , \5:ADC_DIS_2p5  );
capacitor #(.c(3.228e-17)) (*
integer library_binding = "analogLib";

 *)
c5332 ( \2:TX100_DIS_2p5 , BLW_DIS_2p5 );
capacitor #(.c(2.466e-17)) (*
integer library_binding = "analogLib";

 *)
c5333 ( \2:TX100_DIS_2p5 , \6:RX10_PRESENT_2p5  );
capacitor #(.c(4.08e-18)) (*
integer library_binding = "analogLib";

 *)
c5334 ( \2:TX100_DIS_2p5 , RX10_PRESENT_2p5 );
capacitor #(.c(5.092e-16)) (*
integer library_binding = "analogLib";

 *)
c5335 ( \2:TX100_DIS_2p5 , ADC_DIS_2p5 );
capacitor #(.c(1e-17)) (*
integer library_binding = "analogLib";
 *)

c5336 ( \2:TX100_DIS_2p5 , \5:BLW_DIS_2p5  );
capacitor #(.c(3.289e-19)) (*
integer library_binding = "analogLib";

 *)
c5337 ( \2:TX100_DIS_2p5 , \4:AEQ_CNT_ANLG(0)  );
capacitor #(.c(2.862e-19)) (*
integer library_binding = "analogLib";

 *)
c5338 ( \2:TX100_DIS_2p5 , T2_MODE );
capacitor #(.c(6.195e-20)) (*
integer library_binding = "analogLib";

 *)
c5339 ( \8:TX100_DIS_2p5 , \5:WANDER_CNT(4)  );
capacitor #(.c(1.883e-17)) (*
integer library_binding = "analogLib";

 *)
c5340 ( \8:TX100_DIS_2p5 , \WANDER_CNT(4)  );
capacitor #(.c(2.739e-19)) (*
integer library_binding = "analogLib";

 *)
c5341 ( \8:TX100_DIS_2p5 , \5:AEQ_CNT_ANLG(4)  );
capacitor #(.c(1.632e-17)) (*
integer library_binding = "analogLib";

 *)
c5342 ( \8:TX100_DIS_2p5 , \AEQ_CNT_ANLG(4)  );
capacitor #(.c(2.551e-16)) (*
integer library_binding = "analogLib";

 *)
c5343 ( \8:TX100_DIS_2p5 , \5:ADC_DIS_2p5  );
capacitor #(.c(2.548e-18)) (*
integer library_binding = "analogLib";

 *)
c5344 ( \8:TX100_DIS_2p5 , ADC_DIS_2p5 );
capacitor #(.c(4.156e-19)) (*
integer library_binding = "analogLib";

 *)
c5345 ( \8:TX100_DIS_2p5 , \6:RX10_PRESENT_2p5  );
capacitor #(.c(1.866e-17)) (*
integer library_binding = "analogLib";

 *)
c5346 ( \8:TX100_DIS_2p5 , RX10_PRESENT_2p5 );
capacitor #(.c(1.908e-17)) (*
integer library_binding = "analogLib";

 *)
c5347 ( \8:TX100_DIS_2p5 , \4:AEQ_CNT_ANLG(0)  );
capacitor #(.c(1.66e-17)) (*
integer library_binding = "analogLib";

 *)
c5348 ( \8:TX100_DIS_2p5 , T2_MODE );
capacitor #(.c(8.976e-20)) (*
integer library_binding = "analogLib";

 *)
c5349 ( TIMING_UP_ANLG, \MLT3_TDATA_2p5(1)  );
capacitor #(.c(4.818e-18)) (*
integer library_binding = "analogLib";

 *)
c5350 ( TIMING_UP_ANLG, \3:MR_SQUELCH_DISB_2p5  );
capacitor #(.c(8.686e-18)) (*
integer library_binding = "analogLib";

 *)
c5351 ( TIMING_UP_ANLG, MR_SQUELCH_DISB_2p5 );
capacitor #(.c(8.28e-18)) (*
integer library_binding = "analogLib";

 *)
c5352 ( TIMING_UP_ANLG, TIMING_DN_ANLG );
capacitor #(.c(2.802e-18)) (*
integer library_binding = "analogLib";

 *)
c5353 ( TIMING_UP_ANLG, \5:ADC_DIS_2p5  );
capacitor #(.c(8.999e-18)) (*
integer library_binding = "analogLib";

 *)
c5354 ( TIMING_UP_ANLG, BLW_DIS_2p5 );
capacitor #(.c(3.964e-18)) (*
integer library_binding = "analogLib";

 *)
c5355 ( TIMING_UP_ANLG, RX10_PRESENT_2p5 );
capacitor #(.c(1.678e-17)) (*
integer library_binding = "analogLib";

 *)
c5356 ( TIMING_UP_ANLG, ADC_DIS_2p5 );
capacitor #(.c(1.628e-17)) (*
integer library_binding = "analogLib";

 *)
c5357 ( TIMING_UP_ANLG, \6:RX10_PRESENT_2p5  );
capacitor #(.c(4.279e-18)) (*
integer library_binding = "analogLib";

 *)
c5358 ( TIMING_UP_ANLG, \5:BLW_DIS_2p5  );
capacitor #(.c(1.057e-18)) (*
integer library_binding = "analogLib";

 *)
c5359 ( TIMING_UP_ANLG, AEQ_DIS_2p5 );
capacitor #(.c(1.919e-17)) (*
integer library_binding = "analogLib";

 *)
c5360 ( TIMING_UP_ANLG, \6:AEQ_DIS_2p5  );
capacitor #(.c(4.188e-17)) (*
integer library_binding = "analogLib";

 *)
c5361 ( TIMING_UP_ANLG, \25:VDDTX  );
capacitor #(.c(1.254e-16)) (*
integer library_binding = "analogLib";

 *)
c5362 ( TIMING_UP_ANLG, \7:PHASE_IN(7)  );
capacitor #(.c(1.053e-17)) (*
integer library_binding = "analogLib";

 *)
c5363 ( TIMING_UP_ANLG, \4:MLT3_TDATA_2p5(1)  );
capacitor #(.c(2.024e-17)) (*
integer library_binding = "analogLib";

 *)
c5364 ( TIMING_UP_ANLG, \2:I_REXT_50(0)  );
capacitor #(.c(4.441e-16)) (*
integer library_binding = "analogLib";

 *)
c5365 ( TIMING_UP_ANLG, \5:PHASE_IN(7)  );
capacitor #(.c(7.972e-16)) (*
integer library_binding = "analogLib";

 *)
c5366 ( TIMING_UP_ANLG, \5:TIMING_DN_ANLG  );
capacitor #(.c(1.333e-17)) (*
integer library_binding = "analogLib";

 *)
c5367 ( \6:TIMING_UP_ANLG , TIMING_DN_ANLG );
capacitor #(.c(8.204e-18)) (*
integer library_binding = "analogLib";

 *)
c5368 ( \6:TIMING_UP_ANLG , \5:TIMING_DN_ANLG  );
capacitor #(.c(6.362e-16)) (*
integer library_binding = "analogLib";

 *)
c5369 ( \6:TIMING_UP_ANLG , \5:PHASE_IN(7)  );
capacitor #(.c(6.741e-17)) (*
integer library_binding = "analogLib";

 *)
c5370 ( \6:TIMING_UP_ANLG , \25:VDDTX  );
capacitor #(.c(2.018e-16)) (*
integer library_binding = "analogLib";

 *)
c5371 ( \6:TIMING_UP_ANLG , \7:PHASE_IN(7)  );
capacitor #(.c(5.432e-18)) (*
integer library_binding = "analogLib";

 *)
c5372 ( BLW_DIS_2p5, \4:PHASE_250(2)  );
capacitor #(.c(9.393e-18)) (*
integer library_binding = "analogLib";

 *)
c5373 ( BLW_DIS_2p5, \4:PHASE_250(8)  );
capacitor #(.c(1.449e-17)) (*
integer library_binding = "analogLib";

 *)
c5374 ( BLW_DIS_2p5, \PHASE_250(9)  );
capacitor #(.c(2.791e-16)) (*
integer library_binding = "analogLib";

 *)
c5375 ( BLW_DIS_2p5, \AEQ_CNT_ANLG(4)  );
capacitor #(.c(6.115e-18)) (*
integer library_binding = "analogLib";

 *)
c5376 ( BLW_DIS_2p5, \3:MR_SQUELCH_DISB_2p5  );
capacitor #(.c(1.977e-19)) (*
integer library_binding = "analogLib";

 *)
c5377 ( BLW_DIS_2p5, \5:ADC_DIS_2p5  );
capacitor #(.c(2.146e-17)) (*
integer library_binding = "analogLib";

 *)
c5378 ( BLW_DIS_2p5, \PHASE_250(8)  );
capacitor #(.c(2.068e-17)) (*
integer library_binding = "analogLib";

 *)
c5379 ( BLW_DIS_2p5, \PHASE_250(2)  );
capacitor #(.c(1.785e-17)) (*
integer library_binding = "analogLib";

 *)
c5380 ( BLW_DIS_2p5, \3:PHASE_250(9)  );
capacitor #(.c(5.364e-16)) (*
integer library_binding = "analogLib";

 *)
c5381 ( BLW_DIS_2p5, \5:AEQ_CNT_ANLG(4)  );
capacitor #(.c(7.285e-18)) (*
integer library_binding = "analogLib";

 *)
c5382 ( BLW_DIS_2p5, \5:TIMING_DN_ANLG  );
capacitor #(.c(2.171e-19)) (*
integer library_binding = "analogLib";

 *)
c5383 ( BLW_DIS_2p5, T2_MODE );
capacitor #(.c(2.776e-19)) (*
integer library_binding = "analogLib";

 *)
c5384 ( BLW_DIS_2p5, \4:AEQ_CNT_ANLG(0)  );
capacitor #(.c(2.399e-17)) (*
integer library_binding = "analogLib";

 *)
c5385 ( BLW_DIS_2p5, MR_SQUELCH_DISB_2p5 );
capacitor #(.c(7.364e-19)) (*
integer library_binding = "analogLib";

 *)
c5386 ( BLW_DIS_2p5, RX10_PRESENT_2p5 );
capacitor #(.c(1.813e-17)) (*
integer library_binding = "analogLib";

 *)
c5387 ( BLW_DIS_2p5, \PHASE_250(6)  );
capacitor #(.c(6.081e-18)) (*
integer library_binding = "analogLib";

 *)
c5388 ( BLW_DIS_2p5, \4:PHASE_250(6)  );
capacitor #(.c(9.608e-18)) (*
integer library_binding = "analogLib";

 *)
c5389 ( BLW_DIS_2p5, RCLK125_TST );
capacitor #(.c(1.413e-17)) (*
integer library_binding = "analogLib";

 *)
c5390 ( BLW_DIS_2p5, \PHASE_250(10)  );
capacitor #(.c(5.854e-18)) (*
integer library_binding = "analogLib";

 *)
c5391 ( BLW_DIS_2p5, \4:PHASE_250(4)  );
capacitor #(.c(2.02e-17)) (*
integer library_binding = "analogLib";

 *)
c5392 ( BLW_DIS_2p5, \PHASE_250(4)  );
capacitor #(.c(1.362e-17)) (*
integer library_binding = "analogLib";

 *)
c5393 ( BLW_DIS_2p5, \6:RX10_PRESENT_2p5  );
capacitor #(.c(1.465e-17)) (*
integer library_binding = "analogLib";

 *)
c5394 ( BLW_DIS_2p5, \4:RCLK125_TST  );
capacitor #(.c(1.334e-17)) (*
integer library_binding = "analogLib";

 *)
c5395 ( BLW_DIS_2p5, \4:PHASE_250(10)  );
capacitor #(.c(1.815e-17)) (*
integer library_binding = "analogLib";

 *)
c5396 ( BLW_DIS_2p5, \2:I_REXT_50(0)  );
capacitor #(.c(6.668e-20)) (*
integer library_binding = "analogLib";

 *)
c5397 ( \5:BLW_DIS_2p5 , \5:WANDER_CNT(4)  );
capacitor #(.c(2.026e-17)) (*
integer library_binding = "analogLib";

 *)
c5398 ( \5:BLW_DIS_2p5 , \WANDER_CNT(4)  );
capacitor #(.c(1.875e-18)) (*
integer library_binding = "analogLib";

 *)
c5399 ( \5:BLW_DIS_2p5 , \PHASE_250(9)  );
capacitor #(.c(1.196e-15)) (*
integer library_binding = "analogLib";

 *)
c5400 ( \5:BLW_DIS_2p5 , \AEQ_CNT_ANLG(4)  );
capacitor #(.c(2.184e-18)) (*
integer library_binding = "analogLib";

 *)
c5401 ( \5:BLW_DIS_2p5 , \3:MR_SQUELCH_DISB_2p5  );
capacitor #(.c(1.404e-17)) (*
integer library_binding = "analogLib";

 *)
c5402 ( \5:BLW_DIS_2p5 , \5:ADC_DIS_2p5  );
capacitor #(.c(1.402e-19)) (*
integer library_binding = "analogLib";

 *)
c5403 ( \5:BLW_DIS_2p5 , ADC_DIS_2p5 );
capacitor #(.c(1.709e-18)) (*
integer library_binding = "analogLib";

 *)
c5404 ( \5:BLW_DIS_2p5 , \PHASE_250(10)  );
capacitor #(.c(1.709e-18)) (*
integer library_binding = "analogLib";

 *)
c5405 ( \5:BLW_DIS_2p5 , \PHASE_250(8)  );
capacitor #(.c(1.709e-18)) (*
integer library_binding = "analogLib";

 *)
c5406 ( \5:BLW_DIS_2p5 , \PHASE_250(2)  );
capacitor #(.c(2.309e-18)) (*
integer library_binding = "analogLib";

 *)
c5407 ( \5:BLW_DIS_2p5 , \3:PHASE_250(9)  );
capacitor #(.c(1.709e-18)) (*
integer library_binding = "analogLib";

 *)
c5408 ( \5:BLW_DIS_2p5 , \PHASE_250(4)  );
capacitor #(.c(1.471e-18)) (*
integer library_binding = "analogLib";

 *)
c5409 ( \5:BLW_DIS_2p5 , \PHASE_250(6)  );
capacitor #(.c(5.616e-18)) (*
integer library_binding = "analogLib";

 *)
c5410 ( \5:BLW_DIS_2p5 , MR_SQUELCH_DISB_2p5 );
capacitor #(.c(3.741e-19)) (*
integer library_binding = "analogLib";

 *)
c5411 ( \5:BLW_DIS_2p5 , \6:RX10_PRESENT_2p5  );
capacitor #(.c(1.68e-17)) (*
integer library_binding = "analogLib";

 *)
c5412 ( \5:BLW_DIS_2p5 , RX10_PRESENT_2p5 );
capacitor #(.c(1.971e-17)) (*
integer library_binding = "analogLib";

 *)
c5413 ( \5:BLW_DIS_2p5 , \4:AEQ_CNT_ANLG(0)  );
capacitor #(.c(2.729e-16)) (*
integer library_binding = "analogLib";

 *)
c5414 ( \5:BLW_DIS_2p5 , \5:AEQ_CNT_ANLG(4)  );
capacitor #(.c(3.464e-18)) (*
integer library_binding = "analogLib";

 *)
c5415 ( \5:BLW_DIS_2p5 , \5:TIMING_DN_ANLG  );
capacitor #(.c(4.088e-18)) (*
integer library_binding = "analogLib";

 *)
c5416 ( \5:BLW_DIS_2p5 , RCLK125_TST );
capacitor #(.c(1.541e-17)) (*
integer library_binding = "analogLib";

 *)
c5417 ( \5:BLW_DIS_2p5 , T2_MODE );
capacitor #(.c(3.513e-19)) (*
integer library_binding = "analogLib";

 *)
c5418 ( \5:BLW_DIS_2p5 , \6:T2_MODE  );
capacitor #(.c(1.051e-17)) (*
integer library_binding = "analogLib";

 *)
c5419 ( \PHASE_250(2) , \2:I_REXT_50(0)  );
capacitor #(.c(1.7e-17)) (*
integer library_binding = "analogLib";

 *)
c5420 ( \PHASE_250(2) , \6:RX10_PRESENT_2p5  );
capacitor #(.c(1.897e-17)) (*
integer library_binding = "analogLib";

 *)
c5421 ( \PHASE_250(2) , ADC_DIS_2p5 );
capacitor #(.c(1.932e-17)) (*
integer library_binding = "analogLib";

 *)
c5422 ( \PHASE_250(2) , \6:AEQ_DIS_2p5  );
capacitor #(.c(4.54e-17)) (*
integer library_binding = "analogLib";

 *)
c5423 ( \PHASE_250(2) , \4:MLT3_TDATA_2p5(1)  );
capacitor #(.c(6.744e-16)) (*
integer library_binding = "analogLib";

 *)
c5424 ( \PHASE_250(2) , \4:PHASE_250(4)  );
capacitor #(.c(9.58e-18)) (*
integer library_binding = "analogLib";

 *)
c5425 ( \PHASE_250(2) , \3:PHASE_250(9)  );
capacitor #(.c(5.366e-16)) (*
integer library_binding = "analogLib";

 *)
c5426 ( \PHASE_250(2) , \PHASE_250(4)  );
capacitor #(.c(3.874e-18)) (*
integer library_binding = "analogLib";

 *)
c5427 ( \PHASE_250(2) , \PHASE_250(10)  );
capacitor #(.c(4.826e-18)) (*
integer library_binding = "analogLib";

 *)
c5428 ( \PHASE_250(2) , \4:PHASE_250(10)  );
capacitor #(.c(5.034e-18)) (*
integer library_binding = "analogLib";

 *)
c5429 ( \PHASE_250(2) , RCLK125_TST );
capacitor #(.c(3.25e-18)) (*
integer library_binding = "analogLib";

 *)
c5430 ( \PHASE_250(2) , \4:RCLK125_TST  );
capacitor #(.c(6.528e-19)) (*
integer library_binding = "analogLib";

 *)
c5431 ( \PHASE_250(2) , AEQ_DIS_2p5 );
capacitor #(.c(4.89e-18)) (*
integer library_binding = "analogLib";

 *)
c5432 ( \PHASE_250(2) , \4:PHASE_250(6)  );
capacitor #(.c(4.412e-18)) (*
integer library_binding = "analogLib";

 *)
c5433 ( \PHASE_250(2) , \PHASE_250(6)  );
capacitor #(.c(3.489e-19)) (*
integer library_binding = "analogLib";

 *)
c5434 ( \PHASE_250(2) , RX10_PRESENT_2p5 );
capacitor #(.c(3.041e-19)) (*
integer library_binding = "analogLib";

 *)
c5435 ( \PHASE_250(2) , \5:ADC_DIS_2p5  );
capacitor #(.c(1.37e-17)) (*
integer library_binding = "analogLib";

 *)
c5436 ( \PHASE_250(2) , TP_DISC_2p5 );
capacitor #(.c(1.745e-19)) (*
integer library_binding = "analogLib";

 *)
c5437 ( \PHASE_250(2) , \3:TP_DISC_2p5  );
capacitor #(.c(3.601e-18)) (*
integer library_binding = "analogLib";

 *)
c5438 ( \PHASE_250(2) , \PHASE_250(9)  );
capacitor #(.c(3.87e-19)) (*
integer library_binding = "analogLib";

 *)
c5439 ( \PHASE_250(2) , \MLT3_TDATA_2p5(1)  );
capacitor #(.c(1.682e-18)) (*
integer library_binding = "analogLib";

 *)
c5440 ( \PHASE_250(2) , \3:MR_SQUELCH_DISB_2p5  );
capacitor #(.c(2.1e-17)) (*
integer library_binding = "analogLib";

 *)
c5441 ( \PHASE_250(2) , MR_SQUELCH_DISB_2p5 );
capacitor #(.c(7.645e-18)) (*
integer library_binding = "analogLib";

 *)
c5442 ( \4:PHASE_250(2) , \2:I_REXT_50(0)  );
capacitor #(.c(1.237e-17)) (*
integer library_binding = "analogLib";

 *)
c5443 ( \4:PHASE_250(2) , \6:RX10_PRESENT_2p5  );
capacitor #(.c(1.381e-17)) (*
integer library_binding = "analogLib";

 *)
c5444 ( \4:PHASE_250(2) , ADC_DIS_2p5 );
capacitor #(.c(1.406e-17)) (*
integer library_binding = "analogLib";

 *)
c5445 ( \4:PHASE_250(2) , \6:AEQ_DIS_2p5  );
capacitor #(.c(5.483e-18)) (*
integer library_binding = "analogLib";

 *)
c5446 ( \4:PHASE_250(2) , MR_SQUELCH_DISB_2p5 );
capacitor #(.c(3.304e-17)) (*
integer library_binding = "analogLib";

 *)
c5447 ( \4:PHASE_250(2) , \4:MLT3_TDATA_2p5(1)  );
capacitor #(.c(6.972e-18)) (*
integer library_binding = "analogLib";

 *)
c5448 ( \4:PHASE_250(2) , \3:PHASE_250(9)  );
capacitor #(.c(4.751e-19)) (*
integer library_binding = "analogLib";

 *)
c5449 ( \4:PHASE_250(2) , AEQ_DIS_2p5 );
capacitor #(.c(2.539e-19)) (*
integer library_binding = "analogLib";

 *)
c5450 ( \4:PHASE_250(2) , RX10_PRESENT_2p5 );
capacitor #(.c(2.213e-19)) (*
integer library_binding = "analogLib";

 *)
c5451 ( \4:PHASE_250(2) , \5:ADC_DIS_2p5  );
capacitor #(.c(9.967e-18)) (*
integer library_binding = "analogLib";

 *)
c5452 ( \4:PHASE_250(2) , TP_DISC_2p5 );
capacitor #(.c(1.27e-19)) (*
integer library_binding = "analogLib";

 *)
c5453 ( \4:PHASE_250(2) , \3:TP_DISC_2p5  );
capacitor #(.c(2.817e-19)) (*
integer library_binding = "analogLib";

 *)
c5454 ( \4:PHASE_250(2) , \MLT3_TDATA_2p5(1)  );
capacitor #(.c(1.447e-17)) (*
integer library_binding = "analogLib";

 *)
c5455 ( \4:PHASE_250(2) , \PHASE_250(9)  );
capacitor #(.c(1.46e-17)) (*
integer library_binding = "analogLib";

 *)
c5456 ( \4:PHASE_250(2) , \4:PHASE_250(10)  );
capacitor #(.c(1.317e-17)) (*
integer library_binding = "analogLib";

 *)
c5457 ( \4:PHASE_250(2) , \4:RCLK125_TST  );
capacitor #(.c(1.812e-15)) (*
integer library_binding = "analogLib";

 *)
c5458 ( \4:PHASE_250(2) , \4:PHASE_250(4)  );
capacitor #(.c(4.685e-16)) (*
integer library_binding = "analogLib";

 *)
c5459 ( \4:PHASE_250(2) , \PHASE_250(4)  );
capacitor #(.c(3.578e-18)) (*
integer library_binding = "analogLib";

 *)
c5460 ( \4:PHASE_250(2) , \PHASE_250(10)  );
capacitor #(.c(4.409e-18)) (*
integer library_binding = "analogLib";

 *)
c5461 ( \4:PHASE_250(2) , RCLK125_TST );
capacitor #(.c(2.074e-17)) (*
integer library_binding = "analogLib";

 *)
c5462 ( \4:PHASE_250(2) , \4:PHASE_250(6)  );
capacitor #(.c(4.312e-18)) (*
integer library_binding = "analogLib";

 *)
c5463 ( \4:PHASE_250(2) , \PHASE_250(6)  );
capacitor #(.c(2.462e-18)) (*
integer library_binding = "analogLib";

 *)
c5464 ( \7:ADC_1p0(4) , \4:MLT3_TDATA_1p0(0)  );
capacitor #(.c(2.829e-18)) (*
integer library_binding = "analogLib";

 *)
c5465 ( \7:ADC_1p0(4) , \TEST_MODE(2)  );
capacitor #(.c(1.487e-17)) (*
integer library_binding = "analogLib";

 *)
c5466 ( \7:ADC_1p0(4) , \3:TEST_MODE(2)  );
capacitor #(.c(2.563e-18)) (*
integer library_binding = "analogLib";

 *)
c5467 ( \7:ADC_1p0(4) , \4:TX_SLOPETRIM_1p0(1)  );
capacitor #(.c(1.514e-17)) (*
integer library_binding = "analogLib";

 *)
c5468 ( \7:ADC_1p0(4) , \TX_SLOPETRIM_1p0(1)  );
capacitor #(.c(1.516e-17)) (*
integer library_binding = "analogLib";

 *)
c5469 ( \7:ADC_1p0(4) , SLICER_OUT_1p0 );
capacitor #(.c(2.54e-18)) (*
integer library_binding = "analogLib";

 *)
c5470 ( \7:ADC_1p0(4) , \4:SLICER_OUT_1p0  );
capacitor #(.c(2.71e-18)) (*
integer library_binding = "analogLib";

 *)
c5471 ( \7:ADC_1p0(4) , \4:X_125  );
capacitor #(.c(1.524e-17)) (*
integer library_binding = "analogLib";

 *)
c5472 ( \7:ADC_1p0(4) , \MLT3_TDATA_1p0(0)  );
capacitor #(.c(1.499e-17)) (*
integer library_binding = "analogLib";

 *)
c5473 ( \7:ADC_1p0(4) , X_125 );
capacitor #(.c(2.627e-19)) (*
integer library_binding = "analogLib";

 *)
c5474 ( \1:ADC_1p0(4) , \4:MLT3_TDATA_1p0(0)  );
capacitor #(.c(3.019e-19)) (*
integer library_binding = "analogLib";

 *)
c5475 ( \1:ADC_1p0(4) , \TEST_MODE(2)  );
capacitor #(.c(1.587e-18)) (*
integer library_binding = "analogLib";

 *)
c5476 ( \1:ADC_1p0(4) , \3:TEST_MODE(2)  );
capacitor #(.c(2.735e-19)) (*
integer library_binding = "analogLib";

 *)
c5477 ( \1:ADC_1p0(4) , \4:TX_SLOPETRIM_1p0(1)  );
capacitor #(.c(1.615e-18)) (*
integer library_binding = "analogLib";

 *)
c5478 ( \1:ADC_1p0(4) , \TX_SLOPETRIM_1p0(1)  );
capacitor #(.c(1.618e-18)) (*
integer library_binding = "analogLib";

 *)
c5479 ( \1:ADC_1p0(4) , SLICER_OUT_1p0 );
capacitor #(.c(2.711e-19)) (*
integer library_binding = "analogLib";

 *)
c5480 ( \1:ADC_1p0(4) , \4:SLICER_OUT_1p0  );
capacitor #(.c(2.892e-19)) (*
integer library_binding = "analogLib";

 *)
c5481 ( \1:ADC_1p0(4) , \4:X_125  );
capacitor #(.c(1.626e-18)) (*
integer library_binding = "analogLib";

 *)
c5482 ( \1:ADC_1p0(4) , \MLT3_TDATA_1p0(0)  );
capacitor #(.c(1.6e-18)) (*
integer library_binding = "analogLib";

 *)
c5483 ( \1:ADC_1p0(4) , X_125 );
capacitor #(.c(1.959e-17)) (*
integer library_binding = "analogLib";

 *)
c5484 ( \1:ADC_1p0(4) , XTAL25_1p0 );
capacitor #(.c(1.959e-17)) (*
integer library_binding = "analogLib";

 *)
c5485 ( \1:ADC_1p0(4) , \MR_SQUELCH_RANGE_1p0(0)  );
capacitor #(.c(1.959e-17)) (*
integer library_binding = "analogLib";

 *)
c5486 ( \1:ADC_1p0(4) , POS_DETECT_1p0 );
capacitor #(.c(1.959e-17)) (*
integer library_binding = "analogLib";

 *)
c5487 ( \1:ADC_1p0(4) , \4:MR_SQUELCH_DISB_1p0  );
capacitor #(.c(1.959e-17)) (*
integer library_binding = "analogLib";

 *)
c5488 ( \1:ADC_1p0(4) , NEG_DETECT_1p0 );
capacitor #(.c(1.406e-17)) (*
integer library_binding = "analogLib";

 *)
c5489 ( \3:ADC_1p0(4) , \7:I_REXT_50(0)  );
capacitor #(.c(1.973e-18)) (*
integer library_binding = "analogLib";

 *)
c5490 ( \3:ADC_1p0(4) , \I_REXT_50(0)  );
capacitor #(.c(1.508e-17)) (*
integer library_binding = "analogLib";

 *)
c5491 ( \3:ADC_1p0(4) , \4:I_REXT_100(3)  );
capacitor #(.c(1.375e-17)) (*
integer library_binding = "analogLib";

 *)
c5492 ( \PHASE_IN(9) , \PHASE_IN(7)  );
capacitor #(.c(5.846e-19)) (*
integer library_binding = "analogLib";

 *)
c5493 ( \PHASE_IN(9) , \3:PHASE_IN(7)  );
capacitor #(.c(3.347e-17)) (*
integer library_binding = "analogLib";

 *)
c5494 ( \PHASE_IN(9) , \PHASE_IN(5)  );
capacitor #(.c(1.605e-17)) (*
integer library_binding = "analogLib";

 *)
c5495 ( \2:PHASE_IN(9) , RESET_10BT );
capacitor #(.c(6.076e-19)) (*
integer library_binding = "analogLib";

 *)
c5496 ( \2:PHASE_IN(9) , \PHASE_IN(7)  );
capacitor #(.c(2.873e-18)) (*
integer library_binding = "analogLib";

 *)
c5497 ( \2:PHASE_IN(9) , TENBT_CLK160_1p0 );
capacitor #(.c(1.562e-17)) (*
integer library_binding = "analogLib";

 *)
c5498 ( \2:PHASE_IN(9) , \6:TENBT_CLK160_1p0  );
capacitor #(.c(2.438e-18)) (*
integer library_binding = "analogLib";

 *)
c5499 ( \2:PHASE_IN(9) , \5:RESET_10BT  );
capacitor #(.c(2.517e-15)) (*
integer library_binding = "analogLib";

 *)
c5500 ( \2:PHASE_IN(9) , \3:PHASE_IN(7)  );
capacitor #(.c(6.59e-16)) (*
integer library_binding = "analogLib";

 *)
c5501 ( \2:PHASE_IN(9) , \1:PHASE_IN(5)  );
capacitor #(.c(1.025e-18)) (*
integer library_binding = "analogLib";

 *)
c5502 ( \4:PHASE_IN(9) , \WANDER_CNT(4)  );
capacitor #(.c(1.006e-15)) (*
integer library_binding = "analogLib";

 *)
c5503 ( \4:PHASE_IN(9) , \MLT3_TDATA_2p5(1)  );
capacitor #(.c(7.471e-19)) (*
integer library_binding = "analogLib";

 *)
c5504 ( \4:PHASE_IN(9) , \WANDER_CNT(2)  );
capacitor #(.c(1.516e-17)) (*
integer library_binding = "analogLib";

 *)
c5505 ( \4:PHASE_IN(9) , \5:WANDER_CNT(2)  );
capacitor #(.c(1.109e-18)) (*
integer library_binding = "analogLib";

 *)
c5506 ( \4:PHASE_IN(9) , \AEQ_CNT_ANLG(4)  );
capacitor #(.c(3.229e-18)) (*
integer library_binding = "analogLib";

 *)
c5507 ( \4:PHASE_IN(9) , \5:PHASE_IN(5)  );
capacitor #(.c(9.39e-17)) (*
integer library_binding = "analogLib";

 *)
c5508 ( \4:PHASE_IN(9) , \24:VDDTX  );
capacitor #(.c(4.93e-16)) (*
integer library_binding = "analogLib";

 *)
c5509 ( \4:PHASE_IN(9) , \25:VDDTX  );
capacitor #(.c(1.482e-17)) (*
integer library_binding = "analogLib";

 *)
c5510 ( \4:PHASE_IN(9) , \AEQ_CNT_ANLG(0)  );
capacitor #(.c(1.082e-18)) (*
integer library_binding = "analogLib";

 *)
c5511 ( \4:PHASE_IN(9) , \4:AEQ_CNT_ANLG(0)  );
capacitor #(.c(1.206e-17)) (*
integer library_binding = "analogLib";

 *)
c5512 ( \4:PHASE_IN(9) , \5:WANDER_CNT(4)  );
capacitor #(.c(1.033e-17)) (*
integer library_binding = "analogLib";

 *)
c5513 ( \4:PHASE_IN(9) , \5:AEQ_CNT_ANLG(4)  );
capacitor #(.c(8.486e-16)) (*
integer library_binding = "analogLib";

 *)
c5514 ( \4:PHASE_IN(9) , \4:MLT3_TDATA_2p5(1)  );
capacitor #(.c(1.528e-15)) (*
integer library_binding = "analogLib";

 *)
c5515 ( \4:PHASE_IN(9) , \5:PHASE_IN(7)  );
capacitor #(.c(6.289e-16)) (*
integer library_binding = "analogLib";

 *)
c5516 ( \4:PHASE_IN(9) , \2:PHASE_IN(5)  );
capacitor #(.c(4.263e-17)) (*
integer library_binding = "analogLib";

 *)
c5517 ( \4:PHASE_IN(9) , \3:PHASE_IN(7)  );
capacitor #(.c(8.665e-17)) (*
integer library_binding = "analogLib";

 *)
c5518 ( \4:PHASE_IN(9) , MR_BYPASS10RX_FILTER );
capacitor #(.c(3.697e-18)) (*
integer library_binding = "analogLib";

 *)
c5519 ( \7:PHASE_IN(9) , \2:PHASE_IN(5)  );
capacitor #(.c(5.476e-18)) (*
integer library_binding = "analogLib";

 *)
c5520 ( \7:PHASE_IN(9) , \5:PHASE_IN(5)  );
capacitor #(.c(1.204e-17)) (*
integer library_binding = "analogLib";

 *)
c5521 ( \7:PHASE_IN(9) , \24:VDDTX  );
capacitor #(.c(6.322e-17)) (*
integer library_binding = "analogLib";

 *)
c5522 ( \7:PHASE_IN(9) , \25:VDDTX  );
capacitor #(.c(9.309e-17)) (*
integer library_binding = "analogLib";

 *)
c5523 ( \7:PHASE_IN(9) , MR_BYPASS10RX_FILTER );
capacitor #(.c(1.98e-17)) (*
integer library_binding = "analogLib";

 *)
c5524 ( AEQ_DIS_2p5, \WANDER_CNT(4)  );
capacitor #(.c(1.238e-18)) (*
integer library_binding = "analogLib";

 *)
c5525 ( AEQ_DIS_2p5, \4:PHASE_250(8)  );
capacitor #(.c(1.086e-18)) (*
integer library_binding = "analogLib";

 *)
c5526 ( AEQ_DIS_2p5, \PHASE_250(8)  );
capacitor #(.c(3.162e-19)) (*
integer library_binding = "analogLib";

 *)
c5527 ( AEQ_DIS_2p5, \AEQ_CNT_ANLG(4)  );
capacitor #(.c(1.745e-17)) (*
integer library_binding = "analogLib";

 *)
c5528 ( AEQ_DIS_2p5, \6:I_REXT_50(0)  );
capacitor #(.c(1.392e-17)) (*
integer library_binding = "analogLib";

 *)
c5529 ( AEQ_DIS_2p5, \5:ADC_DIS_2p5  );
capacitor #(.c(4.045e-17)) (*
integer library_binding = "analogLib";

 *)
c5530 ( AEQ_DIS_2p5, \24:VDDTX  );
capacitor #(.c(2.124e-16)) (*
integer library_binding = "analogLib";

 *)
c5531 ( AEQ_DIS_2p5, \25:VDDTX  );
capacitor #(.c(5.716e-19)) (*
integer library_binding = "analogLib";

 *)
c5532 ( AEQ_DIS_2p5, RX10_PRESENT_2p5 );
capacitor #(.c(5.555e-19)) (*
integer library_binding = "analogLib";

 *)
c5533 ( AEQ_DIS_2p5, \PHASE_250(6)  );
capacitor #(.c(4.995e-19)) (*
integer library_binding = "analogLib";

 *)
c5534 ( AEQ_DIS_2p5, \4:PHASE_250(6)  );
capacitor #(.c(2.62e-18)) (*
integer library_binding = "analogLib";

 *)
c5535 ( AEQ_DIS_2p5, ADC_DIS_2p5 );
capacitor #(.c(7.865e-19)) (*
integer library_binding = "analogLib";

 *)
c5536 ( AEQ_DIS_2p5, \AEQ_CNT_ANLG(0)  );
capacitor #(.c(1.722e-17)) (*
integer library_binding = "analogLib";

 *)
c5537 ( AEQ_DIS_2p5, \4:AEQ_CNT_ANLG(0)  );
capacitor #(.c(9.751e-19)) (*
integer library_binding = "analogLib";

 *)
c5538 ( AEQ_DIS_2p5, \5:TIMING_DN_ANLG  );
capacitor #(.c(2.951e-18)) (*
integer library_binding = "analogLib";

 *)
c5539 ( AEQ_DIS_2p5, \6:RX10_PRESENT_2p5  );
capacitor #(.c(6.138e-19)) (*
integer library_binding = "analogLib";

 *)
c5540 ( AEQ_DIS_2p5, \PHASE_250(4)  );
capacitor #(.c(5.141e-19)) (*
integer library_binding = "analogLib";

 *)
c5541 ( AEQ_DIS_2p5, \4:PHASE_250(4)  );
capacitor #(.c(1.931e-18)) (*
integer library_binding = "analogLib";

 *)
c5542 ( AEQ_DIS_2p5, \PHASE_250(10)  );
capacitor #(.c(2.114e-18)) (*
integer library_binding = "analogLib";

 *)
c5543 ( AEQ_DIS_2p5, \4:PHASE_250(10)  );
capacitor #(.c(6.848e-19)) (*
integer library_binding = "analogLib";

 *)
c5544 ( AEQ_DIS_2p5, RCLK125_TST );
capacitor #(.c(3.614e-19)) (*
integer library_binding = "analogLib";

 *)
c5545 ( AEQ_DIS_2p5, \4:RCLK125_TST  );
capacitor #(.c(4.294e-18)) (*
integer library_binding = "analogLib";

 *)
c5546 ( AEQ_DIS_2p5, \2:I_REXT_50(0)  );
capacitor #(.c(1.962e-18)) (*
integer library_binding = "analogLib";

 *)
c5547 ( AEQ_DIS_2p5, MR_BYPASS10RX_FILTER );
capacitor #(.c(2.944e-18)) (*
integer library_binding = "analogLib";

 *)
c5548 ( AEQ_DIS_2p5, \5:AEQ_CNT_ANLG(4)  );
capacitor #(.c(3.274e-18)) (*
integer library_binding = "analogLib";

 *)
c5549 ( AEQ_DIS_2p5, \5:WANDER_CNT(4)  );
capacitor #(.c(1.127e-18)) (*
integer library_binding = "analogLib";

 *)
c5550 ( \6:AEQ_DIS_2p5 , \WANDER_CNT(4)  );
capacitor #(.c(3.187e-17)) (*
integer library_binding = "analogLib";

 *)
c5551 ( \6:AEQ_DIS_2p5 , \4:PHASE_250(8)  );
capacitor #(.c(2.797e-17)) (*
integer library_binding = "analogLib";

 *)
c5552 ( \6:AEQ_DIS_2p5 , \PHASE_250(8)  );
capacitor #(.c(1.306e-18)) (*
integer library_binding = "analogLib";

 *)
c5553 ( \6:AEQ_DIS_2p5 , \AEQ_CNT_ANLG(4)  );
capacitor #(.c(5.594e-19)) (*
integer library_binding = "analogLib";

 *)
c5554 ( \6:AEQ_DIS_2p5 , \6:I_REXT_50(0)  );
capacitor #(.c(1.714e-18)) (*
integer library_binding = "analogLib";

 *)
c5555 ( \6:AEQ_DIS_2p5 , \5:ADC_DIS_2p5  );
capacitor #(.c(1.671e-16)) (*
integer library_binding = "analogLib";

 *)
c5556 ( \6:AEQ_DIS_2p5 , \24:VDDTX  );
capacitor #(.c(8.771e-16)) (*
integer library_binding = "analogLib";

 *)
c5557 ( \6:AEQ_DIS_2p5 , \25:VDDTX  );
capacitor #(.c(2.727e-18)) (*
integer library_binding = "analogLib";

 *)
c5558 ( \6:AEQ_DIS_2p5 , RX10_PRESENT_2p5 );
capacitor #(.c(1.685e-17)) (*
integer library_binding = "analogLib";

 *)
c5559 ( \6:AEQ_DIS_2p5 , \PHASE_250(6)  );
capacitor #(.c(1.515e-17)) (*
integer library_binding = "analogLib";

 *)
c5560 ( \6:AEQ_DIS_2p5 , \4:PHASE_250(6)  );
capacitor #(.c(1.026e-17)) (*
integer library_binding = "analogLib";

 *)
c5561 ( \6:AEQ_DIS_2p5 , ADC_DIS_2p5 );
capacitor #(.c(2.522e-20)) (*
integer library_binding = "analogLib";

 *)
c5562 ( \6:AEQ_DIS_2p5 , \AEQ_CNT_ANLG(0)  );
capacitor #(.c(5.521e-19)) (*
integer library_binding = "analogLib";

 *)
c5563 ( \6:AEQ_DIS_2p5 , \4:AEQ_CNT_ANLG(0)  );
capacitor #(.c(1.771e-17)) (*
integer library_binding = "analogLib";

 *)
c5564 ( \6:AEQ_DIS_2p5 , \5:TIMING_DN_ANLG  );
capacitor #(.c(2.215e-17)) (*
integer library_binding = "analogLib";

 *)
c5565 ( \6:AEQ_DIS_2p5 , \6:RX10_PRESENT_2p5  );
capacitor #(.c(1.326e-17)) (*
integer library_binding = "analogLib";

 *)
c5566 ( \6:AEQ_DIS_2p5 , \5:WANDER_CNT(4)  );
capacitor #(.c(1.216e-17)) (*
integer library_binding = "analogLib";

 *)
c5567 ( \6:AEQ_DIS_2p5 , \5:AEQ_CNT_ANLG(4)  );
capacitor #(.c(8.104e-18)) (*
integer library_binding = "analogLib";

 *)
c5568 ( \6:AEQ_DIS_2p5 , MR_BYPASS10RX_FILTER );
capacitor #(.c(1.344e-17)) (*
integer library_binding = "analogLib";

 *)
c5569 ( \6:AEQ_DIS_2p5 , RCLK125_TST );
capacitor #(.c(4.582e-17)) (*
integer library_binding = "analogLib";

 *)
c5570 ( \6:AEQ_DIS_2p5 , \4:PHASE_250(10)  );
capacitor #(.c(4.187e-17)) (*
integer library_binding = "analogLib";

 *)
c5571 ( \6:AEQ_DIS_2p5 , \PHASE_250(10)  );
capacitor #(.c(1.661e-17)) (*
integer library_binding = "analogLib";

 *)
c5572 ( \6:AEQ_DIS_2p5 , \4:PHASE_250(4)  );
capacitor #(.c(1.984e-17)) (*
integer library_binding = "analogLib";

 *)
c5573 ( \6:AEQ_DIS_2p5 , \PHASE_250(4)  );
capacitor #(.c(2.121e-17)) (*
integer library_binding = "analogLib";

 *)
c5574 ( \6:AEQ_DIS_2p5 , \4:RCLK125_TST  );
capacitor #(.c(2.895e-17)) (*
integer library_binding = "analogLib";

 *)
c5575 ( \6:AEQ_DIS_2p5 , \2:I_REXT_50(0)  );
capacitor #(.c(4.593e-18)) (*
integer library_binding = "analogLib";

 *)
c5576 ( RCLK125_TST, \4:PHASE_250(8)  );
capacitor #(.c(4.031e-18)) (*
integer library_binding = "analogLib";

 *)
c5577 ( RCLK125_TST, \PHASE_250(8)  );
capacitor #(.c(4.606e-18)) (*
integer library_binding = "analogLib";

 *)
c5578 ( RCLK125_TST, \3:MR_SQUELCH_DISB_2p5  );
capacitor #(.c(8.937e-18)) (*
integer library_binding = "analogLib";

 *)
c5579 ( RCLK125_TST, \3:TP_DISC_2p5  );
capacitor #(.c(7.015e-16)) (*
integer library_binding = "analogLib";

 *)
c5580 ( RCLK125_TST, TP_DISC_2p5 );
capacitor #(.c(1.244e-18)) (*
integer library_binding = "analogLib";

 *)
c5581 ( RCLK125_TST, \5:ADC_DIS_2p5  );
capacitor #(.c(2.604e-18)) (*
integer library_binding = "analogLib";

 *)
c5582 ( RCLK125_TST, RX10_PRESENT_2p5 );
capacitor #(.c(1.421e-17)) (*
integer library_binding = "analogLib";

 *)
c5583 ( RCLK125_TST, \PHASE_250(6)  );
capacitor #(.c(4.708e-17)) (*
integer library_binding = "analogLib";

 *)
c5584 ( RCLK125_TST, ADC_DIS_2p5 );
capacitor #(.c(1.355e-17)) (*
integer library_binding = "analogLib";

 *)
c5585 ( RCLK125_TST, \4:PHASE_250(6)  );
capacitor #(.c(1.312e-17)) (*
integer library_binding = "analogLib";

 *)
c5586 ( RCLK125_TST, \2:I_REXT_50(0)  );
capacitor #(.c(5.761e-18)) (*
integer library_binding = "analogLib";

 *)
c5587 ( RCLK125_TST, \4:PHASE_250(10)  );
capacitor #(.c(9.315e-18)) (*
integer library_binding = "analogLib";

 *)
c5588 ( RCLK125_TST, MR_SQUELCH_DISB_2p5 );
capacitor #(.c(1.152e-17)) (*
integer library_binding = "analogLib";

 *)
c5589 ( RCLK125_TST, \6:RX10_PRESENT_2p5  );
capacitor #(.c(1.37e-17)) (*
integer library_binding = "analogLib";

 *)
c5590 ( RCLK125_TST, \4:PHASE_250(4)  );
capacitor #(.c(1.546e-17)) (*
integer library_binding = "analogLib";

 *)
c5591 ( RCLK125_TST, \PHASE_250(4)  );
capacitor #(.c(4.203e-18)) (*
integer library_binding = "analogLib";

 *)
c5592 ( RCLK125_TST, \PHASE_250(10)  );
capacitor #(.c(2.625e-18)) (*
integer library_binding = "analogLib";

 *)
c5593 ( \4:RCLK125_TST , \PHASE_250(8)  );
capacitor #(.c(4.717e-18)) (*
integer library_binding = "analogLib";

 *)
c5594 ( \4:RCLK125_TST , \3:TP_DISC_2p5  );
capacitor #(.c(3.702e-16)) (*
integer library_binding = "analogLib";

 *)
c5595 ( \4:RCLK125_TST , TP_DISC_2p5 );
capacitor #(.c(6.567e-19)) (*
integer library_binding = "analogLib";

 *)
c5596 ( \4:RCLK125_TST , \5:ADC_DIS_2p5  );
capacitor #(.c(1.893e-17)) (*
integer library_binding = "analogLib";

 *)
c5597 ( \4:RCLK125_TST , \4:PHASE_250(8)  );
capacitor #(.c(1.875e-18)) (*
integer library_binding = "analogLib";

 *)
c5598 ( \4:RCLK125_TST , RX10_PRESENT_2p5 );
capacitor #(.c(8.235e-18)) (*
integer library_binding = "analogLib";

 *)
c5599 ( \4:RCLK125_TST , \PHASE_250(6)  );
capacitor #(.c(2.485e-17)) (*
integer library_binding = "analogLib";

 *)
c5600 ( \4:RCLK125_TST , ADC_DIS_2p5 );
capacitor #(.c(1.86e-17)) (*
integer library_binding = "analogLib";

 *)
c5601 ( \4:RCLK125_TST , \4:PHASE_250(6)  );
capacitor #(.c(6.923e-18)) (*
integer library_binding = "analogLib";

 *)
c5602 ( \4:RCLK125_TST , \2:I_REXT_50(0)  );
capacitor #(.c(3.416e-18)) (*
integer library_binding = "analogLib";

 *)
c5603 ( \4:RCLK125_TST , \PHASE_250(10)  );
capacitor #(.c(8.807e-18)) (*
integer library_binding = "analogLib";

 *)
c5604 ( \4:RCLK125_TST , \PHASE_250(4)  );
capacitor #(.c(1.821e-17)) (*
integer library_binding = "analogLib";

 *)
c5605 ( \4:RCLK125_TST , \4:PHASE_250(4)  );
capacitor #(.c(1.97e-17)) (*
integer library_binding = "analogLib";

 *)
c5606 ( \4:RCLK125_TST , \6:RX10_PRESENT_2p5  );
capacitor #(.c(1.465e-17)) (*
integer library_binding = "analogLib";

 *)
c5607 ( \4:RCLK125_TST , MR_SQUELCH_DISB_2p5 );
capacitor #(.c(2.056e-17)) (*
integer library_binding = "analogLib";

 *)
c5608 ( \4:RCLK125_TST , \4:PHASE_250(10)  );
capacitor #(.c(1.416e-17)) (*
integer library_binding = "analogLib";

 *)
c5609 ( X_125, \TX_SLOPETRIM_1p0(1)  );
capacitor #(.c(2.399e-18)) (*
integer library_binding = "analogLib";

 *)
c5610 ( X_125, \4:TX_SLOPETRIM_1p0(1)  );
capacitor #(.c(2.397e-18)) (*
integer library_binding = "analogLib";

 *)
c5611 ( X_125, \4:MLT3_TDATA_1p0(0)  );
capacitor #(.c(1.482e-17)) (*
integer library_binding = "analogLib";

 *)
c5612 ( X_125, \MLT3_TDATA_1p0(0)  );
capacitor #(.c(1.45e-19)) (*
integer library_binding = "analogLib";

 *)
c5613 ( X_125, \MR_SQUELCH_RANGE_1p0(0)  );
capacitor #(.c(1.82e-17)) (*
integer library_binding = "analogLib";

 *)
c5614 ( X_125, \3:MR_SQUELCH_RANGE_1p0(0)  );
capacitor #(.c(1.662e-17)) (*
integer library_binding = "analogLib";

 *)
c5615 ( X_125, MR_SQUELCH_DISB_1p0 );
capacitor #(.c(3.142e-19)) (*
integer library_binding = "analogLib";

 *)
c5616 ( X_125, \4:MR_SQUELCH_DISB_1p0  );
capacitor #(.c(2.828e-18)) (*
integer library_binding = "analogLib";

 *)
c5617 ( \4:X_125 , \TX_SLOPETRIM_1p0(1)  );
capacitor #(.c(1.979e-17)) (*
integer library_binding = "analogLib";

 *)
c5618 ( \4:X_125 , \4:TX_SLOPETRIM_1p0(1)  );
capacitor #(.c(1.962e-17)) (*
integer library_binding = "analogLib";

 *)
c5619 ( \4:X_125 , \4:MR_SQUELCH_DISB_1p0  );
capacitor #(.c(1.962e-17)) (*
integer library_binding = "analogLib";

 *)
c5620 ( \4:X_125 , \MR_SQUELCH_RANGE_1p0(0)  );
capacitor #(.c(2.005e-17)) (*
integer library_binding = "analogLib";

 *)
c5621 ( \4:X_125 , \4:MLT3_TDATA_1p0(0)  );
capacitor #(.c(2.68e-18)) (*
integer library_binding = "analogLib";

 *)
c5622 ( \4:X_125 , \MLT3_TDATA_1p0(0)  );
capacitor #(.c(1.768e-17)) (*
integer library_binding = "analogLib";

 *)
c5623 ( \PHASE_250(9) , \PHASE_250(8)  );
capacitor #(.c(1.455e-17)) (*
integer library_binding = "analogLib";

 *)
c5624 ( \PHASE_250(9) , MR_SQUELCH_DISB_2p5 );
capacitor #(.c(1.817e-18)) (*
integer library_binding = "analogLib";

 *)
c5625 ( \PHASE_250(9) , \3:MR_SQUELCH_DISB_2p5  );
capacitor #(.c(1.651e-17)) (*
integer library_binding = "analogLib";

 *)
c5626 ( \PHASE_250(9) , \4:PHASE_250(8)  );
capacitor #(.c(1.026e-17)) (*
integer library_binding = "analogLib";

 *)
c5627 ( \PHASE_250(9) , \PHASE_250(6)  );
capacitor #(.c(1.891e-17)) (*
integer library_binding = "analogLib";

 *)
c5628 ( \PHASE_250(9) , \4:PHASE_250(6)  );
capacitor #(.c(9.759e-18)) (*
integer library_binding = "analogLib";

 *)
c5629 ( \PHASE_250(9) , \PHASE_250(4)  );
capacitor #(.c(1.592e-17)) (*
integer library_binding = "analogLib";

 *)
c5630 ( \PHASE_250(9) , \4:PHASE_250(4)  );
capacitor #(.c(1.815e-17)) (*
integer library_binding = "analogLib";

 *)
c5631 ( \PHASE_250(9) , \2:I_REXT_50(0)  );
capacitor #(.c(5.986e-18)) (*
integer library_binding = "analogLib";

 *)
c5632 ( \3:PHASE_250(9) , \3:MR_SQUELCH_DISB_2p5  );
capacitor #(.c(1.44e-17)) (*
integer library_binding = "analogLib";

 *)
c5633 ( \3:PHASE_250(9) , MR_SQUELCH_DISB_2p5 );
capacitor #(.c(6.206e-18)) (*
integer library_binding = "analogLib";

 *)
c5634 ( \3:PHASE_250(9) , \4:PHASE_250(6)  );
capacitor #(.c(1.206e-17)) (*
integer library_binding = "analogLib";

 *)
c5635 ( \3:PHASE_250(9) , \4:PHASE_250(4)  );
capacitor #(.c(5.624e-17)) (*
integer library_binding = "analogLib";

 *)
c5636 ( \3:PHASE_250(9) , \PHASE_250(8)  );
capacitor #(.c(2.958e-17)) (*
integer library_binding = "analogLib";

 *)
c5637 ( \3:PHASE_250(9) , \PHASE_250(4)  );
capacitor #(.c(3.002e-17)) (*
integer library_binding = "analogLib";

 *)
c5638 ( \3:PHASE_250(9) , \PHASE_250(6)  );
capacitor #(.c(1.853e-17)) (*
integer library_binding = "analogLib";

 *)
c5639 ( XTAL25_1p0, \4:SLICER_OUT_1p0  );
capacitor #(.c(2.726e-18)) (*
integer library_binding = "analogLib";

 *)
c5640 ( XTAL25_1p0, \3:POS_DETECT_1p0  );
capacitor #(.c(7.922e-19)) (*
integer library_binding = "analogLib";

 *)
c5641 ( XTAL25_1p0, SLICER_OUT_1p0 );
capacitor #(.c(2.915e-18)) (*
integer library_binding = "analogLib";

 *)
c5642 ( XTAL25_1p0, \3:MR_SQUELCH_RANGE_1p0(0)  );
capacitor #(.c(1.477e-17)) (*
integer library_binding = "analogLib";

 *)
c5643 ( XTAL25_1p0, \MR_SQUELCH_RANGE_1p0(0)  );
capacitor #(.c(7.374e-16)) (*
integer library_binding = "analogLib";

 *)
c5644 ( XTAL25_1p0, \3:NEG_DETECT_1p0  );
capacitor #(.c(2.841e-18)) (*
integer library_binding = "analogLib";

 *)
c5645 ( XTAL25_1p0, MR_SQUELCH_DISB_1p0 );
capacitor #(.c(2.307e-15)) (*
integer library_binding = "analogLib";

 *)
c5646 ( XTAL25_1p0, NEG_DETECT_1p0 );
capacitor #(.c(1.481e-17)) (*
integer library_binding = "analogLib";

 *)
c5647 ( XTAL25_1p0, \4:MR_SQUELCH_DISB_1p0  );
capacitor #(.c(1.719e-17)) (*
integer library_binding = "analogLib";

 *)
c5648 ( XTAL25_1p0, POS_DETECT_1p0 );
capacitor #(.c(2.112e-17)) (*
integer library_binding = "analogLib";

 *)
c5649 ( \3:XTAL25_1p0 , \3:POS_DETECT_1p0  );
capacitor #(.c(2.078e-17)) (*
integer library_binding = "analogLib";

 *)
c5650 ( \3:XTAL25_1p0 , SLICER_OUT_1p0 );
capacitor #(.c(2.672e-18)) (*
integer library_binding = "analogLib";

 *)
c5651 ( \3:XTAL25_1p0 , POS_DETECT_1p0 );
capacitor #(.c(2.605e-18)) (*
integer library_binding = "analogLib";

 *)
c5652 ( \3:XTAL25_1p0 , \4:MR_SQUELCH_DISB_1p0  );
capacitor #(.c(4.246e-16)) (*
integer library_binding = "analogLib";

 *)
c5653 ( \3:XTAL25_1p0 , NEG_DETECT_1p0 );
capacitor #(.c(1.66e-17)) (*
integer library_binding = "analogLib";

 *)
c5654 ( \3:XTAL25_1p0 , MR_SQUELCH_DISB_1p0 );
capacitor #(.c(2.937e-15)) (*
integer library_binding = "analogLib";

 *)
c5655 ( \3:XTAL25_1p0 , \3:NEG_DETECT_1p0  );
capacitor #(.c(2.434e-18)) (*
integer library_binding = "analogLib";

 *)
c5656 ( \3:XTAL25_1p0 , \MR_SQUELCH_RANGE_1p0(0)  );
capacitor #(.c(1.815e-17)) (*
integer library_binding = "analogLib";

 *)
c5657 ( \3:XTAL25_1p0 , \3:MR_SQUELCH_RANGE_1p0(0)  );
capacitor #(.c(1.778e-17)) (*
integer library_binding = "analogLib";

 *)
c5658 ( \WANDER_CNT(4) , T2_MODE );
capacitor #(.c(1.791e-17)) (*
integer library_binding = "analogLib";

 *)
c5659 ( \WANDER_CNT(4) , \AEQ_CNT_ANLG(4)  );
capacitor #(.c(5.658e-16)) (*
integer library_binding = "analogLib";

 *)
c5660 ( \WANDER_CNT(4) , \3:MR_SQUELCH_DISB_2p5  );
capacitor #(.c(1.958e-17)) (*
integer library_binding = "analogLib";

 *)
c5661 ( \WANDER_CNT(4) , \4:AEQ_CNT_ANLG(0)  );
capacitor #(.c(1.973e-17)) (*
integer library_binding = "analogLib";

 *)
c5662 ( \WANDER_CNT(4) , RX10_PRESENT_2p5 );
capacitor #(.c(1.184e-18)) (*
integer library_binding = "analogLib";

 *)
c5663 ( \WANDER_CNT(4) , \5:AEQ_CNT_ANLG(4)  );
capacitor #(.c(7.739e-18)) (*
integer library_binding = "analogLib";

 *)
c5664 ( \WANDER_CNT(4) , \2:PHASE_IN(5)  );
capacitor #(.c(1.363e-18)) (*
integer library_binding = "analogLib";

 *)
c5665 ( \WANDER_CNT(4) , \2:I_REXT_50(0)  );
capacitor #(.c(1.156e-16)) (*
integer library_binding = "analogLib";

 *)
c5666 ( \WANDER_CNT(4) , MR_BYPASS10RX_FILTER );
capacitor #(.c(1.005e-18)) (*
integer library_binding = "analogLib";

 *)
c5667 ( \WANDER_CNT(4) , \6:RX10_PRESENT_2p5  );
capacitor #(.c(1.244e-18)) (*
integer library_binding = "analogLib";

 *)
c5668 ( \WANDER_CNT(4) , \AEQ_CNT_ANLG(0)  );
capacitor #(.c(1.246e-18)) (*
integer library_binding = "analogLib";

 *)
c5669 ( \WANDER_CNT(4) , ADC_DIS_2p5 );
capacitor #(.c(4.626e-17)) (*
integer library_binding = "analogLib";

 *)
c5670 ( \WANDER_CNT(4) , \25:VDDTX  );
capacitor #(.c(8.811e-18)) (*
integer library_binding = "analogLib";

 *)
c5671 ( \WANDER_CNT(4) , \24:VDDTX  );
capacitor #(.c(1.852e-17)) (*
integer library_binding = "analogLib";

 *)
c5672 ( \WANDER_CNT(4) , \5:ADC_DIS_2p5  );
capacitor #(.c(3.609e-17)) (*
integer library_binding = "analogLib";

 *)
c5673 ( \WANDER_CNT(4) , MR_SQUELCH_DISB_2p5 );
capacitor #(.c(1.272e-18)) (*
integer library_binding = "analogLib";

 *)
c5674 ( \WANDER_CNT(4) , \5:WANDER_CNT(2)  );
capacitor #(.c(6.27e-20)) (*
integer library_binding = "analogLib";

 *)
c5675 ( \WANDER_CNT(4) , \WANDER_CNT(2)  );
capacitor #(.c(9.551e-16)) (*
integer library_binding = "analogLib";

 *)
c5676 ( \WANDER_CNT(4) , \5:MR_BYPASS10RX_FILTER  );
capacitor #(.c(5.852e-20)) (*
integer library_binding = "analogLib";

 *)
c5677 ( \5:WANDER_CNT(4) , T2_MODE );
capacitor #(.c(1.221e-15)) (*
integer library_binding = "analogLib";

 *)
c5678 ( \5:WANDER_CNT(4) , \5:MR_BYPASS10RX_FILTER  );
capacitor #(.c(7.374e-19)) (*
integer library_binding = "analogLib";

 *)
c5679 ( \5:WANDER_CNT(4) , \WANDER_CNT(2)  );
capacitor #(.c(1.496e-17)) (*
integer library_binding = "analogLib";

 *)
c5680 ( \5:WANDER_CNT(4) , \5:WANDER_CNT(2)  );
capacitor #(.c(1.554e-18)) (*
integer library_binding = "analogLib";

 *)
c5681 ( \5:WANDER_CNT(4) , \AEQ_CNT_ANLG(4)  );
capacitor #(.c(4.244e-16)) (*
integer library_binding = "analogLib";

 *)
c5682 ( \5:WANDER_CNT(4) , MR_SQUELCH_DISB_2p5 );
capacitor #(.c(2.147e-18)) (*
integer library_binding = "analogLib";

 *)
c5683 ( \5:WANDER_CNT(4) , \5:ADC_DIS_2p5  );
capacitor #(.c(1.036e-16)) (*
integer library_binding = "analogLib";

 *)
c5684 ( \5:WANDER_CNT(4) , \24:VDDTX  );
capacitor #(.c(5.441e-16)) (*
integer library_binding = "analogLib";

 *)
c5685 ( \5:WANDER_CNT(4) , \25:VDDTX  );
capacitor #(.c(2.943e-18)) (*
integer library_binding = "analogLib";

 *)
c5686 ( \5:WANDER_CNT(4) , RX10_PRESENT_2p5 );
capacitor #(.c(1.25e-17)) (*
integer library_binding = "analogLib";

 *)
c5687 ( \5:WANDER_CNT(4) , ADC_DIS_2p5 );
capacitor #(.c(1.463e-17)) (*
integer library_binding = "analogLib";

 *)
c5688 ( \5:WANDER_CNT(4) , \AEQ_CNT_ANLG(0)  );
capacitor #(.c(1.132e-18)) (*
integer library_binding = "analogLib";

 *)
c5689 ( \5:WANDER_CNT(4) , \4:AEQ_CNT_ANLG(0)  );
capacitor #(.c(1.182e-17)) (*
integer library_binding = "analogLib";

 *)
c5690 ( \5:WANDER_CNT(4) , \6:RX10_PRESENT_2p5  );
capacitor #(.c(1.142e-15)) (*
integer library_binding = "analogLib";

 *)
c5691 ( \5:WANDER_CNT(4) , MR_BYPASS10RX_FILTER );
capacitor #(.c(4.949e-16)) (*
integer library_binding = "analogLib";

 *)
c5692 ( \5:WANDER_CNT(4) , \3:MR_SQUELCH_DISB_2p5  );
capacitor #(.c(1.603e-17)) (*
integer library_binding = "analogLib";

 *)
c5693 ( \5:WANDER_CNT(4) , \2:I_REXT_50(0)  );
capacitor #(.c(9.101e-17)) (*
integer library_binding = "analogLib";

 *)
c5694 ( \5:WANDER_CNT(4) , \2:PHASE_IN(5)  );
capacitor #(.c(1.392e-17)) (*
integer library_binding = "analogLib";

 *)
c5695 ( \5:WANDER_CNT(4) , \5:AEQ_CNT_ANLG(4)  );
capacitor #(.c(8.323e-15)) (*
integer library_binding = "analogLib";

 *)
c5696 ( MR_SQUELCH_DISB_1p0, \3:MR_SQUELCH_RANGE_1p0(0)  );
capacitor #(.c(1.265e-15)) (*
integer library_binding = "analogLib";

 *)
c5697 ( MR_SQUELCH_DISB_1p0, \MR_SQUELCH_RANGE_1p0(0)  );
capacitor #(.c(1.662e-17)) (*
integer library_binding = "analogLib";

 *)
c5698 ( MR_SQUELCH_DISB_1p0, \3:NEG_DETECT_1p0  );
capacitor #(.c(1.662e-17)) (*
integer library_binding = "analogLib";

 *)
c5699 ( MR_SQUELCH_DISB_1p0, \MLT3_TDATA_1p0(0)  );
capacitor #(.c(1.698e-17)) (*
integer library_binding = "analogLib";

 *)
c5700 ( MR_SQUELCH_DISB_1p0, \3:POS_DETECT_1p0  );
capacitor #(.c(1.662e-17)) (*
integer library_binding = "analogLib";

 *)
c5701 ( MR_SQUELCH_DISB_1p0, SLICER_OUT_1p0 );
capacitor #(.c(2.814e-18)) (*
integer library_binding = "analogLib";

 *)
c5702 ( MR_SQUELCH_DISB_1p0, POS_DETECT_1p0 );
capacitor #(.c(2.764e-18)) (*
integer library_binding = "analogLib";

 *)
c5703 ( MR_SQUELCH_DISB_1p0, NEG_DETECT_1p0 );
capacitor #(.c(2.198e-17)) (*
integer library_binding = "analogLib";

 *)
c5704 ( \4:MR_SQUELCH_DISB_1p0 , \4:MLT3_TDATA_1p0(0)  );
capacitor #(.c(1.853e-17)) (*
integer library_binding = "analogLib";

 *)
c5705 ( \4:MR_SQUELCH_DISB_1p0 , \4:SLICER_OUT_1p0  );
capacitor #(.c(1.184e-15)) (*
integer library_binding = "analogLib";

 *)
c5706 ( \4:MR_SQUELCH_DISB_1p0 , \3:MR_SQUELCH_RANGE_1p0(0)  );
capacitor #(.c(6.146e-15)) (*
integer library_binding = "analogLib";

 *)
c5707 ( \4:MR_SQUELCH_DISB_1p0 , \MR_SQUELCH_RANGE_1p0(0)  );
capacitor #(.c(2.602e-18)) (*
integer library_binding = "analogLib";

 *)
c5708 ( \4:MR_SQUELCH_DISB_1p0 , \3:NEG_DETECT_1p0  );
capacitor #(.c(7.505e-19)) (*
integer library_binding = "analogLib";

 *)
c5709 ( \4:MR_SQUELCH_DISB_1p0 , \MLT3_TDATA_1p0(0)  );
capacitor #(.c(2.51e-18)) (*
integer library_binding = "analogLib";

 *)
c5710 ( \4:MR_SQUELCH_DISB_1p0 , \3:POS_DETECT_1p0  );
capacitor #(.c(5.941e-19)) (*
integer library_binding = "analogLib";

 *)
c5711 ( \4:MR_SQUELCH_DISB_1p0 , SLICER_OUT_1p0 );
capacitor #(.c(1.445e-17)) (*
integer library_binding = "analogLib";

 *)
c5712 ( \4:MR_SQUELCH_DISB_1p0 , NEG_DETECT_1p0 );
capacitor #(.c(1.705e-17)) (*
integer library_binding = "analogLib";

 *)
c5713 ( \4:MR_SQUELCH_DISB_1p0 , POS_DETECT_1p0 );
capacitor #(.c(6.765e-17)) (*
integer library_binding = "analogLib";

 *)
c5714 ( TIMING_DN_ANLG, \25:VDDTX  );
capacitor #(.c(1.398e-15)) (*
integer library_binding = "analogLib";

 *)
c5715 ( TIMING_DN_ANLG, \5:PHASE_IN(7)  );
capacitor #(.c(4.722e-16)) (*
integer library_binding = "analogLib";

 *)
c5716 ( TIMING_DN_ANLG, \7:PHASE_IN(7)  );
capacitor #(.c(3.915e-18)) (*
integer library_binding = "analogLib";

 *)
c5717 ( \5:TIMING_DN_ANLG , \3:MR_SQUELCH_DISB_2p5  );
capacitor #(.c(7.059e-18)) (*
integer library_binding = "analogLib";

 *)
c5718 ( \5:TIMING_DN_ANLG , MR_SQUELCH_DISB_2p5 );
capacitor #(.c(4.164e-17)) (*
integer library_binding = "analogLib";

 *)
c5719 ( \5:TIMING_DN_ANLG , \25:VDDTX  );
capacitor #(.c(2.906e-16)) (*
integer library_binding = "analogLib";

 *)
c5720 ( \5:TIMING_DN_ANLG , \7:PHASE_IN(7)  );
capacitor #(.c(2.656e-18)) (*
integer library_binding = "analogLib";

 *)
c5721 ( \5:TIMING_DN_ANLG , \5:ADC_DIS_2p5  );
capacitor #(.c(3.658e-18)) (*
integer library_binding = "analogLib";

 *)
c5722 ( \5:TIMING_DN_ANLG , RX10_PRESENT_2p5 );
capacitor #(.c(1.591e-17)) (*
integer library_binding = "analogLib";

 *)
c5723 ( \5:TIMING_DN_ANLG , ADC_DIS_2p5 );
capacitor #(.c(1.502e-17)) (*
integer library_binding = "analogLib";

 *)
c5724 ( \5:TIMING_DN_ANLG , \6:RX10_PRESENT_2p5  );
capacitor #(.c(1.868e-17)) (*
integer library_binding = "analogLib";

 *)
c5725 ( \5:TIMING_DN_ANLG , \2:I_REXT_50(0)  );
capacitor #(.c(9.737e-16)) (*
integer library_binding = "analogLib";

 *)
c5726 ( \5:TIMING_DN_ANLG , \5:PHASE_IN(7)  );
capacitor #(.c(1.024e-17)) (*
integer library_binding = "analogLib";

 *)
c5727 ( MR_SQUELCH_DISB_2p5, \PHASE_250(8)  );
capacitor #(.c(1.651e-17)) (*
integer library_binding = "analogLib";

 *)
c5728 ( MR_SQUELCH_DISB_2p5, \4:PHASE_250(8)  );
capacitor #(.c(1.239e-17)) (*
integer library_binding = "analogLib";

 *)
c5729 ( MR_SQUELCH_DISB_2p5, \PHASE_250(6)  );
capacitor #(.c(1.207e-17)) (*
integer library_binding = "analogLib";

 *)
c5730 ( MR_SQUELCH_DISB_2p5, \4:PHASE_250(6)  );
capacitor #(.c(1.066e-17)) (*
integer library_binding = "analogLib";

 *)
c5731 ( MR_SQUELCH_DISB_2p5, \PHASE_250(10)  );
capacitor #(.c(5.854e-18)) (*
integer library_binding = "analogLib";

 *)
c5732 ( MR_SQUELCH_DISB_2p5, \4:PHASE_250(4)  );
capacitor #(.c(2.046e-17)) (*
integer library_binding = "analogLib";

 *)
c5733 ( MR_SQUELCH_DISB_2p5, \PHASE_250(4)  );
capacitor #(.c(1.334e-17)) (*
integer library_binding = "analogLib";

 *)
c5734 ( MR_SQUELCH_DISB_2p5, \4:PHASE_250(10)  );
capacitor #(.c(1.815e-17)) (*
integer library_binding = "analogLib";

 *)
c5735 ( MR_SQUELCH_DISB_2p5, \2:I_REXT_50(0)  );
capacitor #(.c(1.677e-19)) (*
integer library_binding = "analogLib";

 *)
c5736 ( \3:MR_SQUELCH_DISB_2p5 , MR_BYPASS10RX_FILTER );
capacitor #(.c(7.617e-18)) (*
integer library_binding = "analogLib";

 *)
c5737 ( \3:MR_SQUELCH_DISB_2p5 , \5:MR_BYPASS10RX_FILTER  );
capacitor #(.c(5.404e-18)) (*
integer library_binding = "analogLib";

 *)
c5738 ( \3:MR_SQUELCH_DISB_2p5 , \PHASE_250(10)  );
capacitor #(.c(5.404e-18)) (*
integer library_binding = "analogLib";

 *)
c5739 ( \3:MR_SQUELCH_DISB_2p5 , \PHASE_250(8)  );
capacitor #(.c(1.682e-18)) (*
integer library_binding = "analogLib";

 *)
c5740 ( \3:MR_SQUELCH_DISB_2p5 , \PHASE_250(4)  );
capacitor #(.c(1.451e-18)) (*
integer library_binding = "analogLib";

 *)
c5741 ( \3:MR_SQUELCH_DISB_2p5 , \PHASE_250(6)  );
capacitor #(.c(1.276e-17)) (*
integer library_binding = "analogLib";

 *)
c5742 ( \4:I_REXT_100(3) , \7:I_REXT_50(0)  );
capacitor #(.c(1.492e-17)) (*
integer library_binding = "analogLib";

 *)
c5743 ( TP_DISC_2p5, \4:PHASE_250(8)  );
capacitor #(.c(1.309e-17)) (*
integer library_binding = "analogLib";

 *)
c5744 ( TP_DISC_2p5, \PHASE_250(8)  );
capacitor #(.c(4.069e-19)) (*
integer library_binding = "analogLib";

 *)
c5745 ( TP_DISC_2p5, \MLT3_TDATA_2p5(1)  );
capacitor #(.c(4.773e-17)) (*
integer library_binding = "analogLib";

 *)
c5746 ( TP_DISC_2p5, \4:MLT3_TDATA_2p5(1)  );
capacitor #(.c(2.197e-17)) (*
integer library_binding = "analogLib";

 *)
c5747 ( TP_DISC_2p5, \PHASE_250(4)  );
capacitor #(.c(1.84e-17)) (*
integer library_binding = "analogLib";

 *)
c5748 ( TP_DISC_2p5, \4:PHASE_250(4)  );
capacitor #(.c(2.697e-17)) (*
integer library_binding = "analogLib";

 *)
c5749 ( TP_DISC_2p5, \PHASE_250(10)  );
capacitor #(.c(2.952e-17)) (*
integer library_binding = "analogLib";

 *)
c5750 ( TP_DISC_2p5, \4:PHASE_250(10)  );
capacitor #(.c(2.47e-17)) (*
integer library_binding = "analogLib";

 *)
c5751 ( TP_DISC_2p5, \4:PHASE_250(6)  );
capacitor #(.c(2.747e-17)) (*
integer library_binding = "analogLib";

 *)
c5752 ( TP_DISC_2p5, \PHASE_250(6)  );
capacitor #(.c(1.923e-16)) (*
integer library_binding = "analogLib";

 *)
c5753 ( TP_DISC_2p5, \25:VDDTX  );
capacitor #(.c(3.663e-17)) (*
integer library_binding = "analogLib";

 *)
c5754 ( TP_DISC_2p5, \24:VDDTX  );
capacitor #(.c(7.037e-20)) (*
integer library_binding = "analogLib";

 *)
c5755 ( \3:TP_DISC_2p5 , \4:PHASE_250(8)  );
capacitor #(.c(6.176e-20)) (*
integer library_binding = "analogLib";

 *)
c5756 ( \3:TP_DISC_2p5 , \PHASE_250(8)  );
capacitor #(.c(6.081e-19)) (*
integer library_binding = "analogLib";

 *)
c5757 ( \3:TP_DISC_2p5 , \4:MLT3_TDATA_2p5(1)  );
capacitor #(.c(2.799e-19)) (*
integer library_binding = "analogLib";

 *)
c5758 ( \3:TP_DISC_2p5 , \PHASE_250(4)  );
capacitor #(.c(2.345e-19)) (*
integer library_binding = "analogLib";

 *)
c5759 ( \3:TP_DISC_2p5 , \4:PHASE_250(4)  );
capacitor #(.c(3.436e-19)) (*
integer library_binding = "analogLib";

 *)
c5760 ( \3:TP_DISC_2p5 , \PHASE_250(10)  );
capacitor #(.c(3.761e-19)) (*
integer library_binding = "analogLib";

 *)
c5761 ( \3:TP_DISC_2p5 , \4:PHASE_250(10)  );
capacitor #(.c(3.146e-19)) (*
integer library_binding = "analogLib";

 *)
c5762 ( \3:TP_DISC_2p5 , \4:PHASE_250(6)  );
capacitor #(.c(3.499e-19)) (*
integer library_binding = "analogLib";

 *)
c5763 ( \3:TP_DISC_2p5 , \PHASE_250(6)  );
capacitor #(.c(8.87e-17)) (*
integer library_binding = "analogLib";

 *)
c5764 ( \3:TP_DISC_2p5 , \24:VDDTX  );
capacitor #(.c(4.657e-16)) (*
integer library_binding = "analogLib";

 *)
c5765 ( \3:TP_DISC_2p5 , \25:VDDTX  );
capacitor #(.c(1.177e-18)) (*
integer library_binding = "analogLib";

 *)
c5766 ( T2_MODE, \5:AEQ_CNT_ANLG(4)  );
capacitor #(.c(1.76e-17)) (*
integer library_binding = "analogLib";

 *)
c5767 ( T2_MODE, \6:I_REXT_50(0)  );
capacitor #(.c(1.707e-18)) (*
integer library_binding = "analogLib";

 *)
c5768 ( T2_MODE, \2:I_REXT_50(0)  );
capacitor #(.c(1.304e-17)) (*
integer library_binding = "analogLib";

 *)
c5769 ( T2_MODE, \5:ADC_DIS_2p5  );
capacitor #(.c(1.302e-19)) (*
integer library_binding = "analogLib";

 *)
c5770 ( T2_MODE, ADC_DIS_2p5 );
capacitor #(.c(1.595e-16)) (*
integer library_binding = "analogLib";

 *)
c5771 ( T2_MODE, \AEQ_CNT_ANLG(4)  );
capacitor #(.c(1.54e-20)) (*
integer library_binding = "analogLib";

 *)
c5772 ( \6:T2_MODE , \5:AEQ_CNT_ANLG(4)  );
capacitor #(.c(9.178e-19)) (*
integer library_binding = "analogLib";

 *)
c5773 ( \6:T2_MODE , \AEQ_CNT_ANLG(4)  );
capacitor #(.c(4.012e-19)) (*
integer library_binding = "analogLib";

 *)
c5774 ( \6:T2_MODE , \6:I_REXT_50(0)  );
capacitor #(.c(3.891e-20)) (*
integer library_binding = "analogLib";

 *)
c5775 ( \6:T2_MODE , \2:I_REXT_50(0)  );
capacitor #(.c(3.152e-16)) (*
integer library_binding = "analogLib";

 *)
c5776 ( \6:T2_MODE , \24:VDDTX  );
capacitor #(.c(1.655e-15)) (*
integer library_binding = "analogLib";

 *)
c5777 ( \6:T2_MODE , \25:VDDTX  );
capacitor #(.c(5.792e-18)) (*
integer library_binding = "analogLib";

 *)
c5778 ( \PHASE_250(10) , \4:PHASE_250(8)  );
capacitor #(.c(5.083e-18)) (*
integer library_binding = "analogLib";

 *)
c5779 ( \PHASE_250(10) , \PHASE_250(8)  );
capacitor #(.c(4.33e-19)) (*
integer library_binding = "analogLib";

 *)
c5780 ( \PHASE_250(10) , \MLT3_TDATA_2p5(1)  );
capacitor #(.c(4.26e-19)) (*
integer library_binding = "analogLib";

 *)
c5781 ( \PHASE_250(10) , \5:ADC_DIS_2p5  );
capacitor #(.c(3.654e-19)) (*
integer library_binding = "analogLib";

 *)
c5782 ( \PHASE_250(10) , RX10_PRESENT_2p5 );
capacitor #(.c(3.268e-16)) (*
integer library_binding = "analogLib";

 *)
c5783 ( \PHASE_250(10) , \PHASE_250(6)  );
capacitor #(.c(1.612e-17)) (*
integer library_binding = "analogLib";

 *)
c5784 ( \PHASE_250(10) , ADC_DIS_2p5 );
capacitor #(.c(3.509e-16)) (*
integer library_binding = "analogLib";

 *)
c5785 ( \PHASE_250(10) , \4:PHASE_250(6)  );
capacitor #(.c(1.032e-17)) (*
integer library_binding = "analogLib";

 *)
c5786 ( \PHASE_250(10) , \2:I_REXT_50(0)  );
capacitor #(.c(5.079e-17)) (*
integer library_binding = "analogLib";

 *)
c5787 ( \PHASE_250(10) , \4:MLT3_TDATA_2p5(1)  );
capacitor #(.c(1.086e-17)) (*
integer library_binding = "analogLib";

 *)
c5788 ( \PHASE_250(10) , \6:RX10_PRESENT_2p5  );
capacitor #(.c(4.817e-18)) (*
integer library_binding = "analogLib";

 *)
c5789 ( \PHASE_250(10) , \4:PHASE_250(4)  );
capacitor #(.c(4.671e-18)) (*
integer library_binding = "analogLib";

 *)
c5790 ( \PHASE_250(10) , \PHASE_250(4)  );
capacitor #(.c(6.062e-18)) (*
integer library_binding = "analogLib";

 *)
c5791 ( \4:PHASE_250(10) , \PHASE_250(8)  );
capacitor #(.c(4.739e-19)) (*
integer library_binding = "analogLib";

 *)
c5792 ( \4:PHASE_250(10) , \MLT3_TDATA_2p5(1)  );
capacitor #(.c(4.663e-19)) (*
integer library_binding = "analogLib";

 *)
c5793 ( \4:PHASE_250(10) , \5:ADC_DIS_2p5  );
capacitor #(.c(2.285e-17)) (*
integer library_binding = "analogLib";

 *)
c5794 ( \4:PHASE_250(10) , \4:PHASE_250(8)  );
capacitor #(.c(3.999e-19)) (*
integer library_binding = "analogLib";

 *)
c5795 ( \4:PHASE_250(10) , RX10_PRESENT_2p5 );
capacitor #(.c(6.608e-16)) (*
integer library_binding = "analogLib";

 *)
c5796 ( \4:PHASE_250(10) , \PHASE_250(6)  );
capacitor #(.c(1.764e-17)) (*
integer library_binding = "analogLib";

 *)
c5797 ( \4:PHASE_250(10) , ADC_DIS_2p5 );
capacitor #(.c(1.429e-15)) (*
integer library_binding = "analogLib";

 *)
c5798 ( \4:PHASE_250(10) , \4:PHASE_250(6)  );
capacitor #(.c(1.129e-17)) (*
integer library_binding = "analogLib";

 *)
c5799 ( \4:PHASE_250(10) , \2:I_REXT_50(0)  );
capacitor #(.c(5.559e-17)) (*
integer library_binding = "analogLib";

 *)
c5800 ( \4:PHASE_250(10) , \4:MLT3_TDATA_2p5(1)  );
capacitor #(.c(5.873e-18)) (*
integer library_binding = "analogLib";

 *)
c5801 ( \4:PHASE_250(10) , \PHASE_250(4)  );
capacitor #(.c(1.815e-17)) (*
integer library_binding = "analogLib";

 *)
c5802 ( \4:PHASE_250(10) , \4:PHASE_250(4)  );
capacitor #(.c(2.423e-17)) (*
integer library_binding = "analogLib";

 *)
c5803 ( \4:PHASE_250(10) , \6:RX10_PRESENT_2p5  );
capacitor #(.c(3.346e-17)) (*
integer library_binding = "analogLib";

 *)
c5804 ( \PHASE_IN(7) , \PHASE_IN(5)  );
capacitor #(.c(1.295e-17)) (*
integer library_binding = "analogLib";

 *)
c5805 ( \3:PHASE_IN(7) , RESET_10BT );
capacitor #(.c(3.182e-18)) (*
integer library_binding = "analogLib";

 *)
c5806 ( \3:PHASE_IN(7) , TENBT_CLK160_1p0 );
capacitor #(.c(1.73e-17)) (*
integer library_binding = "analogLib";

 *)
c5807 ( \3:PHASE_IN(7) , \6:TENBT_CLK160_1p0  );
capacitor #(.c(1.967e-18)) (*
integer library_binding = "analogLib";

 *)
c5808 ( \3:PHASE_IN(7) , \5:RESET_10BT  );
capacitor #(.c(2.459e-14)) (*
integer library_binding = "analogLib";

 *)
c5809 ( \3:PHASE_IN(7) , \1:PHASE_IN(5)  );
capacitor #(.c(6.704e-16)) (*
integer library_binding = "analogLib";

 *)
c5810 ( \3:PHASE_IN(7) , \2:PHASE_IN(5)  );
capacitor #(.c(5.088e-15)) (*
integer library_binding = "analogLib";

 *)
c5811 ( \5:PHASE_IN(7) , \MLT3_TDATA_2p5(1)  );
capacitor #(.c(3.768e-17)) (*
integer library_binding = "analogLib";

 *)
c5812 ( \5:PHASE_IN(7) , \24:VDDTX  );
capacitor #(.c(2.024e-18)) (*
integer library_binding = "analogLib";

 *)
c5813 ( \5:PHASE_IN(7) , \5:PHASE_IN(5)  );
capacitor #(.c(2.231e-16)) (*
integer library_binding = "analogLib";

 *)
c5814 ( \5:PHASE_IN(7) , \25:VDDTX  );
capacitor #(.c(5.221e-15)) (*
integer library_binding = "analogLib";

 *)
c5815 ( \5:PHASE_IN(7) , \4:MLT3_TDATA_2p5(1)  );
capacitor #(.c(2.443e-14)) (*
integer library_binding = "analogLib";

 *)
c5816 ( \5:PHASE_IN(7) , \2:PHASE_IN(5)  );
capacitor #(.c(9.845e-18)) (*
integer library_binding = "analogLib";

 *)
c5817 ( \7:PHASE_IN(7) , \5:PHASE_IN(5)  );
capacitor #(.c(1.229e-16)) (*
integer library_binding = "analogLib";

 *)
c5818 ( \7:PHASE_IN(7) , \25:VDDTX  );
capacitor #(.c(1.656e-17)) (*
integer library_binding = "analogLib";

 *)
c5819 ( \AEQ_CNT_ANLG(4) , \4:AEQ_CNT_ANLG(0)  );
capacitor #(.c(1.577e-18)) (*
integer library_binding = "analogLib";

 *)
c5820 ( \AEQ_CNT_ANLG(4) , \2:I_REXT_50(0)  );
capacitor #(.c(1.458e-18)) (*
integer library_binding = "analogLib";

 *)
c5821 ( \AEQ_CNT_ANLG(4) , \6:RX10_PRESENT_2p5  );
capacitor #(.c(1.815e-18)) (*
integer library_binding = "analogLib";

 *)
c5822 ( \AEQ_CNT_ANLG(4) , \AEQ_CNT_ANLG(0)  );
capacitor #(.c(1.387e-17)) (*
integer library_binding = "analogLib";

 *)
c5823 ( \AEQ_CNT_ANLG(4) , RX10_PRESENT_2p5 );
capacitor #(.c(5.764e-17)) (*
integer library_binding = "analogLib";

 *)
c5824 ( \AEQ_CNT_ANLG(4) , \25:VDDTX  );
capacitor #(.c(1.098e-17)) (*
integer library_binding = "analogLib";

 *)
c5825 ( \AEQ_CNT_ANLG(4) , \24:VDDTX  );
capacitor #(.c(1.281e-19)) (*
integer library_binding = "analogLib";

 *)
c5826 ( \AEQ_CNT_ANLG(4) , ADC_DIS_2p5 );
capacitor #(.c(1.282e-17)) (*
integer library_binding = "analogLib";

 *)
c5827 ( \AEQ_CNT_ANLG(4) , \5:ADC_DIS_2p5  );
capacitor #(.c(2.152e-19)) (*
integer library_binding = "analogLib";

 *)
c5828 ( \5:AEQ_CNT_ANLG(4) , \5:ADC_DIS_2p5  );
capacitor #(.c(1.022e-16)) (*
integer library_binding = "analogLib";

 *)
c5829 ( \5:AEQ_CNT_ANLG(4) , \24:VDDTX  );
capacitor #(.c(5.367e-16)) (*
integer library_binding = "analogLib";

 *)
c5830 ( \5:AEQ_CNT_ANLG(4) , \25:VDDTX  );
capacitor #(.c(2.847e-18)) (*
integer library_binding = "analogLib";

 *)
c5831 ( \5:AEQ_CNT_ANLG(4) , RX10_PRESENT_2p5 );
capacitor #(.c(1.69e-17)) (*
integer library_binding = "analogLib";

 *)
c5832 ( \5:AEQ_CNT_ANLG(4) , \AEQ_CNT_ANLG(0)  );
capacitor #(.c(1.509e-18)) (*
integer library_binding = "analogLib";

 *)
c5833 ( \5:AEQ_CNT_ANLG(4) , \4:AEQ_CNT_ANLG(0)  );
capacitor #(.c(1.076e-17)) (*
integer library_binding = "analogLib";

 *)
c5834 ( \5:AEQ_CNT_ANLG(4) , \6:RX10_PRESENT_2p5  );
capacitor #(.c(1.468e-17)) (*
integer library_binding = "analogLib";

 *)
c5835 ( \5:AEQ_CNT_ANLG(4) , \2:I_REXT_50(0)  );
capacitor #(.c(1.754e-17)) (*
integer library_binding = "analogLib";

 *)
c5836 ( \PHASE_250(8) , ADC_DIS_2p5 );
capacitor #(.c(1.493e-17)) (*
integer library_binding = "analogLib";

 *)
c5837 ( \PHASE_250(8) , \4:MLT3_TDATA_2p5(1)  );
capacitor #(.c(1.01e-17)) (*
integer library_binding = "analogLib";

 *)
c5838 ( \PHASE_250(8) , \2:I_REXT_50(0)  );
capacitor #(.c(1.024e-17)) (*
integer library_binding = "analogLib";

 *)
c5839 ( \PHASE_250(8) , \6:RX10_PRESENT_2p5  );
capacitor #(.c(3.577e-19)) (*
integer library_binding = "analogLib";

 *)
c5840 ( \PHASE_250(8) , RX10_PRESENT_2p5 );
capacitor #(.c(2.456e-19)) (*
integer library_binding = "analogLib";

 *)
c5841 ( \PHASE_250(8) , \5:ADC_DIS_2p5  );
capacitor #(.c(5.699e-20)) (*
integer library_binding = "analogLib";

 *)
c5842 ( \PHASE_250(8) , \MLT3_TDATA_2p5(1)  );
capacitor #(.c(1.998e-17)) (*
integer library_binding = "analogLib";

 *)
c5843 ( \4:PHASE_250(8) , ADC_DIS_2p5 );
capacitor #(.c(1.701e-17)) (*
integer library_binding = "analogLib";

 *)
c5844 ( \4:PHASE_250(8) , \4:MLT3_TDATA_2p5(1)  );
capacitor #(.c(1.151e-17)) (*
integer library_binding = "analogLib";

 *)
c5845 ( \4:PHASE_250(8) , \2:I_REXT_50(0)  );
capacitor #(.c(4.076e-19)) (*
integer library_binding = "analogLib";

 *)
c5846 ( \4:PHASE_250(8) , RX10_PRESENT_2p5 );
capacitor #(.c(2.799e-19)) (*
integer library_binding = "analogLib";

 *)
c5847 ( \4:PHASE_250(8) , \5:ADC_DIS_2p5  );
capacitor #(.c(6.494e-20)) (*
integer library_binding = "analogLib";

 *)
c5848 ( \4:PHASE_250(8) , \MLT3_TDATA_2p5(1)  );
capacitor #(.c(2.761e-17)) (*
integer library_binding = "analogLib";

 *)
c5849 ( \4:PHASE_250(8) , \6:RX10_PRESENT_2p5  );
capacitor #(.c(2.53e-19)) (*
integer library_binding = "analogLib";

 *)
c5850 ( \MLT3_TDATA_2p5(1) , \PHASE_250(4)  );
capacitor #(.c(2.119e-19)) (*
integer library_binding = "analogLib";

 *)
c5851 ( \MLT3_TDATA_2p5(1) , \4:PHASE_250(4)  );
capacitor #(.c(3.104e-19)) (*
integer library_binding = "analogLib";

 *)
c5852 ( \MLT3_TDATA_2p5(1) , \4:PHASE_250(6)  );
capacitor #(.c(3.453e-19)) (*
integer library_binding = "analogLib";

 *)
c5853 ( \MLT3_TDATA_2p5(1) , \PHASE_250(6)  );
capacitor #(.c(8.928e-17)) (*
integer library_binding = "analogLib";

 *)
c5854 ( \MLT3_TDATA_2p5(1) , \24:VDDTX  );
capacitor #(.c(4.688e-16)) (*
integer library_binding = "analogLib";

 *)
c5855 ( \MLT3_TDATA_2p5(1) , \25:VDDTX  );
capacitor #(.c(3.712e-17)) (*
integer library_binding = "analogLib";

 *)
c5856 ( \4:MLT3_TDATA_2p5(1) , \24:VDDTX  );
capacitor #(.c(1.949e-16)) (*
integer library_binding = "analogLib";

 *)
c5857 ( \4:MLT3_TDATA_2p5(1) , \25:VDDTX  );
capacitor #(.c(4.05e-17)) (*
integer library_binding = "analogLib";

 *)
c5858 ( \4:MLT3_TDATA_2p5(1) , \PHASE_250(6)  );
capacitor #(.c(3.642e-17)) (*
integer library_binding = "analogLib";

 *)
c5859 ( \4:MLT3_TDATA_2p5(1) , \4:PHASE_250(6)  );
capacitor #(.c(2.486e-17)) (*
integer library_binding = "analogLib";

 *)
c5860 ( \4:MLT3_TDATA_2p5(1) , \4:PHASE_250(4)  );
capacitor #(.c(2.968e-17)) (*
integer library_binding = "analogLib";

 *)
c5861 ( \4:MLT3_TDATA_2p5(1) , \PHASE_250(4)  );
capacitor #(.c(8.618e-17)) (*
integer library_binding = "analogLib";

 *)
c5862 ( \25:VDDTX , \WANDER_CNT(2)  );
capacitor #(.c(1.748e-15)) (*
integer library_binding = "analogLib";

 *)
c5863 ( \25:VDDTX , \5:WANDER_CNT(2)  );
capacitor #(.c(5.058e-17)) (*
integer library_binding = "analogLib";

 *)
c5864 ( \25:VDDTX , \5:PHASE_IN(5)  );
capacitor #(.c(9.062e-17)) (*
integer library_binding = "analogLib";

 *)
c5865 ( \25:VDDTX , MR_BYPASS10RX_FILTER );
capacitor #(.c(2.293e-16)) (*
integer library_binding = "analogLib";

 *)
c5866 ( \25:VDDTX , \2:PHASE_IN(5)  );
capacitor #(.c(1.639e-16)) (*
integer library_binding = "analogLib";

 *)
c5867 ( \25:VDDTX , \6:RX10_PRESENT_2p5  );
capacitor #(.c(1.443e-16)) (*
integer library_binding = "analogLib";

 *)
c5868 ( \25:VDDTX , \4:AEQ_CNT_ANLG(0)  );
capacitor #(.c(1.977e-15)) (*
integer library_binding = "analogLib";

 *)
c5869 ( \25:VDDTX , \AEQ_CNT_ANLG(0)  );
capacitor #(.c(3.991e-17)) (*
integer library_binding = "analogLib";

 *)
c5870 ( \25:VDDTX , RX10_PRESENT_2p5 );
capacitor #(.c(1.642e-17)) (*
integer library_binding = "analogLib";

 *)
c5871 ( \24:VDDTX , \WANDER_CNT(2)  );
capacitor #(.c(3.33e-16)) (*
integer library_binding = "analogLib";

 *)
c5872 ( \24:VDDTX , \5:WANDER_CNT(2)  );
capacitor #(.c(9.635e-18)) (*
integer library_binding = "analogLib";

 *)
c5873 ( \24:VDDTX , \5:PHASE_IN(5)  );
capacitor #(.c(1.726e-17)) (*
integer library_binding = "analogLib";

 *)
c5874 ( \24:VDDTX , MR_BYPASS10RX_FILTER );
capacitor #(.c(4.368e-17)) (*
integer library_binding = "analogLib";

 *)
c5875 ( \24:VDDTX , \2:PHASE_IN(5)  );
capacitor #(.c(3.122e-17)) (*
integer library_binding = "analogLib";

 *)
c5876 ( \24:VDDTX , \6:RX10_PRESENT_2p5  );
capacitor #(.c(2.748e-17)) (*
integer library_binding = "analogLib";

 *)
c5877 ( \24:VDDTX , \4:AEQ_CNT_ANLG(0)  );
capacitor #(.c(3.765e-16)) (*
integer library_binding = "analogLib";

 *)
c5878 ( \24:VDDTX , \AEQ_CNT_ANLG(0)  );
capacitor #(.c(7.601e-18)) (*
integer library_binding = "analogLib";

 *)
c5879 ( \24:VDDTX , RX10_PRESENT_2p5 );
capacitor #(.c(5.561e-16)) (*
integer library_binding = "analogLib";

 *)
c5880 ( \24:VDDTX , TENBT_CLK160_1p0 );
capacitor #(.c(5.528e-16)) (*
integer library_binding = "analogLib";

 *)
c5881 ( \24:VDDTX , \5:RESET_10BT  );
capacitor #(.c(1.975e-17)) (*
integer library_binding = "analogLib";

 *)
c5882 ( \WANDER_CNT(2) , \6:I_REXT_50(0)  );
capacitor #(.c(1.915e-18)) (*
integer library_binding = "analogLib";

 *)
c5883 ( \WANDER_CNT(2) , \2:I_REXT_50(0)  );
capacitor #(.c(2.567e-15)) (*
integer library_binding = "analogLib";

 *)
c5884 ( \WANDER_CNT(2) , \4:AEQ_CNT_ANLG(0)  );
capacitor #(.c(3.214e-16)) (*
integer library_binding = "analogLib";

 *)
c5885 ( \WANDER_CNT(2) , \AEQ_CNT_ANLG(0)  );
capacitor #(.c(2.847e-15)) (*
integer library_binding = "analogLib";

 *)
c5886 ( \5:WANDER_CNT(2) , \4:AEQ_CNT_ANLG(0)  );
capacitor #(.c(4.272e-15)) (*
integer library_binding = "analogLib";

 *)
c5887 ( \5:WANDER_CNT(2) , \AEQ_CNT_ANLG(0)  );
capacitor #(.c(6.701e-20)) (*
integer library_binding = "analogLib";

 *)
c5888 ( \5:WANDER_CNT(2) , \2:I_REXT_50(0)  );
capacitor #(.c(6.91e-19)) (*
integer library_binding = "analogLib";

 *)
c5889 ( \5:WANDER_CNT(2) , \6:I_REXT_50(0)  );
capacitor #(.c(3.065e-18)) (*
integer library_binding = "analogLib";

 *)
c5890 ( \TEST_MODE(2) , \TX_SLOPETRIM_1p0(1)  );
capacitor #(.c(1.696e-17)) (*
integer library_binding = "analogLib";

 *)
c5891 ( \TEST_MODE(2) , \4:TX_SLOPETRIM_1p0(1)  );
capacitor #(.c(2.729e-18)) (*
integer library_binding = "analogLib";

 *)
c5892 ( \3:TEST_MODE(2) , \4:TX_SLOPETRIM_1p0(1)  );
capacitor #(.c(1.611e-17)) (*
integer library_binding = "analogLib";

 *)
c5893 ( \3:TEST_MODE(2) , \TX_SLOPETRIM_1p0(1)  );
capacitor #(.c(1.673e-19)) (*
integer library_binding = "analogLib";

 *)
c5894 ( RX10_PRESENT_2p5, MR_BYPASS10RX_FILTER );
capacitor #(.c(7.599e-18)) (*
integer library_binding = "analogLib";

 *)
c5895 ( RX10_PRESENT_2p5, \5:MR_BYPASS10RX_FILTER  );
capacitor #(.c(6.7e-15)) (*
integer library_binding = "analogLib";

 *)
c5896 ( RX10_PRESENT_2p5, \6:I_REXT_50(0)  );
capacitor #(.c(1.417e-17)) (*
integer library_binding = "analogLib";

 *)
c5897 ( RX10_PRESENT_2p5, \5:ADC_DIS_2p5  );
capacitor #(.c(4.384e-15)) (*
integer library_binding = "analogLib";

 *)
c5898 ( RX10_PRESENT_2p5, \2:I_REXT_50(0)  );
capacitor #(.c(2.747e-19)) (*
integer library_binding = "analogLib";

 *)
c5899 ( RX10_PRESENT_2p5, \4:PHASE_250(4)  );
capacitor #(.c(3.28e-19)) (*
integer library_binding = "analogLib";

 *)
c5900 ( RX10_PRESENT_2p5, \PHASE_250(4)  );
capacitor #(.c(2.313e-18)) (*
integer library_binding = "analogLib";

 *)
c5901 ( RX10_PRESENT_2p5, ADC_DIS_2p5 );
capacitor #(.c(3.389e-19)) (*
integer library_binding = "analogLib";

 *)
c5902 ( RX10_PRESENT_2p5, \4:PHASE_250(6)  );
capacitor #(.c(3.77e-19)) (*
integer library_binding = "analogLib";

 *)
c5903 ( RX10_PRESENT_2p5, \PHASE_250(6)  );
capacitor #(.c(1.492e-16)) (*
integer library_binding = "analogLib";

 *)
c5904 ( \6:RX10_PRESENT_2p5 , \6:I_REXT_50(0)  );
capacitor #(.c(1.492e-18)) (*
integer library_binding = "analogLib";

 *)
c5905 ( \6:RX10_PRESENT_2p5 , \5:ADC_DIS_2p5  );
capacitor #(.c(1.703e-17)) (*
integer library_binding = "analogLib";

 *)
c5906 ( \6:RX10_PRESENT_2p5 , \PHASE_250(6)  );
capacitor #(.c(1.531e-17)) (*
integer library_binding = "analogLib";

 *)
c5907 ( \6:RX10_PRESENT_2p5 , \4:PHASE_250(6)  );
capacitor #(.c(8.934e-18)) (*
integer library_binding = "analogLib";

 *)
c5908 ( \6:RX10_PRESENT_2p5 , ADC_DIS_2p5 );
capacitor #(.c(1.334e-17)) (*
integer library_binding = "analogLib";

 *)
c5909 ( \6:RX10_PRESENT_2p5 , \4:PHASE_250(4)  );
capacitor #(.c(1.592e-17)) (*
integer library_binding = "analogLib";

 *)
c5910 ( \6:RX10_PRESENT_2p5 , \PHASE_250(4)  );
capacitor #(.c(7.663e-15)) (*
integer library_binding = "analogLib";

 *)
c5911 ( \6:RX10_PRESENT_2p5 , \2:I_REXT_50(0)  );
capacitor #(.c(1.457e-17)) (*
integer library_binding = "analogLib";

 *)
c5912 ( \1:PHASE_IN(5) , RESET_10BT );
capacitor #(.c(4.162e-18)) (*
integer library_binding = "analogLib";

 *)
c5913 ( \1:PHASE_IN(5) , TENBT_CLK160_1p0 );
capacitor #(.c(2.263e-17)) (*
integer library_binding = "analogLib";

 *)
c5914 ( \1:PHASE_IN(5) , \6:TENBT_CLK160_1p0  );
capacitor #(.c(2.212e-18)) (*
integer library_binding = "analogLib";

 *)
c5915 ( \1:PHASE_IN(5) , \5:RESET_10BT  );
capacitor #(.c(1.047e-18)) (*
integer library_binding = "analogLib";

 *)
c5916 ( \PHASE_250(6) , \5:ADC_DIS_2p5  );
capacitor #(.c(1.874e-17)) (*
integer library_binding = "analogLib";

 *)
c5917 ( \PHASE_250(6) , \2:I_REXT_50(0)  );
capacitor #(.c(3.549e-16)) (*
integer library_binding = "analogLib";

 *)
c5918 ( \PHASE_250(6) , \PHASE_250(4)  );
capacitor #(.c(3.577e-16)) (*
integer library_binding = "analogLib";

 *)
c5919 ( \PHASE_250(6) , \4:PHASE_250(4)  );
capacitor #(.c(3.962e-17)) (*
integer library_binding = "analogLib";

 *)
c5920 ( \PHASE_250(6) , ADC_DIS_2p5 );
capacitor #(.c(9.415e-19)) (*
integer library_binding = "analogLib";

 *)
c5921 ( \4:PHASE_250(6) , \5:ADC_DIS_2p5  );
capacitor #(.c(1.685e-17)) (*
integer library_binding = "analogLib";

 *)
c5922 ( \4:PHASE_250(6) , \2:I_REXT_50(0)  );
capacitor #(.c(3.562e-17)) (*
integer library_binding = "analogLib";

 *)
c5923 ( \4:PHASE_250(6) , ADC_DIS_2p5 );
capacitor #(.c(1.341e-15)) (*
integer library_binding = "analogLib";

 *)
c5924 ( \4:PHASE_250(6) , \4:PHASE_250(4)  );
capacitor #(.c(4.761e-16)) (*
integer library_binding = "analogLib";

 *)
c5925 ( \4:PHASE_250(6) , \PHASE_250(4)  );
capacitor #(.c(2.698e-18)) (*
integer library_binding = "analogLib";

 *)
c5926 ( SLICER_OUT_1p0, \4:MLT3_TDATA_1p0(0)  );
capacitor #(.c(3.289e-16)) (*
integer library_binding = "analogLib";

 *)
c5927 ( SLICER_OUT_1p0, \TX_SLOPETRIM_1p0(1)  );
capacitor #(.c(1.5e-17)) (*
integer library_binding = "analogLib";

 *)
c5928 ( SLICER_OUT_1p0, \MLT3_TDATA_1p0(0)  );
capacitor #(.c(3.57e-16)) (*
integer library_binding = "analogLib";

 *)
c5929 ( SLICER_OUT_1p0, \4:TX_SLOPETRIM_1p0(1)  );
capacitor #(.c(4.25e-19)) (*
integer library_binding = "analogLib";

 *)
c5930 ( SLICER_OUT_1p0, \MR_SQUELCH_RANGE_1p0(0)  );
capacitor #(.c(1.82e-17)) (*
integer library_binding = "analogLib";

 *)
c5931 ( SLICER_OUT_1p0, \3:MR_SQUELCH_RANGE_1p0(0)  );
capacitor #(.c(1.858e-17)) (*
integer library_binding = "analogLib";

 *)
c5932 ( \4:SLICER_OUT_1p0 , \4:MLT3_TDATA_1p0(0)  );
capacitor #(.c(6.111e-17)) (*
integer library_binding = "analogLib";

 *)
c5933 ( \4:SLICER_OUT_1p0 , \TX_SLOPETRIM_1p0(1)  );
capacitor #(.c(2.874e-18)) (*
integer library_binding = "analogLib";

 *)
c5934 ( \4:SLICER_OUT_1p0 , \MLT3_TDATA_1p0(0)  );
capacitor #(.c(4.917e-16)) (*
integer library_binding = "analogLib";

 *)
c5935 ( \4:SLICER_OUT_1p0 , \4:TX_SLOPETRIM_1p0(1)  );
capacitor #(.c(1.853e-17)) (*
integer library_binding = "analogLib";

 *)
c5936 ( \4:SLICER_OUT_1p0 , \MR_SQUELCH_RANGE_1p0(0)  );
capacitor #(.c(5.813e-19)) (*
integer library_binding = "analogLib";

 *)
c5937 ( \MLT3_TDATA_1p0(0) , \MR_SQUELCH_RANGE_1p0(0)  );
capacitor #(.c(1.82e-17)) (*
integer library_binding = "analogLib";

 *)
c5938 ( \MLT3_TDATA_1p0(0) , \3:MR_SQUELCH_RANGE_1p0(0)  );
capacitor #(.c(2.198e-17)) (*
integer library_binding = "analogLib";

 *)
c5939 ( \4:MLT3_TDATA_1p0(0) , \MR_SQUELCH_RANGE_1p0(0)  );
capacitor #(.c(1.34e-18)) (*
integer library_binding = "analogLib";

 *)
c5940 ( \2:I_REXT_50(0) , \4:AEQ_CNT_ANLG(0)  );
capacitor #(.c(2.674e-18)) (*
integer library_binding = "analogLib";

 *)
c5941 ( \2:I_REXT_50(0) , \5:ADC_DIS_2p5  );
capacitor #(.c(1.601e-17)) (*
integer library_binding = "analogLib";

 *)
c5942 ( \2:I_REXT_50(0) , ADC_DIS_2p5 );
capacitor #(.c(9.848e-18)) (*
integer library_binding = "analogLib";

 *)
c5943 ( \2:I_REXT_50(0) , \4:PHASE_250(4)  );
capacitor #(.c(1.176e-17)) (*
integer library_binding = "analogLib";

 *)
c5944 ( \2:I_REXT_50(0) , \PHASE_250(4)  );
capacitor #(.c(1.382e-17)) (*
integer library_binding = "analogLib";

 *)
c5945 ( \6:I_REXT_50(0) , \4:AEQ_CNT_ANLG(0)  );
capacitor #(.c(1.471e-19)) (*
integer library_binding = "analogLib";

 *)
c5946 ( ADC_DIS_2p5, \4:AEQ_CNT_ANLG(0)  );
capacitor #(.c(4.74e-17)) (*
integer library_binding = "analogLib";

 *)
c5947 ( ADC_DIS_2p5, \PHASE_250(4)  );
capacitor #(.c(3.97e-17)) (*
integer library_binding = "analogLib";

 *)
c5948 ( ADC_DIS_2p5, \4:PHASE_250(4)  );
capacitor #(.c(1.473e-17)) (*
integer library_binding = "analogLib";

 *)
c5949 ( \5:ADC_DIS_2p5 , \4:AEQ_CNT_ANLG(0)  );
capacitor #(.c(1.253e-18)) (*
integer library_binding = "analogLib";

 *)
c5950 ( \5:ADC_DIS_2p5 , \PHASE_250(4)  );
capacitor #(.c(1.049e-18)) (*
integer library_binding = "analogLib";

 *)
c5951 ( \5:ADC_DIS_2p5 , \4:PHASE_250(4)  );
capacitor #(.c(2.836e-18)) (*
integer library_binding = "analogLib";

 *)
c5952 ( NEG_DETECT_1p0, \3:MR_SQUELCH_RANGE_1p0(0)  );
capacitor #(.c(1.441e-17)) (*
integer library_binding = "analogLib";

 *)
c5953 ( NEG_DETECT_1p0, \MR_SQUELCH_RANGE_1p0(0)  );
capacitor #(.c(1.817e-17)) (*
integer library_binding = "analogLib";

 *)
c5954 ( \3:NEG_DETECT_1p0 , \3:MR_SQUELCH_RANGE_1p0(0)  );
capacitor #(.c(2.431e-18)) (*
integer library_binding = "analogLib";

 *)
c5955 ( \3:NEG_DETECT_1p0 , \MR_SQUELCH_RANGE_1p0(0)  );
capacitor #(.c(2.855e-18)) (*
integer library_binding = "analogLib";

 *)
c5956 ( POS_DETECT_1p0, \3:MR_SQUELCH_RANGE_1p0(0)  );
capacitor #(.c(1.701e-17)) (*
integer library_binding = "analogLib";

 *)
c5957 ( POS_DETECT_1p0, \MR_SQUELCH_RANGE_1p0(0)  );
capacitor #(.c(2.335e-18)) (*
integer library_binding = "analogLib";

 *)
c5958 ( \3:POS_DETECT_1p0 , \MR_SQUELCH_RANGE_1p0(0)  );
capacitor #(.c(1.857e-17)) (*
integer library_binding = "analogLib";

 *)
c5959 ( \3:POS_DETECT_1p0 , \3:MR_SQUELCH_RANGE_1p0(0)  );

endmodule
