// Verilog-AMS netlist generated by the AMS netlister, version  IC6.1.5.DEL.119 .
// Cadence Design Systems, Inc.

`include "disciplines.vams"

(* cds_ams_schematic *)
module top ( RXDV,GND,DISABLE100,VDDRX,GNDRX,
VDD,DISABLE10,VDDTX,GNDA_250,LEDS,GNDTX,RBIAS_SENSE,TPOP,LEDR,TXER,
MDIO_OE,LEDT,PHY,SCAN_MODE,TX_AMP_TRIM,GNDA_160,MDINT,XTAL25,
SYMBOL_MODE,TPIN,MDC,MDIO_IN,LEDL,CRS,RESETN,ANLG_TST,TXD,TXC,COL,
TX_SLP_TRIM,MDIO_OUT,LEDC,TXEN,RXER,TPON,LEDD,RBIAS,SIDDQ,VDDA_160,
ANDIS,B10_DIS,RXD,TRISTATE,BGTRIM,TPIP,VDDA_250,RXC,SCAN_ENABLE,
B100_DIS );

output   RXDV;
input   GND;
input   DISABLE100;
input   VDDRX;

input   GNDRX;
input   VDD;
input   DISABLE10;
input   VDDTX;
input
 GNDA_250;
output   LEDS;
input   GNDTX;
input   RBIAS_SENSE;
output
 TPOP;
output   LEDR;
input   TXER;
output   MDIO_OE;
output   LEDT;

input [4:0]  PHY;
input   SCAN_MODE;
input [1:0]  TX_AMP_TRIM;
input
 GNDA_160;
output   MDINT;
input   XTAL25;
output   SYMBOL_MODE;

input   TPIN;
input   MDC;
input   MDIO_IN;
output   LEDL;
output
 CRS;
input   RESETN;
output   ANLG_TST;
input [4:0]  TXD;
output
 TXC;
output   COL;
input [1:0]  TX_SLP_TRIM;
output   MDIO_OUT;

output   LEDC;
input   TXEN;
output   RXER;
output   TPON;
output
 LEDD;
input   RBIAS;
input   SIDDQ;
input   VDDA_160;
input   ANDIS;

output   B10_DIS;
output [4:0]  RXD;
output   TRISTATE;
input [3:0]
 BGTRIM;
input   TPIP;
input   VDDA_250;
output   RXC;
input
 SCAN_ENABLE;
output   B100_DIS;

wire [0:3] net294;
wire [2:0] FLASH_1p0;
wire [5:0] ADC_1p0;
wire [5:0] I_RPOLY_100;
wire [4:0] AEQ_CNT_ANLG;
wire [10:0] PHASE_125;
wire [1:0] I_REXT_50;
wire [2:0] TEST_MODE;
wire [0:10] net307;
wire [1:0] MR_SQUELCH_RANGE_1p0;
wire [1:0] MR_SQUELCH_RANGE_2p5;
wire [6:0] I_REXT_100;
wire [1:0] MLT3_TDATA_1p0;
wire [1:0] TX_SLOPETRIM_1p0;
wire [10:0] PHASE_IN;
wire [10:0] PHASE_250;
wire [1:0] MLT3_TDATA_2p5;
wire [4:0] TENBT_FILTER_1p0;
wire [1:0] TX_AMPTRIM_1p0;
wire [6:0] WANDER_CNT;

top_1_port_pnr (*
integer library_binding = "ether";
integer
cds_net_set[0:1] = { "VDD","VSS" };
integer VDD = "VDD";
integer VSS
 = "GND";
 *)
I45 ( .AEQ_BYPASS( AEQ_BYPASS ), .RXDV( RXDV ), .SLICER_OUT(
SLICER_OUT_1p0 ), .TP_DISC( TP_DISC_1p0 ), .TX_AMPTRIM(
TX_AMPTRIM_1p0[1:0] ), .TIMING_DN_ANLG( TIMING_DN_ANLG ), .POS_DETECT(
POS_DETECT_1p0 ), .AEQ_CNT_ANLG( AEQ_CNT_ANLG[4:0] ), .TX_SLOPETRIM(
TX_SLOPETRIM_1p0[1:0] ), .LEDS( LEDS ), .TXER( TXER ), .RESET(
RESET_10BT ), .TEST_MODE( TEST_MODE[2:0] ), .LEDR( LEDR ), .MDIO_OE(
MDIO_OE ), .FLASH( FLASH_1p0[2:0] ), .PHY( PHY[4:0] ), .TENBT_CLK160(
TENBT_CLK160_1p0 ), .MDIX( MDIX ), .LEDT( LEDT ), .X_125( X_125 ), .T2_MODE(
T2_MODE ), .MR_SQUELCH_DISB( MR_SQUELCH_DISB_1p0 ), .MR_SQUELCH_RANGE(
MR_SQUELCH_RANGE_1p0[1:0] ), .SCAN_MODE( SCAN_MODE ), .MDINT( MDINT ),
.TX_AMP_TRIM( TX_AMP_TRIM[1:0] ), .XTAL25( XTAL25_1p0 ), .RX10_PRESENT(
RX10_PRESENT_1p0 ), .SYMBOL_MODE( SYMBOL_MODE ), .CLKPLL_IN( clkpll_sc ),
.MDIO_IN( MDIO_IN ), .MDC( MDC ), .BASE10_DIS( B10_DIS ), .BASEFX_DIS(
BASEFX_DIS ), .CRS( CRS ), .LEDL( LEDL ), .ANLG_TST( ANLG_TST ), .RESETN(
RESETN ), .TXD( TXD[4:0] ), .MR_BYPASS10RX_FILTER(
MR_BYPASS10RX_FILTER ), .BASE10_TX_DIS( BASE10_TX_DIS_1p0 ), .TXC( TXC ),
.X_160( X_160 ), .COL( COL ), .MDIO_OUT( MDIO_OUT ), .TX_SLP_TRIM(
TX_SLP_TRIM[1:0] ), .TIMING_UP_ANLG( TIMING_UP_ANLG ), .TENBT_FILTER(
TENBT_FILTER_1p0[4:0] ), .LEDC( LEDC ), .MLT3_TDATA(
MLT3_TDATA_1p0[1:0] ), .TXEN( TXEN ), .RXER( RXER ), .ADC(
ADC_1p0[5:0] ), .LEDD( LEDD ), .BASE100TX_DIS( B100_DIS ), .RESET_DSP(
RESET_DSP ), .CLKPLL_SC( clkpll_sc ), .ANDIS( ANDIS ), .NEG_DETECT(
NEG_DETECT_1p0 ), .RXD( RXD[4:0] ), .WANDER_CNT_ANLG( WANDER_CNT[6:0] ),
.TRISTATE( TRISTATE ), .RCLK125( RCLK125_1p0 ), .RXC( RXC ), .SCAN_ENABLE(
SCAN_ENABLE ) );

Bias_port (*
integer library_binding = "ether";
 *)
I36 ( .VDD( VDDRX ),
.I_REXT_100_NC( I_REXT_100_NC ), .I_RPOLY_100( I_RPOLY_100[5:0] ), .I_REXT_50(
I_REXT_50[1:0] ), .I_REXT_100( I_REXT_100[6:0] ), .I_REXT_REF100(
I_REXT_REF100 ), .I_RPOLY_REF100( I_RPOLY_REF100 ), .SIDDQ( SIDDQ ), .VSS(
GNDRX ) );

top_1_port_receive (*
integer library_binding = "ether";
 *)
I44 ( .GND(
GND ), .VDDRX( VDDRX ), .RCLK_125( RCLK125_1p0 ), .GNDRX( GNDRX ), .VDD(
VDD ), .I_RPOLY_100( I_RPOLY_100[5:0] ), .TIMING_DN( TIMING_DN_ANLG ),
.TIMING_UP( TIMING_UP_ANLG ), .FLASH( FLASH_1p0[2:0] ), .MR_SQUELCH_DISB(
MR_SQUELCH_DISB_2p5 ), .MR_SQUELCH_RANGE( MR_SQUELCH_RANGE_2p5[1:0] ),
.T2_MODE( T2_MODE ), .ADC_TEST_2p5( ADC_TEST_2p5 ), .I_REXT_100(
I_REXT_100[6:0] ), .RX10_PRESENT( RX10_PRESENT_2p5 ), .BASEFX_DIS(
BASEFX_DIS ), .MR_10BT_FILTER( MR_BYPASS10RX_FILTER ), .MR_AEQ_BYPASS(
AEQ_BYPASS ), .TPIN( TPIN ), .ADC_DIS_2p5( ADC_DIS_2p5 ), .PHASE_250(
PHASE_250[10:0] ), .AEQ_DIS_2p5( AEQ_DIS_2p5 ), .AEQ_CNT(
AEQ_CNT_ANLG[4:0] ), .ADC( ADC_1p0[5:0] ), .RCLK125_TST( RCLK125_TST ),
.RX10_SLICER_OUT( SLICER_OUT_2p5 ), .BASE100TX_DIS( TX100_DIS_2p5 ), .RX10_NEG_SIG_DET(
POS_DETECT_2p5 ), .BLW_DIS_2p5( BLW_DIS_2p5 ), .RESET_DSP( RESET_DSP ),
.RCLK125_TST_SEL( RCLK125_TST_SEL ), .X10_DIS_2p5( X10_DIS_2p5 ), .TPIP(
TPIP ), .RX10_POS_SIG_DET( NEG_DETECT_2p5 ), .WANDER_CNT(
WANDER_CNT[6:0] ) );

anlg_cntl (*
integer library_binding = "ether";
 *)
I42 ( .GND( GND ),
.VDDRX( VDDRX ), .MR_SQUELCH_DISB_1p0( MR_SQUELCH_DISB_1p0 ), .SLICER_OUT_2p5(
SLICER_OUT_2p5 ), .GNDRX( GNDRX ), .VDD( VDD ), .VDDTX( VDDTX ), .PHASE_125(
PHASE_125[10:0] ), .GNDTX( GNDTX ), .TEST_MODE( TEST_MODE[2:0] ), .TXER(
TXER ), .MR_SQUELCH_RANGE_2p5( MR_SQUELCH_RANGE_2p5[1:0] ), .NEG_DETECT_1p0(
NEG_DETECT_1p0 ), .X_125( X_125 ), .MR_SQUELCH_RANGE_1p0(
MR_SQUELCH_RANGE_1p0[1:0] ), .ADC_TEST_2p5( ADC_TEST_2p5 ), .XTAL25(
XTAL25_1p0 ), .BASE10_DIS( B10_DIS ), .BASEFX_DIS( BASEFX_DIS ), .MLT3_TDATA_1p0(
MLT3_TDATA_1p0[1:0] ), .TX_SLOPETRIM_1p0( TX_SLOPETRIM_1p0[1:0] ), .PHASE_IN(
PHASE_IN[10:0] ), .ADC_DIS_2p5( ADC_DIS_2p5 ), .NEG_DETECT_2p5(
NEG_DETECT_2p5 ), .RESETN( RESETN ), .MR_SQUELCH_DISB_2p5(
MR_SQUELCH_DISB_2p5 ), .PHASE_250( PHASE_250[10:0] ), .TX100_DIS_2p5(
TX100_DIS_2p5 ), .AEQ_DIS_2p5( AEQ_DIS_2p5 ), .X_160( X_160 ), .MLT3_TDATA_2p5(
MLT3_TDATA_2p5[1:0] ), .RX10_PRESENT_1p0( RX10_PRESENT_1p0 ), .POS_DETECT_1p0(
POS_DETECT_1p0 ), .RCLK125_TST( RCLK125_TST ), .TP_DISC_2p5(
TP_DISC_2p5 ), .BASE100TX_DIS( B100_DIS ), .SIDDQ( SIDDQ ), .BLW_DIS_2p5(
BLW_DIS_2p5 ), .RCLK125_TST_SEL( RCLK125_TST_SEL ), .PLL_160_IN(
PLL_160_IN ), .TX_AMPTRIM_1p0( TX_AMPTRIM_1p0[1:0] ), .RX10_PRESENT_2p5(
RX10_PRESENT_2p5 ), .XTAL25_IN( XTAL25 ), .X10_DIS_2p5( X10_DIS_2p5 ),
.POS_DETECT_2p5( POS_DETECT_2p5 ), .SLICER_OUT_1p0( SLICER_OUT_1p0 ),
.TP_DISC_1p0( TP_DISC_1p0 ) );

top_1_port_transmit (*
integer library_binding = "ether";
 *)
I46 ( .GND(
GND ), .I_REXT_400_TX( I_REXT_400_TX ), .VDD( VDD ), .VDDTX( VDDTX ),
.GNDTX( GNDTX ), .TPOP( TPOP ), .I_100u_Rext_NC( I_REXT_100_NC ), .TP_DIS(
TP_DISC_2p5 ), .TENBT_CLK_160( TENBT_CLK160_1p0 ), .BASE10_TX_DIS(
BASE10_TX_DIS_1p0 ), .TX100_DIS_2p5( TX100_DIS_2p5 ), .MLT3ENC_DATA(
MLT3_TDATA_2p5[1:0] ), .TENBT_FILTER( TENBT_FILTER_1p0[4:0] ), .TPON(
TPON ), .RESET_10BT( RESET_10BT ), .SIDDQ( SIDDQ ), .I_REXT_50u(
I_REXT_50[1:0] ), .X10_DIS_2p5( X10_DIS_2p5 ) );

top_common #(.ieLib("schroeder_sims"), .ieIO("output")) (*
integer
library_binding = "ether";
 *)
I55 ( .I_REXT_400_TX( net293 ), .DISABLE100(
net302 ), .I_RPOLY_100( net303 ), .DISABLE10( net296 ), .GNDA_250(
net298 ), .RBIAS_SENSE( net300 ), .GNDA_160( net304 ), .I_REXT_100(
net301 ), .PLL160( net305 ), .RBIAS( net299 ), .SIDDQ( net306 ), .VDDA_160(
net297 ), .BGTRIM( net294[0:3] ), .CLKXTAL( net308 ), .VDDA_250(
net295 ), .PHASE( net307[0:10] ) );
top_common #(.ieLib("schroeder_sims"), .ieIO("output")) (*
integer
library_binding = "ether";
 *)
I22 ( .I_REXT_400_TX( I_REXT_400_TX ),
.DISABLE100( DISABLE100 ), .I_RPOLY_100( I_RPOLY_REF100 ), .DISABLE10(
DISABLE10 ), .GNDA_250( GNDA_250 ), .RBIAS_SENSE( RBIAS_SENSE ), .GNDA_160(
GNDA_160 ), .I_REXT_100( I_REXT_REF100 ), .PLL160( PLL_160_IN ), .RBIAS(
RBIAS ), .SIDDQ( SIDDQ ), .VDDA_160( VDDA_160 ), .BGTRIM( BGTRIM[3:0] ),
.CLKXTAL( XTAL25 ), .VDDA_250( VDDA_250 ), .PHASE( PHASE_IN[10:0] ) );

endmodule
