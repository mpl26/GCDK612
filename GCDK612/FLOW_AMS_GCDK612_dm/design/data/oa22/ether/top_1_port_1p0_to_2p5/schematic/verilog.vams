// Verilog-AMS netlist generated by the AMS netlister, version ICOA5.2.51.500.7.
// Cadence Design Systems, Inc.

`include "disciplines.vams"

module top_1_port_1p0_to_2p5 ( RX10_PRESENT_2p5,TP_DISC_1p0,
MR_SQUELCH_RANGE_1p0,MLT3_TDATA_2p5,TP_DISC_2p5,RX10_PRESENT_1p0,
TX_AMPTRIM_1p0,MLT3_TDATA_1p0,MR_SQUELCH_DISB_2p5,VDD_1p0,
MR_SQUELCH_DISB_1p0,MR_SQUELCH_RANGE_2p5,TX_AMPTRIM_2p5,VDD_2p5,
TX_SLOPETRIM_1p0,VSS,TX_SLOPETRIM_2p5 );

output   RX10_PRESENT_2p5;
input   TP_DISC_1p0;
input [1:0]
 MR_SQUELCH_RANGE_1p0;
output [1:0]  MLT3_TDATA_2p5;
output
 TP_DISC_2p5;
input   RX10_PRESENT_1p0;
input [1:0]  TX_AMPTRIM_1p0;

input [1:0]  MLT3_TDATA_1p0;
output   MR_SQUELCH_DISB_2p5;
input
 VDD_1p0;
input   MR_SQUELCH_DISB_1p0;
output [1:0]
 MR_SQUELCH_RANGE_2p5;
output [1:0]  TX_AMPTRIM_2p5;
input   VDD_2p5;

input [1:0]  TX_SLOPETRIM_1p0;
input   VSS;
output [1:0]
 TX_SLOPETRIM_2p5;

level_shifter_1p0_2p5_inh (*
integer library_binding = "ether";

integer elaboration_binding = "I22[1:1]";
 *)
I22_1 ( .IN(
TX_SLOPETRIM_1p0[1] ), .VDD_1p0( VDD_1p0 ), .VDD_2p5( VDD_2p5 ), .OUT(
TX_SLOPETRIM_2p5[1] ), .VSS( VSS ) );
level_shifter_1p0_2p5_inh #(.ieIO("output"), .d2a_tr("100p"), .a2d_v0("0.5"),
 .d2a_tf("100p"), .d2a_vh("2.5"), .a2d_v1("0.8"), .a2d_tx("100p")) (*

integer library_binding = "ether";
integer elaboration_binding
 = "I15[1:1]";
 *)
I15_1 ( .IN( TX_AMPTRIM_1p0[1] ), .VDD_1p0( VDD_1p0 ),
.VDD_2p5( VDD_2p5 ), .OUT( TX_AMPTRIM_2p5[1] ), .VSS( VSS ) );
level_shifter_1p0_2p5_inh (*
integer library_binding = "ether";

integer elaboration_binding = "I23[1:1]";
 *)
I23_1 ( .IN(
MR_SQUELCH_RANGE_1p0[1] ), .VDD_1p0( VDD_1p0 ), .VDD_2p5( VDD_2p5 ), .OUT(
MR_SQUELCH_RANGE_2p5[1] ), .VSS( VSS ) );
level_shifter_1p0_2p5_inh (*
integer library_binding = "ether";

integer elaboration_binding = "I15[0:0]";
 *)
I15_0 ( .IN(
TX_AMPTRIM_1p0[0] ), .VDD_1p0( VDD_1p0 ), .VDD_2p5( VDD_2p5 ), .OUT(
TX_AMPTRIM_2p5[0] ), .VSS( VSS ) );
level_shifter_1p0_2p5_inh (*
integer library_binding = "ether";

integer elaboration_binding = "I16[0:0]";
 *)
I16_0 ( .IN(
TX_SLOPETRIM_1p0[0] ), .VDD_1p0( VDD_1p0 ), .VDD_2p5( VDD_2p5 ), .OUT(
TX_SLOPETRIM_2p5[0] ), .VSS( VSS ) );
level_shifter_1p0_2p5_inh (*
integer library_binding = "ether";
 *)

I18 ( .IN( MR_SQUELCH_DISB_1p0 ), .VDD_1p0( VDD_1p0 ), .VDD_2p5(
VDD_2p5 ), .OUT( MR_SQUELCH_DISB_2p5 ), .VSS( VSS ) );
level_shifter_1p0_2p5_inh (*
integer library_binding = "ether";
 *)

I17 ( .IN( RX10_PRESENT_1p0 ), .VDD_1p0( VDD_1p0 ), .VDD_2p5( VDD_2p5 ),
.OUT( RX10_PRESENT_2p5 ), .VSS( VSS ) );
level_shifter_1p0_2p5_inh (*
integer library_binding = "ether";

integer elaboration_binding = "I19[0:0]";
 *)
I19_0 ( .IN(
MR_SQUELCH_RANGE_1p0[0] ), .VDD_1p0( VDD_1p0 ), .VDD_2p5( VDD_2p5 ), .OUT(
MR_SQUELCH_RANGE_2p5[0] ), .VSS( VSS ) );
level_shifter_1p0_2p5_inh (*
integer library_binding = "ether";
 *)
I5
 ( .IN( TP_DISC_1p0 ), .VDD_1p0( VDD_1p0 ), .VDD_2p5( VDD_2p5 ), .OUT(
TP_DISC_2p5 ), .VSS( VSS ) );
level_shifter_1p0_2p5_inh #(.ieIO("output"), .d2a_tr("100p"), .a2d_v0("0.5"),
 .d2a_tf("100p"), .d2a_vh("2.5"), .a2d_v1("0.8"), .a2d_tx("100p")) (*

integer library_binding = "ether";
integer elaboration_binding
 = "I2[0:0]";
 *)
I2_0 ( .IN( MLT3_TDATA_1p0[0] ), .VDD_1p0( VDD_1p0 ),
.VDD_2p5( VDD_2p5 ), .OUT( MLT3_TDATA_2p5[0] ), .VSS( VSS ) );
level_shifter_1p0_2p5_inh #(.ieIO("output"), .d2a_tr("100p"), .a2d_v0("0.5"),
 .d2a_tf("100p"), .d2a_vh("2.5"), .a2d_v1("0.8"), .a2d_tx("100p")) (*

integer library_binding = "ether";
integer elaboration_binding
 = "I20[1:1]";
 *)
I20_1 ( .IN( MLT3_TDATA_1p0[1] ), .VDD_1p0( VDD_1p0 ),
.VDD_2p5( VDD_2p5 ), .OUT( MLT3_TDATA_2p5[1] ), .VSS( VSS ) );

endmodule
