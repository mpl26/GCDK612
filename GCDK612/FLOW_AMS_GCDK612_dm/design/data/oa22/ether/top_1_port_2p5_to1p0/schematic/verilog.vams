// Verilog-AMS netlist generated by the AMS netlister, version ICOA5.2.51.500.7.
// Cadence Design Systems, Inc.

`include "disciplines.vams"

module top_1_port_2p5_to1p0 ( SLICER_OUT_2p5,POS_DETECT_1p0,
SLICER_OUT_1p0,VDD_1p0,NEG_DETECT_2p5,NEG_DETECT_1p0,POS_DETECT_2p5,
VDD_2p5,VSS );

input   SLICER_OUT_2p5;
output   POS_DETECT_1p0;
output
 SLICER_OUT_1p0;
input   VDD_1p0;
input   NEG_DETECT_2p5;
output
 NEG_DETECT_1p0;
input   POS_DETECT_2p5;
input   VDD_2p5;
input
 VSS;

level_shifter_2p5_1p0_inh (*
integer library_binding = "ether";
 *)

I19 ( .IN( NEG_DETECT_2p5 ), .VDD_1p0( VDD_1p0 ), .VDD_2p5( VDD_2p5 ),
.OUT( NEG_DETECT_1p0 ), .VSS( VSS ) );
level_shifter_2p5_1p0_inh (*
integer library_binding = "ether";
 *)

I18 ( .IN( POS_DETECT_2p5 ), .VDD_1p0( VDD_1p0 ), .VDD_2p5( VDD_2p5 ),
.OUT( POS_DETECT_1p0 ), .VSS( VSS ) );
level_shifter_2p5_1p0_inh (*
integer library_binding = "ether";
 *)
I3
 ( .IN( SLICER_OUT_2p5 ), .VDD_1p0( VDD_1p0 ), .VDD_2p5( VDD_2p5 ), .OUT(
SLICER_OUT_1p0 ), .VSS( VSS ) );

endmodule
