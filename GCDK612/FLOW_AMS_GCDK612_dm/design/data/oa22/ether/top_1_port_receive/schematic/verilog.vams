// Verilog-AMS netlist generated by the AMS netlister, version ICOA5.2.51.500.7.
// Cadence Design Systems, Inc.

`include "disciplines.vams"

module top_1_port_receive ( MR_SQUELCH_DISB,RX10_SLICER_OUT,
I_RPOLY_100,ADC_TEST_2p5,ADC_DIS_2p5,RX10_PRESENT,X10_DIS_2p5,ADC,
RX10_NEG_SIG_DET,RESET_DSP,BASE100TX_DIS,AEQ_CNT,TIMING_DN,I_REXT_100,
PHASE_250,RCLK_125,MR_SQUELCH_RANGE,VDDRX,TIMING_UP,RCLK125_TST_SEL,
VDD,MR_10BT_FILTER,MR_AEQ_BYPASS,FLASH,BASEFX_DIS,TPIP,RCLK125_TST,
GNDRX,AEQ_DIS_2p5,BLW_DIS_2p5,TPIN,T2_MODE,WANDER_CNT,GND,
RX10_POS_SIG_DET );

input   MR_SQUELCH_DISB;
output   RX10_SLICER_OUT;
input [5:0]
 I_RPOLY_100;
input   ADC_TEST_2p5;
input   ADC_DIS_2p5;
input
 RX10_PRESENT;
input   X10_DIS_2p5;
output [5:0]  ADC;
output
 RX10_NEG_SIG_DET;
input   RESET_DSP;
input   BASE100TX_DIS;

input [4:0]  AEQ_CNT;
input   TIMING_DN;
input [6:0]  I_REXT_100;

input [10:0]  PHASE_250;
output   RCLK_125;
input [1:0]
 MR_SQUELCH_RANGE;
input   VDDRX;
input   TIMING_UP;
input
 RCLK125_TST_SEL;
input   VDD;
input   MR_10BT_FILTER;
input
 MR_AEQ_BYPASS;
output [2:0]  FLASH;
input   BASEFX_DIS;
input
 TPIP;
input   RCLK125_TST;
input   GNDRX;
input   AEQ_DIS_2p5;

input   BLW_DIS_2p5;
input   TPIN;
input   T2_MODE;
input [6:0]
 WANDER_CNT;
input   GND;
output   RX10_POS_SIG_DET;

tenbt_rec (*
integer library_binding = "ether";
 *)
I19 ( .pos(
blw_outp ), .MR_SQUELCH_DISB( MR_SQUELCH_DISB ), .MR_BYPASS10RX_FILTER(
MR_10BT_FILTER ), .ibias_rext_100u( I_REXT_100[4] ), .RX10_PRESENT(
RX10_PRESENT ), .ibias_rpoly_100u( I_RPOLY_100[4] ), .NEG_SIG_DET(
RX10_NEG_SIG_DET ), .gnd( GNDRX ), .MR_SQUELCH_RANGE(
MR_SQUELCH_RANGE[1:0] ), .vdd( VDDRX ), .neg( blw_outm ), .ibias_rpoly2_100u(
I_RPOLY_100[5] ), .siddq( X10_DIS_2p5 ), .POS_SIG_DET(
RX10_POS_SIG_DET ), .SLICER_OUT( RX10_SLICER_OUT ) );

Analog_eq (*
integer library_binding = "ether";
 *)
I1 ( .I_rext_100_2(
I_REXT_100[1] ), .agc_eq( AEQ_CNT[4:0] ), .avdd( VDDRX ), .dvdd( VDD ),
.Vref( VDDRX ), .I_rext_100_4( I_REXT_100[3] ), .inp( blw_outp ), .I_rext_100_3(
I_REXT_100[2] ), .agc_eq_bypass( MR_AEQ_BYPASS ), .outp( aneq_outp ),
.I_rext_100_1( I_REXT_100[0] ), .outm( aneq_outm ), .dgnd( GND ), .fdbk_out(
fbk ), .siddq( AEQ_DIS_2p5 ), .agnd( GNDRX ), .inm( blw_outm ), .fdbk_in(
fbk ), .timing_mode( T2_MODE ) );

blw_dac (*
integer library_binding = "ether";
 *)
I12 ( .BASE100_DIS(
BASE100TX_DIS ), .AEQ_DIS( AEQ_DIS_2p5 ), .IN( WANDER_CNT[6:0] ), .INP(
TPIP ), .SIDDQ( BLW_DIS_2p5 ), .AVDD_2p5V( VDDRX ), .DGND( GND ), .DVDD(
VDD ), .I_RPOLY_100_1( I_RPOLY_100[0] ), .OUTP( blw_outp ), .OUTM(
blw_outm ), .AGND( GNDRX ), .INM( TPIN ), .I_RPOLY_100_2(
I_RPOLY_100[1] ), .ADC_TEST( ADC_TEST_2p5 ) );

adc_top (*
integer library_binding = "ether";
 *)
I0 ( .TEST_INM(
blw_outm ), .INP( aneq_outp ), .SIDDQ( ADC_DIS_2p5 ), .TEST_ENABLE(
ADC_TEST_2p5 ), .adc_flash( FLASH[2:0] ), .DVDD( VDD ), .BASE100TX_DIS(
BASE100TX_DIS ), .I100_ext2( I_REXT_100[6] ), .I100_ext1(
I_REXT_100[5] ), .adc_latch_clk( RCLK_125 ), .DVSS( GND ), .VDD( VDDRX ),
.I100_poly1( I_RPOLY_100[2] ), .adc_out( ADC[5:0] ), .TEST_INP(
blw_outp ), .CLK( RCLK_125_PI ), .INM( aneq_outm ), .VSS( GNDRX ), .I100_poly2(
I_RPOLY_100[3] ), .BASEFX_DIS_1p0( BASEFX_DIS ) );

pi #(.d2a_tr("100p"), .ieIO("input"), .a2d_v0("0.5"), .d2a_tf("100p"),
 .a2d_v1("0.8"), .d2a_vh("1"), .a2d_tx("100p")) (*
integer
library_binding = "ether";
 *)
I23 ( .PHASE_DOWN( TIMING_DN ), .phin(
PHASE_250[10:0] ), .RESET( RESET_DSP ), .AVDD_2p5V( VDDRX ), .PHASE_UP(
TIMING_UP ), .VDD( VDD ), .RCLK125( RCLK_125_PI ), .AGND( GNDRX ), .VSS(
GND ), .RCLK125_TEST( RCLK125_TST ), .ADC_TEST_MODE( RCLK125_TST_SEL ) );

endmodule
