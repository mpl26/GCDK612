// Verilog-AMS netlist generated by the AMS netlister, version ICOA5.2.51.500.7.
// Cadence Design Systems, Inc.

`include "disciplines.vams"

module top_1_port_transmit ( TENBT_CLK_160,TPON,SIDDQ,X10_DIS_2p5,
I_REXT_400_TX,BASE10_TX_DIS,TPOP,TENBT_FILTER,VDD,TP_DIS,VDDTX,
I_REXT_50u,RESET_10BT,TX100_DIS_2p5,I_100u_Rext_NC,GNDTX,GND,
MLT3ENC_DATA );

input   TENBT_CLK_160;
output   TPON;
input   SIDDQ;
input
 X10_DIS_2p5;
input   I_REXT_400_TX;
input   BASE10_TX_DIS;
output
 TPOP;
input [4:0]  TENBT_FILTER;
input   VDD;
input   TP_DIS;
input
 VDDTX;
input [1:0]  I_REXT_50u;
input   RESET_10BT;
input
 TX100_DIS_2p5;
input   I_100u_Rext_NC;
input   GNDTX;
input   GND;

input [1:0]  MLT3ENC_DATA;

gpdk090_nmoscap2v #(.m(10 * 1), .l(12.865u), .w(12.825u)) (*
integer
library_binding = "gpdk090";
integer passed_mfactor = "m";
 *)
C1 (
GND, VDD, GND, GND );
gpdk090_nmoscap2v #(.m(22 * 6), .l(12.865u), .w(12.825u)) (*
integer
library_binding = "gpdk090";
integer passed_mfactor = "m";
 *)
C0 (
GNDTX, VDDTX, GNDTX, GNDTX );

trans_ld_10bt_100tx_B (*
integer library_binding = "ether";
 *)
I17 (
.ibias_rext_50u( I_REXT_50u[0] ), .BASE100_DIS( TX100_DIS_2p5 ), .dvdd(
VDD ), .BI_DAM( TPON ), .ibias_rext2_50u( I_REXT_50u[1] ), .BASE10_DIS(
X10_DIS_2p5 ), .gnd( GNDTX ), .reset( RESET_10BT ), .tenbt_filter(
TENBT_FILTER[4:0] ), .vdd( VDDTX ), .BASE10_TX_DIS( BASE10_TX_DIS ), .dgnd(
GND ), .siddq( SIDDQ ), .TP_DIS( TP_DIS ), .ibias_rext_400u(
I_REXT_400_TX ), .I_100u_Rext_NC( I_100u_Rext_NC ), .clk_160mhz(
TENBT_CLK_160 ), .BI_DAP( TPOP ), .MLT3ENC_DATA( MLT3ENC_DATA[1:0] ) );

endmodule
