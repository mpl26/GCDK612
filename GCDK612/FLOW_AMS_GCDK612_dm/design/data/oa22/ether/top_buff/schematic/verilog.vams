// Verilog-AMS netlist generated by the AMS netlister, version ICOA5.2.51.500.7.
// Cadence Design Systems, Inc.

`include "disciplines.vams"

module top_buff ( PHASE_IN,PHASE_125,XTAL25,X_160,PHASE_250,VDDRX,
RESETN,VDD,X_125,PLL_160_IN,VDDTX,GNDRX,XTAL25_IN,GND,GNDTX );

input [10:0]  PHASE_IN;
output [10:0]  PHASE_125;
output   XTAL25;

output   X_160;
output [10:0]  PHASE_250;
input   VDDRX;
input
 RESETN;
input   VDD;
output   X_125;
input   PLL_160_IN;
input
 VDDTX;
input   GNDRX;
input   XTAL25_IN;
input   GND;
input   GNDTX;

wire [10:0] TAP;

parameter tdel=0;
parameter vhigh=0;
parameter vtrans=0;
parameter tr=0;
parameter vlow=0;
parameter tf=0;

level_shifter_2p5_1p0_inh #(.d2a_tr("100p"), .ieIO("output"), .a2d_v0("0.5"),
 .d2a_tf("100p"), .a2d_v1("0.8"), .d2a_vh("1"), .a2d_tx("100p")) (*

integer library_binding = "ether";
integer cds_net_set[0:2] = {
"VDD_1p0","VDD_2p5","VSS" };
integer VDD_1p0 = "VDD";
integer VDD_2p5
 = "VDDTX";
integer VSS = "GND";
 *)
I85 ( .IN( TAP[0] ), .VDD_1p0(
VDD ), .VDD_2p5( VDDTX ), .OUT( net119 ), .VSS( GND ) );
level_shifter_2p5_1p0_inh #(.d2a_tr("100p"), .ieIO("output"), .a2d_v0("0.5"),
 .d2a_tf("100p"), .a2d_v1("0.8"), .a2d_tx("100p"), .d2a_vh("1")) (*

integer library_binding = "ether";
integer cds_net_set[0:2] = {
"VDD_2p5","VSS","VDD_1p0" };
integer VDD_2p5 = "VDDTX";
integer VSS
 = "GND";
integer VDD_1p0 = "VDD";
 *)
I66 ( .IN( net116 ), .VDD_1p0(
VDD ), .VDD_2p5( VDDTX ), .OUT( net124 ), .VSS( GND ) );
level_shifter_2p5_1p0_inh #(.ieIO("output"), .d2a_tr("100p"), .a2d_v0("0.5"),
 .d2a_tf("100p"), .a2d_v1("0.8"), .d2a_vh("1"), .a2d_tx("100p")) (*

integer library_binding = "ether";
integer cds_net_set[0:2] = {
"VDD_1p0","VDD_2p5","VSS" };
integer VDD_1p0 = "VDD";
integer VDD_2p5
 = "VDDTX";
integer VSS = "GND";
 *)
I86 ( .IN( net147 ), .VDD_1p0(
VDD ), .VDD_2p5( VDDTX ), .OUT( net129 ), .VSS( GND ) );

INVX4 #(.d2a_tr("100p"), .ieIO("output"), .a2d_v0("0.5"), .d2a_tf("100p"),
 .a2d_v1("0.8"), .a2d_tx("100p"), .d2a_vh("1")) (*
integer
library_binding = "gsclib090";
integer cds_net_set[0:1] = { "VDD",
"VSS" };
integer VDD = "VDD";
integer VSS = "GND";
 *)
I74 ( .Y( net84 ),
.A( net110 ) );
INVX4 #(.d2a_tr("100p"), .ieIO("output"), .a2d_v0("0.5"), .d2a_tf("100p"),
 .a2d_v1("0.8"), .a2d_tx("100p"), .d2a_vh("1")) (*
integer
library_binding = "gsclib090";
integer cds_net_set[0:1] = { "VDD",
"VSS" };
integer VDD = "VDD";
integer VSS = "GND";
 *)
I69 ( .Y( net86 ),
.A( net108 ) );
INVX4 #(.d2a_tr("100p"), .ieIO("output"), .a2d_v0("0.5"), .d2a_tf("100p"),
 .a2d_v1("0.8"), .a2d_tx("100p"), .d2a_vh("1")) (*
integer
library_binding = "gsclib090";
integer cds_net_set[0:1] = { "VSS",
"VDD" };
integer VSS = "GND";
integer VDD = "VDD";
 *)
I79 ( .Y( net88 ),
.A( net112 ) );

INVX8 #(.d2a_tr("100p"), .ieIO("output"), .a2d_v0("0.5"), .d2a_tf("100p"),
 .a2d_v1("0.8"), .a2d_tx("100p"), .d2a_vh("1")) (*
integer
library_binding = "gsclib090";
integer cds_net_set[0:1] = { "VDD",
"VSS" };
integer VDD = "VDD";
integer VSS = "GND";
 *)
I82 ( .Y(
XTAL25 ), .A( net102 ) );
INVX8 #(.d2a_tr("100p"), .ieIO("output"), .a2d_v0("0.5"), .d2a_tf("100p"),
 .a2d_v1("0.8"), .a2d_tx("100p"), .d2a_vh("1")) (*
integer
library_binding = "gsclib090";
integer cds_net_set[0:1] = { "VDD",
"VSS" };
integer VDD = "VDD";
integer VSS = "GND";
 *)
I83 ( .Y( X_160 ),
.A( net98 ) );
INVX8 #(.d2a_tr("100p"), .ieIO("output"), .a2d_v0("0.5"), .d2a_tf("100p"),
 .a2d_v1("0.8"), .a2d_tx("100p"), .d2a_vh("1")) (*
integer
library_binding = "gsclib090";
integer cds_net_set[0:1] = { "VDD",
"VSS" };
integer VDD = "VDD";
integer VSS = "GND";
 *)
I84 ( .Y( X_125 ),
.A( net100 ) );
INVX8 #(.d2a_tr("100p"), .ieIO("output"), .a2d_v0("0.5"), .d2a_tf("100p"),
 .a2d_v1("0.8"), .a2d_tx("100p"), .d2a_vh("1")) (*
integer
library_binding = "gsclib090";
integer cds_net_set[0:1] = { "VDD",
"VSS" };
integer VDD = "VDD";
integer VSS = "GND";
 *)
I71 ( .Y(
XTAL25 ), .A( net102 ) );
INVX8 #(.d2a_tr("100p"), .ieIO("output"), .a2d_v0("0.5"), .d2a_tf("100p"),
 .a2d_v1("0.8"), .a2d_tx("100p"), .d2a_vh("1")) (*
integer
library_binding = "gsclib090";
integer cds_net_set[0:1] = { "VDD",
"VSS" };
integer VDD = "VDD";
integer VSS = "GND";
 *)
I75 ( .Y( net98 ),
.A( net84 ) );
INVX8 #(.d2a_tr("100p"), .ieIO("output"), .a2d_v0("0.5"), .d2a_tf("100p"),
 .a2d_v1("0.8"), .a2d_tx("100p"), .d2a_vh("1")) (*
integer
library_binding = "gsclib090";
integer cds_net_set[0:1] = { "VSS",
"VDD" };
integer VSS = "GND";
integer VDD = "VDD";
 *)
I78 ( .Y(
net100 ), .A( net88 ) );
INVX8 #(.d2a_tr("100p"), .ieIO("input"), .a2d_v0("0.5"), .d2a_tf("100p"),
 .a2d_tx("100p"), .d2a_vh("1"), .a2d_v1("0.8")) (*
integer
library_binding = "gsclib090";
integer cds_net_set[0:1] = { "VSS",
"VDD" };
integer VSS = "GND";
integer VDD = "VDD";
 *)
I72 ( .Y(
net102 ), .A( net86 ) );
INVX8 #(.d2a_tr("100p"), .ieIO("output"), .a2d_v0("0.5"), .d2a_tf("100p"),
 .a2d_v1("0.8"), .a2d_tx("100p"), .d2a_vh("1")) (*
integer
library_binding = "gsclib090";
integer cds_net_set[0:1] = { "VSS",
"VDD" };
integer VSS = "GND";
integer VDD = "VDD";
 *)
I76 ( .Y( X_160 ),
.A( net98 ) );
INVX8 #(.d2a_tr("100p"), .ieIO("output"), .a2d_v0("0.5"), .d2a_tf("100p"),
 .a2d_v1("0.8"), .a2d_tx("100p"), .d2a_vh("1")) (*
integer
library_binding = "gsclib090";
integer cds_net_set[0:1] = { "VSS",
"VDD" };
integer VSS = "GND";
integer VDD = "VDD";
 *)
I77 ( .Y( X_125 ),
.A( net100 ) );

INVX1 #(.d2a_tr("100p"), .ieIO("output"), .a2d_v0("0.5"), .d2a_tf("100p"),
 .a2d_v1("0.8"), .a2d_tx("100p"), .d2a_vh("1")) (*
integer
library_binding = "gsclib090";
integer cds_net_set[0:1] = { "VDD",
"VSS" };
integer VDD = "VDD";
integer VSS = "GND";
 *)
I68 ( .Y(
net108 ), .A( net129 ) );
INVX1 #(.d2a_tr("100p"), .ieIO("output"), .a2d_v0("0.5"), .d2a_tf("100p"),
 .a2d_v1("0.8"), .a2d_tx("100p"), .d2a_vh("1")) (*
integer
library_binding = "gsclib090";
integer cds_net_set[0:1] = { "VSS",
"VDD" };
integer VSS = "GND";
integer VDD = "VDD";
 *)
I73 ( .Y(
net110 ), .A( net124 ) );
INVX1 #(.d2a_tr("100p"), .ieIO("output"), .a2d_v0("0.5"), .d2a_tf("100p"),
 .a2d_v1("0.8"), .a2d_tx("100p"), .d2a_vh("1")) (*
integer
library_binding = "gsclib090";
integer cds_net_set[0:1] = { "VSS",
"VDD" };
integer VSS = "GND";
integer VDD = "VDD";
 *)
I81 ( .Y(
net112 ), .A( net119 ) );

inv_16x_hv #(.d2a_tr("100p"), .ieIO("output"), .a2d_v0("0.5"), .d2a_tf("100p"),
 .a2d_v1("0.8"), .a2d_tx("100p"), .d2a_vh("2.5")) (*
integer
library_binding = "ether";
integer cds_net_set[0:1] = { "DVSS","DVDD"
 };
integer DVSS = "GNDTX";
integer DVDD = "VDDTX";
 *)
I33 ( .Y(
net147 ), .A( net133 ) );
inv_16x_hv #(.d2a_tr("100p"), .ieIO("output"), .a2d_v0("0.5"), .d2a_tf("100p"),
 .a2d_v1("0.8"), .a2d_tx("100p"), .d2a_vh("2.5")) (*
integer
library_binding = "ether";
integer cds_net_set[0:1] = { "DVSS","DVDD"
 };
integer DVSS = "GNDTX";
integer DVDD = "VDDTX";
 *)
I64 ( .Y(
net116 ), .A( net135 ) );

inv_8x_hv #(.d2a_tr("100p"), .ieIO("output"), .a2d_v0("0.5"), .d2a_tf("100p"),
 .a2d_v1("0.8"), .a2d_tx("100p"), .d2a_vh("2.5")) (*
integer
library_binding = "ether";
integer cds_net_set[0:1] = { "DVSS","DVDD"
 };
integer DVSS = "GNDTX";
integer DVDD = "VDDTX";
 *)
I32 ( .Y(
net133 ), .A( net137 ) );
inv_8x_hv #(.d2a_tr("100p"), .ieIO("output"), .a2d_v0("0.5"), .d2a_tf("100p"),
 .a2d_v1("0.8"), .a2d_tx("100p"), .d2a_vh("2.5")) (*
integer
library_binding = "ether";
integer cds_net_set[0:1] = { "DVSS","DVDD"
 };
integer DVSS = "GNDTX";
integer DVDD = "VDDTX";
 *)
I63 ( .Y(
net135 ), .A( net139 ) );

inv_3x_hv #(.d2a_tr("100p"), .ieIO("output"), .a2d_v0("0.5"), .d2a_tf("100p"),
 .a2d_v1("0.8"), .a2d_tx("100p"), .d2a_vh("2.5")) (*
integer
library_binding = "ether";
integer cds_net_set[0:1] = { "DVDD","DVSS"
 };
integer DVDD = "VDDTX";
integer DVSS = "GNDTX";
 *)
I31 ( .Y(
net137 ), .A( net141 ) );
inv_3x_hv #(.d2a_tr("100p"), .ieIO("output"), .a2d_v0("0.5"), .d2a_tf("100p"),
 .a2d_v1("0.8"), .a2d_tx("100p"), .d2a_vh("2.5")) (*
integer
library_binding = "ether";
integer cds_net_set[0:1] = { "DVSS","DVDD"
 };
integer DVSS = "GNDTX";
integer DVDD = "VDDTX";
 *)
I62 ( .Y(
net139 ), .A( net143 ) );

inv_1x_hv #(.d2a_tr("100p"), .ieIO("output"), .a2d_v0("0.5"), .d2a_tf("100p"),
 .a2d_v1("0.8"), .a2d_tx("100p"), .d2a_vh("2.5")) (*
integer
library_binding = "ether";
integer cds_net_set[0:1] = { "DVDD","DVSS"
 };
integer DVDD = "VDDTX";
integer DVSS = "GNDTX";
 *)
I59 ( .Y(
net141 ), .A( XTAL25_IN ) );
inv_1x_hv #(.d2a_tr("100p"), .ieIO("output"), .a2d_v0("0.5"), .d2a_tf("100p"),
 .a2d_v1("0.8"), .a2d_tx("100p"), .d2a_vh("2.5")) (*
integer
library_binding = "ether";
integer cds_net_set[0:1] = { "DVDD","DVSS"
 };
integer DVDD = "VDDTX";
integer DVSS = "GNDTX";
 *)
I61 ( .Y(
net143 ), .A( PLL_160_IN ) );

clkbuffers2X (*
integer library_binding = "ether";
integer cds_net_set
[0:1] = { "DVSS","DVDD" };
integer DVSS = "GNDRX";
integer DVDD
 = "VDDRX";
 *)
I5 ( .in( PHASE_IN[10:0] ), .out( PHASE_250[10:0] ) );

\100tx_div2  (*
integer library_binding = "ether";
integer cds_net_set
[0:1] = { "DVSS","DVDD" };
integer DVSS = "GNDTX";
integer DVDD
 = "VDDTX";
 *)
I24 ( .IN( PHASE_250[10:0] ), .XTAL25( net147 ), .RESETN(
RESETN ), .TAP( TAP[10:0] ) );

clkbuffers (*
integer library_binding = "ether";
integer cds_net_set
[0:1] = { "DVDD","DVSS" };
integer DVDD = "VDDTX";
integer DVSS
 = "GNDTX";
 *)
I25 ( .in( TAP[10:0] ), .out( PHASE_125[10:0] ) );

endmodule
