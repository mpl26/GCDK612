// Verilog-AMS netlist generated by the AMS netlister, version ICOA5.2.51.500.7.
// Cadence Design Systems, Inc.

`include "disciplines.vams"

module top_common ( CLKXTAL,SIDDQ,I_RPOLY_100,PHASE,I_REXT_100,
I_REXT_400_TX,RBIAS_SENSE,RBIAS,DISABLE10,VDDA_250,PLL160,GNDA_250,
GNDA_160,VDDA_160,DISABLE100,BGTRIM );

input   CLKXTAL;
input   SIDDQ;
output   I_RPOLY_100;
output [10:0]
 PHASE;
output   I_REXT_100;
output   I_REXT_400_TX;
input
 RBIAS_SENSE;
inout   RBIAS;
input   DISABLE10;
input   VDDA_250;

output   PLL160;
input   GNDA_250;
input   GNDA_160;
input
 VDDA_160;
input   DISABLE100;
input [3:0]  BGTRIM;

wire [1:0] I_RPOLY_25_PLL;
wire [1:0] I_REXT_25_PLL;
wire [1:0] I_REXT_100_PLL;

gpdk090_nmoscap2v #(.m(18 * 6), .l(12.865u), .w(12.82u)) (*
integer
library_binding = "gpdk090";
integer passed_mfactor = "m";
 *)
M1 (
GNDA_160, VDDA_160, GNDA_160, GNDA_160 );
gpdk090_nmoscap2v #(.m(18 * 6), .l(12.865u), .w(12.82u)) (*
integer
library_binding = "gpdk090";
integer passed_mfactor = "m";
 *)
M0 (
GNDA_250, VDDA_250, GNDA_250, GNDA_250 );

Bias_top (*
integer library_binding = "ether";
 *)
I36 ( .I_25u_Rpoly_PLL(
I_RPOLY_25_PLL[1:0] ), .I_400u_Rext( I_REXT_400_TX ), .I_100u_Rext(
I_REXT_100 ), .vss( GNDA_160 ), .I_100u_Rpoly( I_RPOLY_100 ), .Vkelvin(
RBIAS_SENSE ), .vdd( VDDA_160 ), .siddq( SIDDQ ), .I_100u_Rext_PLL(
I_REXT_100_PLL[1:0] ), .I_25u_Rext_PLL( I_REXT_25_PLL[1:0] ), .Rext(
RBIAS ), .BGTRIM( BGTRIM[3:0] ) );

PLL_250MHZ #(.ieIO("output"), .d2a_tr("1n"), .a2d_v0("1"), .d2a_tf("1n"),
 .a2d_v1("3."), .d2a_vh("2.5")) (*
integer library_binding = "ether";

 *)
I30 ( .CLK_250MHZ_PH( PHASE[10:0] ), .SIDDQ( SIDDQ ), .DISABLE(
DISABLE100 ), .IPLY_25u( I_RPOLY_25_PLL[0] ), .CLK_25MHZ( CLKXTAL ), .IEXT_100u(
I_REXT_100_PLL[0] ), .CP_ITEST_25u( net59 ), .VDD( VDDA_250 ), .IEXT_25u(
I_REXT_25_PLL[0] ), .VSS( GNDA_250 ) );

PLL_160MHZ (*
integer library_binding = "ether";
 *)
I5 ( .SIDDQ(
SIDDQ ), .DISABLE( DISABLE10 ), .IPLY_25u( I_RPOLY_25_PLL[1] ), .CLK_160MHZ(
PLL160 ), .CLK_25MHZ( CLKXTAL ), .IEXT_100u( I_REXT_100_PLL[1] ), .CP_ITEST_25u(
net69 ), .VDD( VDDA_160 ), .IEXT_25u( I_REXT_25_PLL[1] ), .VSS(
GNDA_160 ) );

endmodule
