ADE simulation setup
Run mode: Single Run, Sweeps and Corners
Tests:
  ether_adcflash_RAD90_sims:adc_cascode_opamp_sim:1: ether_adcflash_RAD90_sims/adc_cascode_opamp_sim/schematic, simulator spectre
Global variables:
  isr_100u = 1
  siddq = 1
  vdd = 3
  vin_ac = 100m
