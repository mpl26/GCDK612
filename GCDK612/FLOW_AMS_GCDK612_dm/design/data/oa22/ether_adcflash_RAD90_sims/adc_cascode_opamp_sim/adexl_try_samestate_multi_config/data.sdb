ADE simulation setup
Run mode: Single Run, Sweeps and Corners
Tests:
  ether_adcflash_RAD90_sims:adc_cascode_opamp_sim:1: ether_adcflash_RAD90_sims/adc_cascode_opamp_sim/config_generic_2, simulator spectre
  ether_adcflash_RAD90_sims:adc_cascode_opamp_sim:2: ether_adcflash_RAD90_sims/adc_cascode_opamp_sim/config_generic_3, simulator spectre
Global variables:
  isr_100u = 50
  siddq = 5
  vdd = 2
  vin_ac = 0.5
