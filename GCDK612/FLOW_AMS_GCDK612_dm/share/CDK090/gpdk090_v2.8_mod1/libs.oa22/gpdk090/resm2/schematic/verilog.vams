// Verilog-AMS netlist generated by the AMS netlister, version ICOA5.2.51.500.7.
// Cadence Design Systems, Inc.

`include "disciplines.vams"

module resm2 ( PLUS,MINUS );

inout   PLUS;
inout   MINUS;

parameter tc2=0;
parameter dw=0;
parameter isnoisy=0;
parameter segW=2u;
parameter trise=0;
parameter segR=240m;
parameter hrc=0;
parameter pasUpdateParamList="segW";
parameter effW=2u;
parameter dl=0;
parameter rend=0;
parameter lxParamsToIgnoreForCAS="showTapParams showSimParams";
parameter resform=0;
parameter dtemp=0;
parameter rsh=60m;
parameter tc1=0;
parameter segL=8u;
parameter model="gpdk090_resm2";
parameter scale=0;
parameter ssegs=1;
parameter r=240m;
parameter calculatedParam="Resistance";
parameter effL=8u;
parameter psegs=1;
parameter connection="Series";
parameter ac=0;
parameter segments=1;

gpdk090_resm2 #(.l(segL), .w(segW)) (*
integer library_binding
 = "gpdk090";
 *)
R0 ( net3, net4 );

endmodule
