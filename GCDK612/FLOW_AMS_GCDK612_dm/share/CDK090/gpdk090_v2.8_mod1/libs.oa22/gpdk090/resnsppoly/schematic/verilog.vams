// Verilog-AMS netlist generated by the AMS netlister, version ICOA5.2.51.500.7.
// Cadence Design Systems, Inc.

`include "disciplines.vams"

module resnsppoly ( PLUS,MINUS,B );

inout   PLUS;
inout   MINUS;
input   B;

parameter tc2=0;
parameter cntRows=1;
parameter dw=0;
parameter isnoisy=0;
parameter segW=1.5u;
parameter trise=0;
parameter segR=2.13733K;
parameter hrc=0;
parameter pasUpdateParamList="segW";
parameter effW=1.5u;
parameter dl=0;
parameter rend=0;
parameter resform=0;
parameter dtemp=0;
parameter rcont=10;
parameter rsh=400;
parameter tc1=0;
parameter tapExtension=0;
parameter segL=8u;
parameter model="gpdk090_resnsppoly";
parameter scale=0;
parameter ssegs=1;
parameter r=2.13733K;
parameter calculatedParam="Resistance";
parameter effL=8u;
parameter psegs=1;
parameter cntCols=5;
parameter connection="Series";
parameter ac=0;
parameter segments=1;

gpdk090_resnsppoly #(.l(segL), .w(segW)) (*
integer library_binding
 = "gpdk090";
 *)
R0 ( net5, net6, net4 );

endmodule
