// Verilog-AMS netlist generated by the AMS netlister, version ICOA5.2.51.500.7.
// Cadence Design Systems, Inc.

`include "disciplines.vams"

module CLKBUFX3 ( .VDD(\VDD! ),Y,.VSS(\VSS! ),A );

input  (*
integer inh_conn_prop_name = "VDD";
integer
inh_conn_def_value = "cds_globals.\\VDD! ";
 *)
 \VDD! ;
output   Y;

input  (*
integer inh_conn_prop_name = "VSS";
integer
inh_conn_def_value = "cds_globals.\\VSS! ";
 *)
 \VSS! ;
input   A;

wire (*
integer inh_conn_prop_name = "VDD";
integer inh_conn_def_value
 = "cds_globals.\\VDD! ";
 *)
\VDD! ;
wire Y;
wire (*
integer inh_conn_prop_name = "VSS";
integer inh_conn_def_value
 = "cds_globals.\\VSS! ";
 *)
\VSS! ;
wire A;

gpdk090_pmos1v #(.ps(2.51u), .m(1 * 1), .as(546f), .l(100n), .pd(2.51u),
 .ad(546f), .w(1.95u)) (*
integer library_binding = "gpdk090";

integer passed_mfactor = "m";
 *)
mp1 ( Y, net44, \VDD! , \VDD!  );
gpdk090_pmos1v #(.ps(1.21u), .m(1 * 1), .as(182f), .l(100n), .pd(1.21u),
 .ad(182f), .w(650n)) (*
integer library_binding = "gpdk090";
integer
passed_mfactor = "m";
 *)
mp0 ( net44, A, \VDD! , \VDD!  );

gpdk090_nmos1v #(.ps(1.85u), .m(1 * 1), .as(361.2f), .l(100n), .pd(1.85u),
 .ad(361.2f), .w(1.29u)) (*
integer library_binding = "gpdk090";

integer passed_mfactor = "m";
 *)
mn1 ( Y, net44, \VSS! , \VSS!  );
gpdk090_nmos1v #(.ps(990n), .m(1 * 1), .as(120.4f), .l(100n), .pd(990n),
 .ad(120.4f), .w(430n)) (*
integer library_binding = "gpdk090";

integer passed_mfactor = "m";
 *)
mn0 ( net44, A, \VSS! , \VSS!  );

endmodule
