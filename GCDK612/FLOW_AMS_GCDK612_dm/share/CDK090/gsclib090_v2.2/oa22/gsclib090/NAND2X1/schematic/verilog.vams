// Verilog-AMS netlist generated by the AMS netlister, version ICOA5.2.51.500.7.
// Cadence Design Systems, Inc.

`include "disciplines.vams"

module NAND2X1 ( .VDD(\VDD! ),Y,B,.VSS(\VSS! ),A );

input  (*
integer inh_conn_prop_name = "VDD";
integer
inh_conn_def_value = "cds_globals.\\VDD! ";
 *)
 \VDD! ;
output   Y;

input   B;
input  (*
integer inh_conn_prop_name = "VSS";
integer
inh_conn_def_value = "cds_globals.\\VSS! ";
 *)
 \VSS! ;
input   A;

wire n0;
wire (*
integer inh_conn_prop_name = "VDD";
integer inh_conn_def_value
 = "cds_globals.\\VDD! ";
 *)
\VDD! ;
wire Y;
wire B;
wire (*
integer inh_conn_prop_name = "VSS";
integer inh_conn_def_value
 = "cds_globals.\\VSS! ";
 *)
\VSS! ;
wire A;

gpdk090_pmos1v #(.ps(1.04u), .m(1 * 1), .as(69.6f), .l(1E-07), .pd(1.04u),
 .ad(69.6f), .w(120n)) (*
integer library_binding = "gpdk090";

integer passed_mfactor = "m";
 *)
mp1 ( Y, B, \VDD! , \VDD!  );
gpdk090_pmos1v #(.ps(1.04u), .m(1 * 1), .as(69.6f), .l(1E-07), .pd(1.04u),
 .ad(69.6f), .w(120n)) (*
integer library_binding = "gpdk090";

integer passed_mfactor = "m";
 *)
mp0 ( Y, A, \VDD! , \VDD!  );

gpdk090_nmos1v #(.ps(1.04u), .m(1 * 1), .as(69.6f), .l(1E-07), .pd(1.04u),
 .ad(69.6f), .w(120n)) (*
integer library_binding = "gpdk090";

integer passed_mfactor = "m";
 *)
mn1 ( Y, B, n0, \VSS!  );
gpdk090_nmos1v #(.ps(1.04u), .m(1 * 1), .as(69.6f), .l(1E-07), .pd(1.04u),
 .ad(69.6f), .w(120n)) (*
integer library_binding = "gpdk090";

integer passed_mfactor = "m";
 *)
mn0 ( n0, A, \VSS! , \VSS!  );

endmodule
