// Verilog-AMS netlist generated by the AMS netlister, version ICOA5.2.51.500.7.
// Cadence Design Systems, Inc.

`include "disciplines.vams"

module NOR3BXL ( AN,C,.VDD(\VDD! ),Y,B,.VSS(\VSS! ) );

input   AN;
input   C;
input  (*
integer inh_conn_prop_name = "VDD";

integer inh_conn_def_value = "cds_globals.\\VDD! ";
 *)
 \VDD! ;

output   Y;
input   B;
input  (*
integer inh_conn_prop_name = "VSS";

integer inh_conn_def_value = "cds_globals.\\VSS! ";
 *)
 \VSS! ;

wire (*
integer inh_conn_prop_name = "VDD";
integer inh_conn_def_value
 = "cds_globals.\\VDD! ";
 *)
\VDD! ;
wire AN;
wire C;
wire Y;
wire net91;
wire B;
wire (*
integer inh_conn_prop_name = "VSS";
integer inh_conn_def_value
 = "cds_globals.\\VSS! ";
 *)
\VSS! ;
wire net86;
wire net90;

gpdk090_pmos1v #(.ps(920n), .m(1 * 1), .as(100.8f), .l(100n), .pd(920n),
 .ad(100.8f), .w(360n)) (*
integer library_binding = "gpdk090";

integer passed_mfactor = "m";
 *)
mp3 ( Y, C, net90, \VDD!  );
gpdk090_pmos1v #(.ps(1.04u), .m(1 * 1), .as(69.6f), .l(1E-07), .pd(1.04u),
 .ad(69.6f), .w(120n)) (*
integer library_binding = "gpdk090";

integer passed_mfactor = "m";
 *)
mp0 ( net91, AN, \VDD! , \VDD!  );
gpdk090_pmos1v #(.ps(920n), .m(1 * 1), .as(100.8f), .l(100n), .pd(920n),
 .ad(100.8f), .w(360n)) (*
integer library_binding = "gpdk090";

integer passed_mfactor = "m";
 *)
mp1 ( net86, net91, \VDD! , \VDD!  );
gpdk090_pmos1v #(.ps(920n), .m(1 * 1), .as(100.8f), .l(100n), .pd(920n),
 .ad(100.8f), .w(360n)) (*
integer library_binding = "gpdk090";

integer passed_mfactor = "m";
 *)
mp2 ( net90, B, net86, \VDD!  );

gpdk090_nmos1v #(.ps(800n), .m(1 * 1), .as(67.2f), .l(100n), .pd(800n),
 .ad(67.2f), .w(240n)) (*
integer library_binding = "gpdk090";

integer passed_mfactor = "m";
 *)
mn1 ( Y, net91, \VSS! , \VSS!  );
gpdk090_nmos1v #(.ps(800n), .m(1 * 1), .as(67.2f), .l(100n), .pd(800n),
 .ad(67.2f), .w(240n)) (*
integer library_binding = "gpdk090";

integer passed_mfactor = "m";
 *)
mn3 ( Y, C, \VSS! , \VSS!  );
gpdk090_nmos1v #(.ps(1.04u), .m(1 * 1), .as(69.6f), .l(1E-07), .pd(1.04u),
 .ad(69.6f), .w(120n)) (*
integer library_binding = "gpdk090";

integer passed_mfactor = "m";
 *)
mn0 ( net91, AN, \VSS! , \VSS!  );
gpdk090_nmos1v #(.ps(800n), .m(1 * 1), .as(67.2f), .l(100n), .pd(800n),
 .ad(67.2f), .w(240n)) (*
integer library_binding = "gpdk090";

integer passed_mfactor = "m";
 *)
mn2 ( Y, B, \VSS! , \VSS!  );

endmodule
