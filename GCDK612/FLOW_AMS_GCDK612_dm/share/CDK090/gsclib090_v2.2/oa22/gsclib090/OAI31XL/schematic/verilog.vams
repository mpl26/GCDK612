// Verilog-AMS netlist generated by the AMS netlister, version ICOA5.2.51.500.7.
// Cadence Design Systems, Inc.

`include "disciplines.vams"

module OAI31XL ( A0,A1,.VDD(\VDD! ),B0,Y,A2,.VSS(\VSS! ) );

input   A0;
input   A1;
input  (*
integer inh_conn_prop_name
 = "VDD";
integer inh_conn_def_value = "cds_globals.\\VDD! ";
 *)

 \VDD! ;
input   B0;
output   Y;
input   A2;
input  (*
integer
inh_conn_prop_name = "VSS";
integer inh_conn_def_value
 = "cds_globals.\\VSS! ";
 *)
 \VSS! ;

wire A0;
wire (*
integer inh_conn_prop_name = "VDD";
integer inh_conn_def_value
 = "cds_globals.\\VDD! ";
 *)
\VDD! ;
wire A1;
wire n2;
wire B0;
wire Y;
wire A2;
wire (*
integer inh_conn_prop_name = "VSS";
integer inh_conn_def_value
 = "cds_globals.\\VSS! ";
 *)
\VSS! ;

gpdk090_pmos1v #(.ps(920n), .m(1 * 1), .as(100.8f), .l(100n), .pd(920n),
 .ad(100.8f), .w(360n)) (*
integer library_binding = "gpdk090";

integer passed_mfactor = "m";
 *)
mp2 ( Y, A2, n2, \VDD!  );
gpdk090_pmos1v #(.ps(920n), .m(1 * 1), .as(100.8f), .l(100n), .pd(920n),
 .ad(100.8f), .w(360n)) (*
integer library_binding = "gpdk090";

integer passed_mfactor = "m";
 *)
mp1 ( n2, A1, n1, \VDD!  );
gpdk090_pmos1v #(.ps(920n), .m(1 * 1), .as(100.8f), .l(100n), .pd(920n),
 .ad(100.8f), .w(360n)) (*
integer library_binding = "gpdk090";

integer passed_mfactor = "m";
 *)
mp3 ( Y, B0, \VDD! , \VDD!  );
gpdk090_pmos1v #(.ps(920n), .m(1 * 1), .as(100.8f), .l(100n), .pd(920n),
 .ad(100.8f), .w(360n)) (*
integer library_binding = "gpdk090";

integer passed_mfactor = "m";
 *)
mp0 ( n1, A0, \VDD! , \VDD!  );

gpdk090_nmos1v #(.ps(800n), .m(1 * 1), .as(67.2f), .l(100n), .pd(800n),
 .ad(67.2f), .w(240n)) (*
integer library_binding = "gpdk090";

integer passed_mfactor = "m";
 *)
mn3 ( Y, B0, n0, \VSS!  );
gpdk090_nmos1v #(.ps(800n), .m(1 * 1), .as(67.2f), .l(100n), .pd(800n),
 .ad(67.2f), .w(240n)) (*
integer library_binding = "gpdk090";

integer passed_mfactor = "m";
 *)
mn0 ( n0, A0, \VSS! , \VSS!  );
gpdk090_nmos1v #(.ps(800n), .m(1 * 1), .as(67.2f), .l(100n), .pd(800n),
 .ad(67.2f), .w(240n)) (*
integer library_binding = "gpdk090";

integer passed_mfactor = "m";
 *)
mn2 ( n0, A2, \VSS! , \VSS!  );
gpdk090_nmos1v #(.ps(800n), .m(1 * 1), .as(67.2f), .l(100n), .pd(800n),
 .ad(67.2f), .w(240n)) (*
integer library_binding = "gpdk090";

integer passed_mfactor = "m";
 *)
mn1 ( n0, A1, \VSS! , \VSS!  );

endmodule
