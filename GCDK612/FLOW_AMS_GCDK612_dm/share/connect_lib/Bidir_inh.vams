// INCLUDE FILES:
`include "disciplines.vams"
`timescale 1ns / 100ps

//============================================================================
connectmodule Bidir_inh (Din, Aout);
  inout Din; logic Din;                       // logic signal
  inout Aout; electrical Aout;                // electrical signal

// Supply Sensitivity attributes
//  electrical (* integer supplySensitivity = "cds_globals.\\vdd! " ; *) vdd;
 // electrical (* integer groundSensitivity = "cds_globals.\\vss! " ; *) vss;

//INHCONN attribute

electrical
   (* integer inh_conn_prop_name="DVDD";
      integer inh_conn_def_value="cds_globals.\\vdda! "; *)
 \vdda ;
electrical
   (* integer inh_conn_prop_name="DVSS";
      integer inh_conn_def_value="cds_globals.\\vss! "; *)
 \vss ;

// INSTANCE PARAMETERS:
  parameter real tr=0.2n from (0:1m);         // risetime (L/X to Hi)
  parameter real tf=tr from (0:1m);           // falltime (H/X to Lo)
  parameter real tx=tr from (0:1m);           // time to unknown (L/H/Z to X)
  parameter real tz=tr from (0:1m);           // impedance risetime to/from Z
  parameter real txdel=4*tr;                  // analog-midrange to output X
  parameter real rlo=200 from (0:1M);         // low state output resistance
  parameter real rhi=rlo from (0:1M);         // high state output resistance
  parameter real rx=(rlo+rhi)/10 from (0:1M); // X state output resistance
  parameter real rz=10M from (rhi:1T];        // Z state output resistance
  parameter real ttol=tr/4;                   // time tolerance of crossing
// scaled input/output levels/thresholds (0 maps to Vref, 1 maps to Vsup):
  parameter real vlo=0 from [0:1);            // frac. output low level
  parameter real vhi=1 from (vlo:1];          // frac. output high level
  parameter real vthi=vhi/1.5 from (vlo:vhi); // frac. for high tresh (def=2/3)
  parameter real vtlo=vthi/2 from (vlo:vthi); // frac. for low tresh (def=1/3)
  parameter real vx=(vthi+vtlo)/2 from (vtlo:vthi); // frac for X state voltage
  parameter real vz=(vthi+vtlo)/2 from (vlo:vhi);   // frac for Z state voltage
  parameter real vtol=(vthi-vtlo)/10 from (0:(vthi-vtlo)/4]; // frac. for vtol

// LOCAL VARIABLES:
  reg Dreg;                // register to writeback logic
  reg Dold;                // register for keeping previous state of Din
  real Kin,Kout;           // input & output relative to supply range
  real Vout,Rout;          // output voltage & resistance
  reg Xin;                 // flag if analog is midrange
  real Rlog;               // natural log of output resistance value
  real txdig;              // delay midlevel to X in timescale units
  real TdV,TrV,TrR;        // delays & risetime for voltage & resistance
  real vtlox,vthix;        // thresholds for transition to X state

//============================================================================
  initial begin
    txdig=txdel/1n;        // digital delay midlevel to X  (ASSUMES TIMESCALE)
    Dreg=(Kin>vthi)? 1'b1 : (Kin<vtlo)? 1'b0 : 1'bz;  // initial level
    Xin=0;                 // initially not in X delay region.
    vtlox=vtlo+2*vtol;     // lo-to-x threshold point
    vthix=vthi-2*vtol;     // hi-to-x threshold point
  end
  always begin
    case (Din)                        // Lookup of V,R,T values for new state
      1'b1:  begin                    // to HIGH
         Kout=vhi;  Rlog=ln(rhi);  TdV=0;
         if (Dold!==1'bz)  begin TrV=tr;   TrR=tr; end   // Lo/X to Hi
         else              begin TrV=tz/2; TrR=tz; end   // Z to high
      end
      1'b0: begin                     // to LOW
         Kout=vlo;  Rlog=ln(rlo);  TdV=0;
         if (Dold!==1'bz)  begin TrV=tf;   TrR=tf; end   // Hi/X to Lo
         else              begin TrV=tz/2; TrR=tz; end   // Z to low
      end
      1'bz:  begin                    // to HIGH IMPEDANCE
         Kout=vz;  Rlog=ln(rz);  TdV=tz/2;
         TrV=tz/2; TrR=tz;                               // Hi/Lo/X to Z
      end
      default:  begin                 // to UNKNOWN
         if ($abstime>0) begin        // normal X level
           Kout=vx;  Rlog=ln(rx);  TdV=0;
           TrV=tx;  TrR=tx;                              // Hi/Lo/Z to X
           Dreg=1'bx;                 // logic X occurs immediately
         end
         else begin                   // @T=0, define as Z rather than X
           Kout=vz;  Rlog=ln(rz);  TdV=0;
           TrV=tz/2;  TrR=tz;                            // Z to Hi/Lo
           Dreg=1'bz;                 // logic Z level
         end
      end
    endcase
    if ($abstime==0) begin            // get new state appropriately at DC:
      if (Din===1'bz) Dreg=(Kin>vthi)? 1'b1 : (Kin<vtlo)? 1'b0 : 1'bz;
      else if (Din!==1'bx) Dreg=Din;
    end
    Dold=Din;                         // keep old value of Din
    @(Din);                           // repeat when Din changes.
  end

  analog begin
// Relative input level (maps input to range of 0=vref, 1=vsup):
     Kin = V(Aout,vss)/max(V(vdda,vss),1m);
// Output resistance shifts on log scale over its rise time:
     Rout = exp(transition(Rlog,0,TrR,TrR));
// Output voltage shifts linearly over rise time, scales with supply:
     Vout = V(vdda,vss)*transition(Kout,TdV,TrV,TrV);
     I(Aout) <+ (V(Aout,vss)-Vout)/Rout;
//+// Output drive from proper supply could use this format:
//+     if (Vout<V(Aout,vss))  I(Aout,vss) <+ (V(Aout,vss)-Vout)/Rout;
//+     else                   I(vdda,Aout) <+ (Vout-V(Aout,vss))/Rout;
  end

// Reflect actual levels on analog side back to digital side:
  always @(above(Kin-vthi,ttol,vtol))
      begin Dreg=1; Xin=0; end                   // analog XtoH
  always @(above(vtlo-Kin,ttol,vtol))
      begin Dreg=0; Xin=0; end                   // analog XtoL
  always @(above(vthix-Kin,ttol,vtol))
      if (Kin>vtlo && Dreg!==1'bx) Xin=1;        // analog HtoX
  always @(above(Kin-vtlox,ttol,vtol))
      if (Kin<vthi && Dreg!==1'bx) Xin=1;        // analog LtoX
// Wait for txdel before driving output to X:
  always @(posedge(Xin)) begin :GoToX            // input changed to X
    #(txdig)                                     // wait for X time delay
    if (Kin>0 && Kin<1) Dreg=1'bx;               // goto X if still between
    else Xin=0;                                  // else clear the X flag
  end
  always @(negedge(Xin)) disable GoToX;          // cancel out-to-X on Xin=0
  assign  Din=Dreg;                              // assign register to output
endmodule
